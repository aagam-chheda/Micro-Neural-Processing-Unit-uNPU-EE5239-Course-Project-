$ Spice netlist generated by v2lvs
$ v2022.4_37.20    Fri Dec 2 17:42:37 PST 2022
.INCLUDE "/storage/PDK_iitg/SCLPDK_V3.0_KIT/scl180/stdcell/fs120/4M1IL/cdl/scl18fs120_supply_pins.cdl"
*.BUSDELIMITER [

.SUBCKT unpu_deskew ZCTSNET_36 rst_n array_en psum_in[127] psum_in[126]
+ psum_in[125] psum_in[124] psum_in[123] psum_in[122] psum_in[121] psum_in[120]
+ psum_in[119] psum_in[118] psum_in[117] psum_in[116] psum_in[115] psum_in[114]
+ psum_in[113] psum_in[112] psum_in[111] psum_in[110] psum_in[109] psum_in[108]
+ psum_in[107] psum_in[106] psum_in[105] psum_in[104] psum_in[103] psum_in[102]
+ psum_in[101] psum_in[100] psum_in[99] psum_in[98] psum_in[97] psum_in[96]
+ psum_in[95] psum_in[94] psum_in[93] psum_in[92] psum_in[91] psum_in[90]
+ psum_in[89] psum_in[88] psum_in[87] psum_in[86] psum_in[85] psum_in[84]
+ psum_in[83] psum_in[82] psum_in[81] psum_in[80] psum_in[79] psum_in[78]
+ psum_in[77] psum_in[76] psum_in[75] psum_in[74] psum_in[73] psum_in[72]
+ psum_in[71] psum_in[70] psum_in[69] psum_in[68] psum_in[67] psum_in[66]
+ psum_in[65] psum_in[64] psum_in[63] psum_in[62] psum_in[61] psum_in[60]
+ psum_in[59] psum_in[58] psum_in[57] psum_in[56] psum_in[55] psum_in[54]
+ psum_in[53] psum_in[52] psum_in[51] psum_in[50] psum_in[49] psum_in[48]
+ psum_in[47] psum_in[46] psum_in[45] psum_in[44] psum_in[43] psum_in[42]
+ psum_in[41] psum_in[40] psum_in[39] psum_in[38] psum_in[37] psum_in[36]
+ psum_in[35] psum_in[34] psum_in[33] psum_in[32] psum_in[31] psum_in[30]
+ psum_in[29] psum_in[28] psum_in[27] psum_in[26] psum_in[25] psum_in[24]
+ psum_in[23] psum_in[22] psum_in[21] psum_in[20] psum_in[19] psum_in[18]
+ psum_in[17] psum_in[16] psum_in[15] psum_in[14] psum_in[13] psum_in[12]
+ psum_in[11] psum_in[10] psum_in[9] psum_in[8] psum_in[7] psum_in[6]
+ psum_in[5] psum_in[4] psum_in[3] psum_in[2] psum_in[1] psum_in[0] c_out[127]
+ c_out[126] c_out[125] c_out[124] c_out[123] c_out[122] c_out[121] c_out[120]
+ c_out[119] c_out[118] c_out[117] c_out[116] c_out[115] c_out[114] c_out[113]
+ c_out[112] c_out[111] c_out[110] c_out[109] c_out[108] c_out[107] c_out[106]
+ c_out[105] c_out[104] c_out[103] c_out[102] c_out[101] c_out[100] c_out[99]
+ c_out[98] c_out[97] c_out[96] c_out[95] c_out[94] c_out[93] c_out[92]
+ c_out[91] c_out[90] c_out[89] c_out[88] c_out[87] c_out[86] c_out[85]
+ c_out[84] c_out[83] c_out[82] c_out[81] c_out[80] c_out[79] c_out[78]
+ c_out[77] c_out[76] c_out[75] c_out[74] c_out[73] c_out[72] c_out[71]
+ c_out[70] c_out[69] c_out[68] c_out[67] c_out[66] c_out[65] c_out[64]
+ c_out[63] c_out[62] c_out[61] c_out[60] c_out[59] c_out[58] c_out[57]
+ c_out[56] c_out[55] c_out[54] c_out[53] c_out[52] c_out[51] c_out[50]
+ c_out[49] c_out[48] c_out[47] c_out[46] c_out[45] c_out[44] c_out[43]
+ c_out[42] c_out[41] c_out[40] c_out[39] c_out[38] c_out[37] c_out[36]
+ c_out[35] c_out[34] c_out[33] c_out[32] c_out[31] c_out[30] c_out[29]
+ c_out[28] c_out[27] c_out[26] c_out[25] c_out[24] c_out[23] c_out[22]
+ c_out[21] c_out[20] c_out[19] c_out[18] c_out[17] c_out[16] c_out[15]
+ c_out[14] c_out[13] c_out[12] c_out[11] c_out[10] c_out[9] c_out[8] c_out[7]
+ c_out[6] c_out[5] c_out[4] c_out[3] c_out[2] c_out[1] c_out[0] VDD VSS
+ ZCTSNET_39 ZCTSNET_40 ZCTSNET_43 HFSNET_8 HFSNET_9 HFSNET_10 HFSNET_11
+ HFSNET_12 HFSNET_14 HFSNET_16 HFSNET_18 HFSNET_21 HFSNET_22 HFSNET_24
+ HFSNET_25 HFSNET_26 HFSNET_27 HFSNET_29 HFSNET_30 HFSNET_31 HFSNET_32
+ HFSNET_33 HFSNET_34 HFSNET_35 ZCTSNET_2 ZCTSNET_4 ZCTSNET_5 ZCTSNET_8
+ sbcto_ht1_0
*.CONNECT c_out[127] psum_in[127]
*.CONNECT c_out[126] psum_in[126]
*.CONNECT c_out[125] psum_in[125]
*.CONNECT c_out[124] psum_in[124]
*.CONNECT c_out[123] psum_in[123]
*.CONNECT c_out[122] psum_in[122]
*.CONNECT c_out[121] psum_in[121]
*.CONNECT c_out[120] psum_in[120]
*.CONNECT c_out[119] psum_in[119]
*.CONNECT c_out[118] psum_in[118]
*.CONNECT c_out[117] psum_in[117]
*.CONNECT c_out[116] psum_in[116]
*.CONNECT c_out[115] psum_in[115]
*.CONNECT c_out[114] psum_in[114]
*.CONNECT c_out[113] psum_in[113]
*.CONNECT c_out[112] psum_in[112]
*.CONNECT c_out[111] psum_in[111]
*.CONNECT c_out[110] psum_in[110]
*.CONNECT c_out[109] psum_in[109]
*.CONNECT c_out[108] psum_in[108]
*.CONNECT c_out[107] psum_in[107]
*.CONNECT c_out[106] psum_in[106]
*.CONNECT c_out[105] psum_in[105]
*.CONNECT c_out[104] psum_in[104]
*.CONNECT c_out[103] psum_in[103]
*.CONNECT c_out[102] psum_in[102]
*.CONNECT c_out[101] psum_in[101]
*.CONNECT c_out[100] psum_in[100]
*.CONNECT c_out[99] psum_in[99]
*.CONNECT c_out[98] psum_in[98]
*.CONNECT c_out[97] psum_in[97]
*.CONNECT c_out[96] psum_in[96]
XU3 aor22d1 $PINS A1=HFSNET_20 A2=copt_net_2359 B1=HFSNET_15 B2=copt_net_1557
+ Z=n33 VDD=VDD VSS=VSS
XU4 aor22d1 $PINS A1=HFSNET_20 A2=copt_net_2217 B1=copt_net_2267 B2=HFSNET_15
+ Z=n34 VDD=VDD VSS=VSS
XU5 aor22d1 $PINS A1=HFSNET_19 A2=copt_net_1551 B1=HFSNET_13 B2=copt_net_2217
+ Z=n35 VDD=VDD VSS=VSS
XU6 aor22d1 $PINS A1=HFSNET_19 A2=copt_net_2175 B1=copt_net_2589 B2=HFSNET_13
+ Z=n36 VDD=VDD VSS=VSS
XU7 aor22d1 $PINS A1=HFSNET_19 A2=col0_q1[17] B1=HFSNET_13 B2=col0_q2[17] Z=n37
+ VDD=VDD VSS=VSS
XU8 aor22d1 $PINS A1=HFSNET_20 A2=copt_net_1766 B1=c_out[18] B2=HFSNET_15 Z=n38
+ VDD=VDD VSS=VSS
XU9 aor22d1 $PINS A1=HFSNET_20 A2=copt_net_2381 B1=HFSNET_15 B2=copt_net_1766
+ Z=n39 VDD=VDD VSS=VSS
XU10 aor22d1 $PINS A1=HFSNET_20 A2=copt_net_2167 B1=c_out[19] B2=HFSNET_15
+ Z=n40 VDD=VDD VSS=VSS
XU11 aor22d1 $PINS A1=HFSNET_18 A2=copt_net_2220 B1=HFSNET_12 B2=copt_net_2167
+ Z=n41 VDD=VDD VSS=VSS
XU12 aor22d1 $PINS A1=HFSNET_20 A2=copt_net_1471 B1=copt_net_2592 B2=HFSNET_15
+ Z=n42 VDD=VDD VSS=VSS
XU13 aor22d1 $PINS A1=HFSNET_19 A2=copt_net_1672 B1=HFSNET_13 B2=col0_q2[20]
+ Z=n43 VDD=VDD VSS=VSS
XU14 aor22d1 $PINS A1=HFSNET_20 A2=copt_net_2147 B1=copt_net_2690 B2=HFSNET_15
+ Z=n44 VDD=VDD VSS=VSS
XU15 aor22d1 $PINS A1=HFSNET_20 A2=copt_net_1761 B1=HFSNET_15 B2=copt_net_2147
+ Z=n45 VDD=VDD VSS=VSS
XU16 aor22d1 $PINS A1=HFSNET_20 A2=copt_net_2204 B1=c_out[22] B2=HFSNET_15
+ Z=n46 VDD=VDD VSS=VSS
XU17 aor22d1 $PINS A1=HFSNET_18 A2=copt_net_1768 B1=HFSNET_12 B2=copt_net_2204
+ Z=n47 VDD=VDD VSS=VSS
XU18 aor22d1 $PINS A1=HFSNET_19 A2=copt_net_2215 B1=c_out[23] B2=HFSNET_13
+ Z=n48 VDD=VDD VSS=VSS
XU19 aor22d1 $PINS A1=HFSNET_19 A2=copt_net_1563 B1=HFSNET_13 B2=copt_net_2215
+ Z=n49 VDD=VDD VSS=VSS
XU20 aor22d1 $PINS A1=HFSNET_20 A2=copt_net_2557 B1=copt_net_1664 B2=HFSNET_15
+ Z=n50 VDD=VDD VSS=VSS
XU21 aor22d1 $PINS A1=HFSNET_20 A2=copt_net_2725 B1=HFSNET_15 B2=copt_net_2557
+ Z=n51 VDD=VDD VSS=VSS
XU22 aor22d1 $PINS A1=HFSNET_18 A2=copt_net_2219 B1=c_out[25] B2=HFSNET_12
+ Z=n52 VDD=VDD VSS=VSS
XU23 aor22d1 $PINS A1=HFSNET_18 A2=copt_net_1812 B1=HFSNET_12 B2=copt_net_2219
+ Z=n53 VDD=VDD VSS=VSS
XU24 aor22d1 $PINS A1=HFSNET_20 A2=copt_net_2126 B1=c_out[26] B2=HFSNET_15
+ Z=n54 VDD=VDD VSS=VSS
XU25 aor22d1 $PINS A1=HFSNET_20 A2=copt_net_1853 B1=HFSNET_15 B2=copt_net_2126
+ Z=n55 VDD=VDD VSS=VSS
XU26 aor22d1 $PINS A1=HFSNET_18 A2=copt_net_2351 B1=copt_net_2244 B2=HFSNET_12
+ Z=n56 VDD=VDD VSS=VSS
XU27 aor22d1 $PINS A1=HFSNET_18 A2=copt_net_1772 B1=HFSNET_12 B2=copt_net_2351
+ Z=n57 VDD=VDD VSS=VSS
XU28 aor22d1 $PINS A1=HFSNET_20 A2=copt_net_2459 B1=c_out[28] B2=HFSNET_15
+ Z=n58 VDD=VDD VSS=VSS
XU29 aor22d1 $PINS A1=HFSNET_18 A2=copt_net_2145 B1=HFSNET_12 B2=copt_net_2459
+ Z=n59 VDD=VDD VSS=VSS
XU30 aor22d1 $PINS A1=HFSNET_20 A2=copt_net_2182 B1=c_out[29] B2=HFSNET_15
+ Z=n60 VDD=VDD VSS=VSS
XU31 aor22d1 $PINS A1=HFSNET_20 A2=copt_net_2178 B1=HFSNET_15 B2=copt_net_2182
+ Z=n61 VDD=VDD VSS=VSS
XU32 aor22d1 $PINS A1=HFSNET_18 A2=copt_net_2189 B1=copt_net_2524 B2=HFSNET_12
+ Z=n62 VDD=VDD VSS=VSS
XU33 aor22d1 $PINS A1=HFSNET_18 A2=copt_net_1543 B1=HFSNET_12 B2=copt_net_2189
+ Z=n63 VDD=VDD VSS=VSS
XU34 aor22d1 $PINS A1=HFSNET_20 A2=copt_net_2142 B1=c_out[31] B2=HFSNET_15
+ Z=n64 VDD=VDD VSS=VSS
XU35 aor22d1 $PINS A1=HFSNET_22 A2=copt_net_2203 B1=HFSNET_21 B2=col0_q2[31]
+ Z=n65 VDD=VDD VSS=VSS
XU36 aor22d1 $PINS A1=HFSNET_21 A2=col0_q1[0] B1=psum_in[0] B2=HFSNET_22 Z=n66
+ VDD=VDD VSS=VSS
XU37 aor22d1 $PINS A1=HFSNET_12 A2=copt_net_2223 B1=copt_net_2670 B2=HFSNET_18
+ Z=n67 VDD=VDD VSS=VSS
XU38 aor22d1 $PINS A1=HFSNET_13 A2=copt_net_1414 B1=copt_net_2576 B2=HFSNET_19
+ Z=n68 VDD=VDD VSS=VSS
XU39 aor22d1 $PINS A1=HFSNET_12 A2=col0_q1[3] B1=psum_in[3] B2=HFSNET_18 Z=n69
+ VDD=VDD VSS=VSS
XU40 aor22d1 $PINS A1=HFSNET_13 A2=copt_net_1393 B1=copt_net_2586 B2=HFSNET_19
+ Z=n70 VDD=VDD VSS=VSS
XU41 aor22d1 $PINS A1=HFSNET_11 A2=copt_net_1567 B1=copt_net_2553 B2=HFSNET_16
+ Z=n71 VDD=VDD VSS=VSS
XU42 aor22d1 $PINS A1=HFSNET_13 A2=copt_net_1450 B1=copt_net_2429 B2=HFSNET_19
+ Z=n72 VDD=VDD VSS=VSS
XU43 aor22d1 $PINS A1=HFSNET_11 A2=copt_net_2179 B1=copt_net_2247 B2=HFSNET_16
+ Z=n73 VDD=VDD VSS=VSS
XU44 aor22d1 $PINS A1=HFSNET_13 A2=copt_net_1741 B1=copt_net_2493 B2=HFSNET_19
+ Z=n74 VDD=VDD VSS=VSS
XU45 aor22d1 $PINS A1=HFSNET_13 A2=copt_net_2031 B1=copt_net_2682 B2=HFSNET_19
+ Z=n75 VDD=VDD VSS=VSS
XU46 aor22d1 $PINS A1=HFSNET_10 A2=copt_net_2396 B1=copt_net_1562 B2=HFSNET_17
+ Z=n76 VDD=VDD VSS=VSS
XU47 aor22d1 $PINS A1=HFSNET_12 A2=copt_net_2457 B1=copt_net_2245 B2=HFSNET_18
+ Z=n77 VDD=VDD VSS=VSS
XU48 aor22d1 $PINS A1=HFSNET_12 A2=copt_net_2471 B1=copt_net_2194 B2=HFSNET_18
+ Z=n78 VDD=VDD VSS=VSS
XU49 aor22d1 $PINS A1=HFSNET_12 A2=col0_q1[13] B1=psum_in[13] B2=HFSNET_18
+ Z=n79 VDD=VDD VSS=VSS
XU50 aor22d1 $PINS A1=HFSNET_12 A2=copt_net_1690 B1=copt_net_2523 B2=HFSNET_18
+ Z=n80 VDD=VDD VSS=VSS
XU51 aor22d1 $PINS A1=HFSNET_15 A2=copt_net_2359 B1=copt_net_2241 B2=HFSNET_20
+ Z=n81 VDD=VDD VSS=VSS
XU52 aor22d1 $PINS A1=HFSNET_13 A2=copt_net_1551 B1=copt_net_2529 B2=HFSNET_19
+ Z=n82 VDD=VDD VSS=VSS
XU53 aor22d1 $PINS A1=HFSNET_12 A2=col0_q1[17] B1=psum_in[17] B2=HFSNET_18
+ Z=n83 VDD=VDD VSS=VSS
XU54 aor22d1 $PINS A1=HFSNET_15 A2=copt_net_2381 B1=copt_net_2214 B2=HFSNET_20
+ Z=n84 VDD=VDD VSS=VSS
XU55 aor22d1 $PINS A1=HFSNET_15 A2=copt_net_2220 B1=copt_net_2685 B2=HFSNET_20
+ Z=n85 VDD=VDD VSS=VSS
XU56 aor22d1 $PINS A1=HFSNET_21 A2=copt_net_1672 B1=copt_net_2477 B2=HFSNET_22
+ Z=n86 VDD=VDD VSS=VSS
XU57 aor22d1 $PINS A1=HFSNET_13 A2=copt_net_1761 B1=copt_net_2509 B2=HFSNET_19
+ Z=n87 VDD=VDD VSS=VSS
XU58 aor22d1 $PINS A1=HFSNET_11 A2=copt_net_1769 B1=copt_net_2517 B2=HFSNET_16
+ Z=n88 VDD=VDD VSS=VSS
XU59 aor22d1 $PINS A1=HFSNET_11 A2=copt_net_1563 B1=copt_net_2183 B2=HFSNET_16
+ Z=n89 VDD=VDD VSS=VSS
XU60 aor22d1 $PINS A1=HFSNET_21 A2=col0_q1[24] B1=psum_in[24] B2=HFSNET_22
+ Z=n90 VDD=VDD VSS=VSS
XU61 aor22d1 $PINS A1=HFSNET_21 A2=copt_net_1813 B1=copt_net_2518 B2=HFSNET_22
+ Z=n91 VDD=VDD VSS=VSS
XU62 aor22d1 $PINS A1=HFSNET_11 A2=copt_net_1853 B1=copt_net_2497 B2=HFSNET_16
+ Z=n92 VDD=VDD VSS=VSS
XU63 aor22d1 $PINS A1=HFSNET_11 A2=copt_net_1772 B1=copt_net_2496 B2=HFSNET_16
+ Z=n93 VDD=VDD VSS=VSS
XU64 aor22d1 $PINS A1=HFSNET_12 A2=copt_net_2145 B1=copt_net_2694 B2=HFSNET_18
+ Z=n94 VDD=VDD VSS=VSS
XU65 aor22d1 $PINS A1=HFSNET_15 A2=copt_net_2178 B1=copt_net_2695 B2=HFSNET_20
+ Z=n95 VDD=VDD VSS=VSS
XU66 aor22d1 $PINS A1=HFSNET_21 A2=copt_net_1543 B1=copt_net_2236 B2=HFSNET_22
+ Z=n96 VDD=VDD VSS=VSS
XU67 aor22d1 $PINS A1=HFSNET_21 A2=copt_net_2203 B1=copt_net_2218 B2=HFSNET_22
+ Z=n97 VDD=VDD VSS=VSS
XU68 aor22d1 $PINS A1=HFSNET_19 A2=copt_net_1503 B1=c_out[32] B2=HFSNET_13
+ Z=n98 VDD=VDD VSS=VSS
XU69 aor22d1 $PINS A1=HFSNET_21 A2=col1_q1[0] B1=psum_in[32] B2=HFSNET_22 Z=n99
+ VDD=VDD VSS=VSS
XU70 aor22d1 $PINS A1=HFSNET_19 A2=copt_net_1715 B1=c_out[33] B2=HFSNET_13
+ Z=n100 VDD=VDD VSS=VSS
XU71 aor22d1 $PINS A1=HFSNET_21 A2=col1_q1[1] B1=psum_in[33] B2=HFSNET_22
+ Z=n101 VDD=VDD VSS=VSS
XU72 aor22d1 $PINS A1=HFSNET_19 A2=copt_net_1687 B1=copt_net_2305 B2=HFSNET_13
+ Z=n102 VDD=VDD VSS=VSS
XU73 aor22d1 $PINS A1=HFSNET_21 A2=col1_q1[2] B1=psum_in[34] B2=HFSNET_22
+ Z=n103 VDD=VDD VSS=VSS
XU74 aor22d1 $PINS A1=HFSNET_17 A2=copt_net_2403 B1=c_out[35] B2=HFSNET_10
+ Z=n104 VDD=VDD VSS=VSS
XU75 aor22d1 $PINS A1=HFSNET_11 A2=copt_net_2402 B1=copt_net_1618 B2=HFSNET_16
+ Z=n105 VDD=VDD VSS=VSS
XU76 aor22d1 $PINS A1=HFSNET_19 A2=copt_net_270 B1=c_out[36] B2=HFSNET_13
+ Z=n106 VDD=VDD VSS=VSS
XU77 aor22d1 $PINS A1=HFSNET_9 A2=copt_net_271 B1=copt_net_2687 B2=HFSNET_14
+ Z=n107 VDD=VDD VSS=VSS
XU78 aor22d1 $PINS A1=HFSNET_19 A2=copt_net_337 B1=c_out[37] B2=HFSNET_13
+ Z=n108 VDD=VDD VSS=VSS
XU79 aor22d1 $PINS A1=HFSNET_9 A2=copt_net_337 B1=copt_net_2667 B2=HFSNET_14
+ Z=n109 VDD=VDD VSS=VSS
XU80 aor22d1 $PINS A1=HFSNET_14 A2=copt_net_1796 B1=c_out[38] B2=HFSNET_9
+ Z=n110 VDD=VDD VSS=VSS
XU81 aor22d1 $PINS A1=HFSNET_10 A2=copt_net_1796 B1=copt_net_2511 B2=HFSNET_17
+ Z=n111 VDD=VDD VSS=VSS
XU82 aor22d1 $PINS A1=HFSNET_14 A2=copt_net_1156 B1=copt_net_2826 B2=HFSNET_9
+ Z=n112 VDD=VDD VSS=VSS
XU83 aor22d1 $PINS A1=HFSNET_11 A2=copt_net_1156 B1=copt_net_2605 B2=HFSNET_16
+ Z=n113 VDD=VDD VSS=VSS
XU84 aor22d1 $PINS A1=HFSNET_19 A2=copt_net_353 B1=c_out[40] B2=HFSNET_13
+ Z=n114 VDD=VDD VSS=VSS
XU85 aor22d1 $PINS A1=HFSNET_9 A2=copt_net_354 B1=copt_net_2689 B2=HFSNET_14
+ Z=n115 VDD=VDD VSS=VSS
XU86 aor22d1 $PINS A1=HFSNET_16 A2=copt_net_2349 B1=c_out[41] B2=HFSNET_11
+ Z=n116 VDD=VDD VSS=VSS
XU87 aor22d1 $PINS A1=HFSNET_11 A2=copt_net_2349 B1=copt_net_1578 B2=HFSNET_16
+ Z=n117 VDD=VDD VSS=VSS
XU88 aor22d1 $PINS A1=HFSNET_17 A2=copt_net_1524 B1=c_out[42] B2=HFSNET_10
+ Z=n118 VDD=VDD VSS=VSS
XU89 aor22d1 $PINS A1=HFSNET_10 A2=copt_net_1524 B1=copt_net_2533 B2=HFSNET_17
+ Z=n119 VDD=VDD VSS=VSS
XU90 aor22d1 $PINS A1=HFSNET_17 A2=col1_q1[11] B1=c_out[43] B2=HFSNET_10 Z=n120
+ VDD=VDD VSS=VSS
XU91 aor22d1 $PINS A1=HFSNET_9 A2=copt_net_2464 B1=copt_net_2800 B2=HFSNET_14
+ Z=n121 VDD=VDD VSS=VSS
XU92 aor22d1 $PINS A1=HFSNET_19 A2=copt_net_285 B1=c_out[44] B2=HFSNET_13
+ Z=n122 VDD=VDD VSS=VSS
XU93 aor22d1 $PINS A1=HFSNET_9 A2=copt_net_286 B1=copt_net_2671 B2=HFSNET_14
+ Z=n123 VDD=VDD VSS=VSS
XU94 aor22d1 $PINS A1=HFSNET_19 A2=col1_q1[13] B1=c_out[45] B2=HFSNET_13 Z=n124
+ VDD=VDD VSS=VSS
XU95 aor22d1 $PINS A1=HFSNET_9 A2=copt_net_2473 B1=copt_net_2799 B2=HFSNET_14
+ Z=n125 VDD=VDD VSS=VSS
XU96 aor22d1 $PINS A1=HFSNET_17 A2=copt_net_2070 B1=c_out[46] B2=HFSNET_10
+ Z=n126 VDD=VDD VSS=VSS
XU97 aor22d1 $PINS A1=HFSNET_9 A2=copt_net_2069 B1=copt_net_2465 B2=HFSNET_14
+ Z=n127 VDD=VDD VSS=VSS
XU98 aor22d1 $PINS A1=HFSNET_19 A2=copt_net_2190 B1=c_out[47] B2=HFSNET_13
+ Z=n128 VDD=VDD VSS=VSS
XU99 aor22d1 $PINS A1=HFSNET_13 A2=copt_net_2190 B1=copt_net_2679 B2=HFSNET_19
+ Z=n129 VDD=VDD VSS=VSS
XU100 aor22d1 $PINS A1=HFSNET_14 A2=copt_net_253 B1=copt_net_2341 B2=HFSNET_9
+ Z=n130 VDD=VDD VSS=VSS
XU101 aor22d1 $PINS A1=HFSNET_11 A2=copt_net_254 B1=copt_net_2707 B2=HFSNET_16
+ Z=n131 VDD=VDD VSS=VSS
XU102 aor22d1 $PINS A1=HFSNET_16 A2=copt_net_2697 B1=copt_net_240 B2=HFSNET_11
+ Z=n132 VDD=VDD VSS=VSS
XU103 aor22d1 $PINS A1=HFSNET_11 A2=col1_q1[17] B1=psum_in[49] B2=HFSNET_16
+ Z=n133 VDD=VDD VSS=VSS
XU104 aor22d1 $PINS A1=HFSNET_14 A2=copt_net_2488 B1=copt_net_391 B2=HFSNET_9
+ Z=n134 VDD=VDD VSS=VSS
XU105 aor22d1 $PINS A1=HFSNET_11 A2=copt_net_2488 B1=copt_net_1632 B2=HFSNET_16
+ Z=n135 VDD=VDD VSS=VSS
XU106 aor22d1 $PINS A1=HFSNET_16 A2=copt_net_1186 B1=copt_net_2337 B2=HFSNET_11
+ Z=n136 VDD=VDD VSS=VSS
XU107 aor22d1 $PINS A1=HFSNET_11 A2=copt_net_1186 B1=copt_net_2662 B2=HFSNET_16
+ Z=n137 VDD=VDD VSS=VSS
XU108 aor22d1 $PINS A1=HFSNET_14 A2=col1_q1[20] B1=copt_net_1224 B2=HFSNET_9
+ Z=n138 VDD=VDD VSS=VSS
XU109 aor22d1 $PINS A1=HFSNET_11 A2=copt_net_1667 B1=copt_net_2542 B2=HFSNET_16
+ Z=n139 VDD=VDD VSS=VSS
XU110 aor22d1 $PINS A1=HFSNET_14 A2=copt_net_1283 B1=c_out[53] B2=HFSNET_9
+ Z=n140 VDD=VDD VSS=VSS
XU111 aor22d1 $PINS A1=HFSNET_9 A2=copt_net_1283 B1=copt_net_2618 B2=HFSNET_14
+ Z=n141 VDD=VDD VSS=VSS
XU112 aor22d1 $PINS A1=HFSNET_14 A2=copt_net_1284 B1=c_out[54] B2=HFSNET_9
+ Z=n142 VDD=VDD VSS=VSS
XU113 aor22d1 $PINS A1=HFSNET_9 A2=copt_net_1284 B1=copt_net_2606 B2=HFSNET_14
+ Z=n143 VDD=VDD VSS=VSS
XU114 aor22d1 $PINS A1=HFSNET_14 A2=copt_net_745 B1=copt_net_2405 B2=HFSNET_9
+ Z=n144 VDD=VDD VSS=VSS
XU115 aor22d1 $PINS A1=HFSNET_11 A2=copt_net_745 B1=copt_net_2712 B2=HFSNET_16
+ Z=n145 VDD=VDD VSS=VSS
XU116 aor22d1 $PINS A1=HFSNET_14 A2=copt_net_1226 B1=copt_net_2321 B2=HFSNET_9
+ Z=n146 VDD=VDD VSS=VSS
XU117 aor22d1 $PINS A1=HFSNET_11 A2=copt_net_1226 B1=copt_net_2622 B2=HFSNET_16
+ Z=n147 VDD=VDD VSS=VSS
XU118 aor22d1 $PINS A1=HFSNET_14 A2=copt_net_1700 B1=copt_net_693 B2=HFSNET_9
+ Z=n148 VDD=VDD VSS=VSS
XU119 aor22d1 $PINS A1=HFSNET_11 A2=copt_net_1700 B1=copt_net_2521 B2=HFSNET_16
+ Z=n149 VDD=VDD VSS=VSS
XU120 aor22d1 $PINS A1=HFSNET_16 A2=copt_net_1357 B1=c_out[58] B2=HFSNET_11
+ Z=n150 VDD=VDD VSS=VSS
XU121 aor22d1 $PINS A1=HFSNET_11 A2=copt_net_1357 B1=copt_net_2483 B2=HFSNET_16
+ Z=n151 VDD=VDD VSS=VSS
XU122 aor22d1 $PINS A1=HFSNET_16 A2=copt_net_1967 B1=c_out[59] B2=HFSNET_11
+ Z=n152 VDD=VDD VSS=VSS
XU123 aor22d1 $PINS A1=HFSNET_11 A2=col1_q1[27] B1=psum_in[59] B2=HFSNET_16
+ Z=n153 VDD=VDD VSS=VSS
XU124 aor22d1 $PINS A1=HFSNET_16 A2=copt_net_1998 B1=c_out[60] B2=HFSNET_11
+ Z=n154 VDD=VDD VSS=VSS
XU125 aor22d1 $PINS A1=HFSNET_11 A2=copt_net_1998 B1=copt_net_2235 B2=HFSNET_16
+ Z=n155 VDD=VDD VSS=VSS
XU126 aor22d1 $PINS A1=HFSNET_16 A2=copt_net_2344 B1=copt_net_2171 B2=HFSNET_11
+ Z=n156 VDD=VDD VSS=VSS
XU127 aor22d1 $PINS A1=HFSNET_11 A2=copt_net_2343 B1=copt_net_1806 B2=HFSNET_16
+ Z=n157 VDD=VDD VSS=VSS
XU128 aor22d1 $PINS A1=HFSNET_17 A2=copt_net_1197 B1=c_out[62] B2=HFSNET_10
+ Z=n158 VDD=VDD VSS=VSS
XU129 aor22d1 $PINS A1=HFSNET_10 A2=copt_net_1197 B1=copt_net_2643 B2=HFSNET_17
+ Z=n159 VDD=VDD VSS=VSS
XU130 aor22d1 $PINS A1=HFSNET_17 A2=copt_net_2063 B1=c_out[63] B2=HFSNET_10
+ Z=n160 VDD=VDD VSS=VSS
XU131 aor22d1 $PINS A1=HFSNET_10 A2=copt_net_2063 B1=copt_net_2722 B2=HFSNET_17
+ Z=n161 VDD=VDD VSS=VSS
XU132 aor22d1 $PINS A1=copt_net_1945 A2=HFSNET_17 B1=c_out[64] B2=HFSNET_10
+ Z=n162 VDD=VDD VSS=VSS
XU133 aor22d1 $PINS A1=copt_net_1798 A2=HFSNET_17 B1=copt_net_2287 B2=HFSNET_10
+ Z=n163 VDD=VDD VSS=VSS
XU134 aor22d1 $PINS A1=copt_net_1907 A2=HFSNET_17 B1=copt_net_2503 B2=HFSNET_10
+ Z=n164 VDD=VDD VSS=VSS
XU135 aor22d1 $PINS A1=copt_net_1926 A2=HFSNET_17 B1=c_out[67] B2=HFSNET_10
+ Z=n165 VDD=VDD VSS=VSS
XU136 aor22d1 $PINS A1=copt_net_2131 A2=HFSNET_17 B1=c_out[68] B2=HFSNET_10
+ Z=n166 VDD=VDD VSS=VSS
XU137 aor22d1 $PINS A1=copt_net_1731 A2=HFSNET_17 B1=c_out[69] B2=HFSNET_10
+ Z=n167 VDD=VDD VSS=VSS
XU138 aor22d1 $PINS A1=copt_net_1751 A2=HFSNET_17 B1=copt_net_2539 B2=HFSNET_10
+ Z=n168 VDD=VDD VSS=VSS
XU139 aor22d1 $PINS A1=copt_net_2099 A2=HFSNET_8 B1=c_out[71] B2=array_en
+ Z=n169 VDD=VDD VSS=VSS
XU140 aor22d1 $PINS A1=copt_net_1674 A2=HFSNET_8 B1=copt_net_2333 B2=array_en
+ Z=n170 VDD=VDD VSS=VSS
XU141 aor22d1 $PINS A1=copt_net_1773 A2=HFSNET_8 B1=copt_net_2285 B2=array_en
+ Z=n171 VDD=VDD VSS=VSS
XU142 aor22d1 $PINS A1=copt_net_2101 A2=HFSNET_17 B1=c_out[74] B2=HFSNET_10
+ Z=n172 VDD=VDD VSS=VSS
XU143 aor22d1 $PINS A1=copt_net_1728 A2=HFSNET_17 B1=c_out[75] B2=HFSNET_10
+ Z=n173 VDD=VDD VSS=VSS
XU144 aor22d1 $PINS A1=copt_net_1780 A2=HFSNET_17 B1=copt_net_2324 B2=HFSNET_10
+ Z=n174 VDD=VDD VSS=VSS
XU145 aor22d1 $PINS A1=copt_net_2151 A2=HFSNET_8 B1=c_out[77] B2=array_en
+ Z=n175 VDD=VDD VSS=VSS
XU146 aor22d1 $PINS A1=copt_net_2180 A2=HFSNET_17 B1=c_out[78] B2=HFSNET_10
+ Z=n176 VDD=VDD VSS=VSS
XU147 aor22d1 $PINS A1=copt_net_2143 A2=HFSNET_8 B1=c_out[79] B2=array_en
+ Z=n177 VDD=VDD VSS=VSS
XU148 aor22d1 $PINS A1=copt_net_2136 A2=HFSNET_8 B1=c_out[80] B2=array_en
+ Z=n178 VDD=VDD VSS=VSS
XU149 aor22d1 $PINS A1=copt_net_2177 A2=HFSNET_8 B1=c_out[81] B2=array_en
+ Z=n179 VDD=VDD VSS=VSS
XU150 aor22d1 $PINS A1=copt_net_2176 A2=HFSNET_8 B1=c_out[82] B2=array_en
+ Z=n180 VDD=VDD VSS=VSS
XU151 aor22d1 $PINS A1=copt_net_2118 A2=HFSNET_8 B1=c_out[83] B2=array_en
+ Z=n181 VDD=VDD VSS=VSS
XU152 aor22d1 $PINS A1=copt_net_2027 A2=HFSNET_8 B1=c_out[84] B2=array_en
+ Z=n182 VDD=VDD VSS=VSS
XU153 aor22d1 $PINS A1=copt_net_2060 A2=HFSNET_8 B1=c_out[85] B2=array_en
+ Z=n183 VDD=VDD VSS=VSS
XU154 aor22d1 $PINS A1=copt_net_2129 A2=HFSNET_8 B1=c_out[86] B2=array_en
+ Z=n184 VDD=VDD VSS=VSS
XU155 aor22d1 $PINS A1=copt_net_2119 A2=HFSNET_8 B1=c_out[87] B2=array_en
+ Z=n185 VDD=VDD VSS=VSS
XU156 aor22d1 $PINS A1=copt_net_2004 A2=HFSNET_8 B1=c_out[88] B2=array_en
+ Z=n186 VDD=VDD VSS=VSS
XU157 aor22d1 $PINS A1=copt_net_2017 A2=HFSNET_17 B1=c_out[89] B2=HFSNET_10
+ Z=n187 VDD=VDD VSS=VSS
XU158 aor22d1 $PINS A1=copt_net_1915 A2=HFSNET_8 B1=copt_net_2258 B2=array_en
+ Z=n188 VDD=VDD VSS=VSS
XU159 aor22d1 $PINS A1=copt_net_1996 A2=HFSNET_8 B1=copt_net_2297 B2=array_en
+ Z=n189 VDD=VDD VSS=VSS
XU160 aor22d1 $PINS A1=copt_net_2003 A2=HFSNET_8 B1=c_out[92] B2=array_en
+ Z=n190 VDD=VDD VSS=VSS
XU161 aor22d1 $PINS A1=copt_net_2090 A2=HFSNET_8 B1=copt_net_2640 B2=array_en
+ Z=n191 VDD=VDD VSS=VSS
XU162 aor22d1 $PINS A1=copt_net_2051 A2=HFSNET_8 B1=copt_net_2314 B2=array_en
+ Z=n192 VDD=VDD VSS=VSS
XU163 aor22d1 $PINS A1=psum_in[95] A2=HFSNET_8 B1=c_out[95] B2=array_en Z=n193
+ VDD=VDD VSS=VSS
XU164 aor22d1 $PINS A1=HFSNET_20 A2=copt_net_1200 B1=c_out[0] B2=HFSNET_15 Z=n2
+ VDD=VDD VSS=VSS
XU165 aor22d1 $PINS A1=HFSNET_22 A2=copt_net_2770 B1=HFSNET_21 B2=copt_net_1201
+ Z=n3 VDD=VDD VSS=VSS
XU166 aor22d1 $PINS A1=HFSNET_20 A2=copt_net_2170 B1=c_out[1] B2=HFSNET_15 Z=n4
+ VDD=VDD VSS=VSS
XU167 aor22d1 $PINS A1=HFSNET_20 A2=copt_net_2223 B1=HFSNET_15 B2=copt_net_2170
+ Z=n5 VDD=VDD VSS=VSS
XU168 aor22d1 $PINS A1=HFSNET_19 A2=copt_net_1368 B1=copt_net_2625 B2=HFSNET_13
+ Z=n6 VDD=VDD VSS=VSS
XU169 aor22d1 $PINS A1=HFSNET_19 A2=copt_net_1414 B1=HFSNET_13 B2=copt_net_1368
+ Z=n7 VDD=VDD VSS=VSS
XU170 aor22d1 $PINS A1=HFSNET_20 A2=copt_net_2135 B1=copt_net_2713 B2=HFSNET_15
+ Z=n8 VDD=VDD VSS=VSS
XU171 aor22d1 $PINS A1=HFSNET_18 A2=copt_net_2192 B1=HFSNET_12 B2=copt_net_2135
+ Z=n9 VDD=VDD VSS=VSS
XU172 aor22d1 $PINS A1=HFSNET_19 A2=copt_net_2139 B1=c_out[4] B2=HFSNET_13
+ Z=n10 VDD=VDD VSS=VSS
XU173 aor22d1 $PINS A1=HFSNET_19 A2=copt_net_1393 B1=HFSNET_13 B2=copt_net_2139
+ Z=n11 VDD=VDD VSS=VSS
XU174 aor22d4 $PINS A1=HFSNET_19 A2=copt_net_293 B1=copt_net_2292 B2=HFSNET_13
+ Z=n12 VDD=VDD VSS=VSS
XU175 aor22d1 $PINS A1=HFSNET_16 A2=copt_net_1567 B1=HFSNET_11 B2=copt_net_293
+ Z=n13 VDD=VDD VSS=VSS
XU176 aor22d1 $PINS A1=HFSNET_19 A2=copt_net_2134 B1=c_out[6] B2=HFSNET_13
+ Z=n14 VDD=VDD VSS=VSS
XU177 aor22d1 $PINS A1=HFSNET_19 A2=copt_net_1450 B1=HFSNET_13 B2=copt_net_2134
+ Z=n15 VDD=VDD VSS=VSS
XU178 aor22d1 $PINS A1=HFSNET_20 A2=copt_net_2222 B1=c_out[7] B2=HFSNET_15
+ Z=n16 VDD=VDD VSS=VSS
XU179 aor22d1 $PINS A1=HFSNET_19 A2=copt_net_2179 B1=HFSNET_13 B2=copt_net_2222
+ Z=n17 VDD=VDD VSS=VSS
XU180 aor22d1 $PINS A1=HFSNET_20 A2=col0_q2[8] B1=c_out[8] B2=HFSNET_15 Z=n18
+ VDD=VDD VSS=VSS
XU181 aor22d1 $PINS A1=HFSNET_17 A2=copt_net_1741 B1=HFSNET_10 B2=copt_net_2456
+ Z=n19 VDD=VDD VSS=VSS
XU182 aor22d1 $PINS A1=HFSNET_20 A2=copt_net_2211 B1=c_out[9] B2=HFSNET_15
+ Z=n20 VDD=VDD VSS=VSS
XU183 aor22d1 $PINS A1=HFSNET_20 A2=copt_net_2031 B1=HFSNET_15 B2=copt_net_2211
+ Z=n21 VDD=VDD VSS=VSS
XU184 aor22d1 $PINS A1=HFSNET_20 A2=copt_net_1555 B1=c_out[10] B2=HFSNET_15
+ Z=n22 VDD=VDD VSS=VSS
XU185 aor22d1 $PINS A1=HFSNET_20 A2=copt_net_2396 B1=HFSNET_15 B2=copt_net_1555
+ Z=n23 VDD=VDD VSS=VSS
XU186 aor22d1 $PINS A1=HFSNET_20 A2=col0_q2[11] B1=c_out[11] B2=HFSNET_15 Z=n24
+ VDD=VDD VSS=VSS
XU187 aor22d1 $PINS A1=HFSNET_18 A2=copt_net_2457 B1=HFSNET_12 B2=copt_net_1831
+ Z=n25 VDD=VDD VSS=VSS
XU188 aor22d1 $PINS A1=HFSNET_20 A2=copt_net_1606 B1=c_out[12] B2=HFSNET_15
+ Z=n26 VDD=VDD VSS=VSS
XU189 aor22d1 $PINS A1=HFSNET_20 A2=copt_net_2472 B1=HFSNET_15 B2=copt_net_1606
+ Z=n27 VDD=VDD VSS=VSS
XU190 aor22d1 $PINS A1=HFSNET_19 A2=copt_net_2494 B1=c_out[13] B2=HFSNET_13
+ Z=n28 VDD=VDD VSS=VSS
XU191 aor22d1 $PINS A1=HFSNET_20 A2=col0_q1[13] B1=HFSNET_15 B2=col0_q2[13]
+ Z=n29 VDD=VDD VSS=VSS
XU192 aor22d1 $PINS A1=HFSNET_20 A2=copt_net_2354 B1=c_out[14] B2=HFSNET_15
+ Z=n30 VDD=VDD VSS=VSS
XU193 aor22d1 $PINS A1=HFSNET_20 A2=copt_net_1690 B1=HFSNET_15 B2=copt_net_2354
+ Z=n31 VDD=VDD VSS=VSS
Xcol1_q1_reg_31_ dfcrq2 $PINS D=n161 CP=ZCTSNET_2 CDN=HFSNET_33 Q=col1_q1[31]
+ VDD=VDD VSS=VSS
Xcol1_q1_reg_30_ dfcrq2 $PINS D=n159 CP=ZCTSNET_2 CDN=HFSNET_33 Q=col1_q1[30]
+ VDD=VDD VSS=VSS
Xcol1_q1_reg_29_ dfcrq2 $PINS D=n157 CP=ZCTSNET_36 CDN=HFSNET_32 Q=col1_q1[29]
+ VDD=VDD VSS=VSS
Xcol1_q1_reg_28_ dfcrq2 $PINS D=n155 CP=ZCTSNET_36 CDN=HFSNET_32 Q=col1_q1[28]
+ VDD=VDD VSS=VSS
Xcol1_q1_reg_27_ dfcrq2 $PINS D=copt_net_2738 CP=ZCTSNET_36 CDN=HFSNET_32
+ Q=col1_q1[27] VDD=VDD VSS=VSS
Xcol1_q1_reg_26_ dfcrq2 $PINS D=n151 CP=sbcto_ht1_0 CDN=HFSNET_32 Q=col1_q1[26]
+ VDD=VDD VSS=VSS
Xcol1_q1_reg_25_ dfcrq2 $PINS D=n149 CP=sbcto_ht1_0 CDN=HFSNET_32 Q=col1_q1[25]
+ VDD=VDD VSS=VSS
Xcol1_q1_reg_24_ dfcrq2 $PINS D=n147 CP=ZCTSNET_39 CDN=HFSNET_31 Q=col1_q1[24]
+ VDD=VDD VSS=VSS
Xcol1_q1_reg_23_ dfcrq2 $PINS D=n145 CP=ZCTSNET_39 CDN=HFSNET_31 Q=col1_q1[23]
+ VDD=VDD VSS=VSS
Xcol1_q1_reg_22_ dfcrq2 $PINS D=n143 CP=ZCTSNET_39 CDN=HFSNET_31 Q=col1_q1[22]
+ VDD=VDD VSS=VSS
Xcol1_q1_reg_21_ dfcrq2 $PINS D=n141 CP=ZCTSNET_39 CDN=HFSNET_31 Q=col1_q1[21]
+ VDD=VDD VSS=VSS
Xcol1_q1_reg_20_ dfcrq2 $PINS D=n139 CP=sbcto_ht1_0 CDN=HFSNET_31 Q=col1_q1[20]
+ VDD=VDD VSS=VSS
Xcol1_q1_reg_19_ dfcrq2 $PINS D=n137 CP=ZCTSNET_39 CDN=HFSNET_31 Q=col1_q1[19]
+ VDD=VDD VSS=VSS
Xcol1_q1_reg_18_ dfcrq2 $PINS D=n135 CP=ZCTSNET_36 CDN=HFSNET_31 Q=col1_q1[18]
+ VDD=VDD VSS=VSS
Xcol1_q1_reg_17_ dfcrq2 $PINS D=copt_net_298 CP=ZCTSNET_36 CDN=HFSNET_31
+ Q=col1_q1[17] VDD=VDD VSS=VSS
Xcol1_q1_reg_16_ dfcrq2 $PINS D=n131 CP=ZCTSNET_39 CDN=HFSNET_31 Q=col1_q1[16]
+ VDD=VDD VSS=VSS
Xcol1_q1_reg_15_ dfcrq2 $PINS D=copt_net_2918 CP=ZCTSNET_4 CDN=HFSNET_28
+ Q=col1_q1[15] VDD=VDD VSS=VSS
Xcol1_q1_reg_14_ dfcrq2 $PINS D=n127 CP=ZCTSNET_2 CDN=HFSNET_26 Q=col1_q1[14]
+ VDD=VDD VSS=VSS
Xcol1_q1_reg_13_ dfcrq2 $PINS D=n125 CP=ZCTSNET_39 CDN=HFSNET_26 Q=col1_q1[13]
+ VDD=VDD VSS=VSS
Xcol1_q1_reg_12_ dfcrq2 $PINS D=n123 CP=ZCTSNET_39 CDN=HFSNET_31 Q=col1_q1[12]
+ VDD=VDD VSS=VSS
Xcol1_q1_reg_11_ dfcrq2 $PINS D=n121 CP=ZCTSNET_39 CDN=HFSNET_26 Q=col1_q1[11]
+ VDD=VDD VSS=VSS
Xcol1_q1_reg_10_ dfcrq2 $PINS D=n119 CP=ZCTSNET_43 CDN=HFSNET_33 Q=col1_q1[10]
+ VDD=VDD VSS=VSS
Xcol1_q1_reg_9_ dfcrq2 $PINS D=n117 CP=ZCTSNET_36 CDN=HFSNET_32 Q=col1_q1[9]
+ VDD=VDD VSS=VSS
Xcol1_q1_reg_8_ dfcrq2 $PINS D=n115 CP=ZCTSNET_39 CDN=HFSNET_31 Q=col1_q1[8]
+ VDD=VDD VSS=VSS
Xcol1_q1_reg_7_ dfcrq2 $PINS D=n113 CP=ZCTSNET_39 CDN=HFSNET_31 Q=col1_q1[7]
+ VDD=VDD VSS=VSS
Xcol1_q1_reg_6_ dfcrq2 $PINS D=n111 CP=ZCTSNET_43 CDN=HFSNET_35 Q=col1_q1[6]
+ VDD=VDD VSS=VSS
Xcol1_q1_reg_5_ dfcrq2 $PINS D=n109 CP=ZCTSNET_39 CDN=HFSNET_26 Q=col1_q1[5]
+ VDD=VDD VSS=VSS
Xcol1_q1_reg_4_ dfcrq2 $PINS D=n107 CP=ZCTSNET_39 CDN=HFSNET_26 Q=col1_q1[4]
+ VDD=VDD VSS=VSS
Xcol1_q1_reg_3_ dfcrq2 $PINS D=n105 CP=ZCTSNET_36 CDN=HFSNET_32 Q=col1_q1[3]
+ VDD=VDD VSS=VSS
Xcol1_q1_reg_2_ dfcrq2 $PINS D=copt_net_2746 CP=sbcto_ht1_0 CDN=HFSNET_29
+ Q=col1_q1[2] VDD=VDD VSS=VSS
Xcol1_q1_reg_1_ dfcrq2 $PINS D=copt_net_2876 CP=sbcto_ht1_0 CDN=HFSNET_29
+ Q=col1_q1[1] VDD=VDD VSS=VSS
Xcol1_q1_reg_0_ dfcrq2 $PINS D=copt_net_2821 CP=sbcto_ht1_0 CDN=HFSNET_29
+ Q=col1_q1[0] VDD=VDD VSS=VSS
Xcol0_q1_reg_31_ dfcrq2 $PINS D=copt_net_2890 CP=sbcto_ht1_0 CDN=HFSNET_29
+ Q=col0_q1[31] VDD=VDD VSS=VSS
Xcol0_q1_reg_30_ dfcrq2 $PINS D=n96 CP=sbcto_ht1_0 CDN=HFSNET_29 Q=col0_q1[30]
+ VDD=VDD VSS=VSS
Xcol0_q1_reg_29_ dfcrq2 $PINS D=copt_net_2912 CP=sbcto_ht1_0 CDN=HFSNET_25
+ Q=col0_q1[29] VDD=VDD VSS=VSS
Xcol0_q1_reg_28_ dfcrq2 $PINS D=n94 CP=ZCTSNET_5 CDN=HFSNET_27 Q=col0_q1[28]
+ VDD=VDD VSS=VSS
Xcol0_q1_reg_27_ dfcrq2 $PINS D=n93 CP=sbcto_ht1_0 CDN=HFSNET_28 Q=col0_q1[27]
+ VDD=VDD VSS=VSS
Xcol0_q1_reg_26_ dfcrq2 $PINS D=n92 CP=sbcto_ht1_0 CDN=HFSNET_28 Q=col0_q1[26]
+ VDD=VDD VSS=VSS
Xcol0_q1_reg_25_ dfcrq2 $PINS D=n91 CP=sbcto_ht1_0 CDN=HFSNET_29 Q=col0_q1[25]
+ VDD=VDD VSS=VSS
Xcol0_q1_reg_24_ dfcrq2 $PINS D=copt_net_306 CP=ZCTSNET_5 CDN=HFSNET_28
+ Q=col0_q1[24] VDD=VDD VSS=VSS
Xcol0_q1_reg_23_ dfcrq2 $PINS D=n89 CP=sbcto_ht1_0 CDN=HFSNET_28 Q=col0_q1[23]
+ VDD=VDD VSS=VSS
Xcol0_q1_reg_22_ dfcrq2 $PINS D=n88 CP=sbcto_ht1_0 CDN=HFSNET_28 Q=col0_q1[22]
+ VDD=VDD VSS=VSS
Xcol0_q1_reg_21_ dfcrq2 $PINS D=n87 CP=sbcto_ht1_0 CDN=HFSNET_28 Q=col0_q1[21]
+ VDD=VDD VSS=VSS
Xcol0_q1_reg_20_ dfcrq2 $PINS D=n86 CP=sbcto_ht1_0 CDN=HFSNET_28 Q=col0_q1[20]
+ VDD=VDD VSS=VSS
Xcol0_q1_reg_19_ dfcrq2 $PINS D=copt_net_2917 CP=sbcto_ht1_0 CDN=HFSNET_27
+ Q=col0_q1[19] VDD=VDD VSS=VSS
Xcol0_q1_reg_18_ dfcrq2 $PINS D=n84 CP=sbcto_ht1_0 CDN=HFSNET_28 Q=col0_q1[18]
+ VDD=VDD VSS=VSS
Xcol0_q1_reg_17_ dfcrq2 $PINS D=copt_net_2742 CP=ZCTSNET_5 CDN=HFSNET_27
+ Q=col0_q1[17] VDD=VDD VSS=VSS
Xcol0_q1_reg_16_ dfcrq2 $PINS D=n82 CP=sbcto_ht1_0 CDN=HFSNET_28 Q=col0_q1[16]
+ VDD=VDD VSS=VSS
Xcol0_q1_reg_15_ dfcrq2 $PINS D=n81 CP=sbcto_ht1_0 CDN=HFSNET_25 Q=col0_q1[15]
+ VDD=VDD VSS=VSS
Xcol0_q1_reg_14_ dfcrq2 $PINS D=n80 CP=sbcto_ht1_0 CDN=HFSNET_27 Q=col0_q1[14]
+ VDD=VDD VSS=VSS
Xcol0_q1_reg_13_ dfcrq2 $PINS D=copt_net_305 CP=ZCTSNET_5 CDN=HFSNET_27
+ Q=col0_q1[13] VDD=VDD VSS=VSS
Xcol0_q1_reg_12_ dfcrq2 $PINS D=n78 CP=ZCTSNET_5 CDN=HFSNET_27 Q=col0_q1[12]
+ VDD=VDD VSS=VSS
Xcol0_q1_reg_11_ dfcrq2 $PINS D=n77 CP=ZCTSNET_5 CDN=HFSNET_27 Q=col0_q1[11]
+ VDD=VDD VSS=VSS
Xcol0_q1_reg_10_ dfcrq2 $PINS D=n76 CP=ZCTSNET_4 CDN=HFSNET_26 Q=col0_q1[10]
+ VDD=VDD VSS=VSS
Xcol0_q1_reg_9_ dfcrq2 $PINS D=n75 CP=ZCTSNET_2 CDN=HFSNET_26 Q=col0_q1[9]
+ VDD=VDD VSS=VSS
Xcol0_q1_reg_8_ dfcrq2 $PINS D=n74 CP=ZCTSNET_2 CDN=HFSNET_26 Q=col0_q1[8]
+ VDD=VDD VSS=VSS
Xcol0_q1_reg_7_ dfcrq2 $PINS D=copt_net_2903 CP=sbcto_ht1_0 CDN=HFSNET_29
+ Q=col0_q1[7] VDD=VDD VSS=VSS
Xcol0_q1_reg_6_ dfcrq2 $PINS D=n72 CP=sbcto_ht1_0 CDN=HFSNET_31 Q=col0_q1[6]
+ VDD=VDD VSS=VSS
Xcol0_q1_reg_5_ dfcrq2 $PINS D=n71 CP=sbcto_ht1_0 CDN=HFSNET_31 Q=col0_q1[5]
+ VDD=VDD VSS=VSS
Xcol0_q1_reg_4_ dfcrq2 $PINS D=n70 CP=sbcto_ht1_0 CDN=HFSNET_28 Q=col0_q1[4]
+ VDD=VDD VSS=VSS
Xcol0_q1_reg_3_ dfcrq2 $PINS D=copt_net_2360 CP=ZCTSNET_5 CDN=HFSNET_27
+ Q=col0_q1[3] VDD=VDD VSS=VSS
Xcol0_q1_reg_2_ dfcrq2 $PINS D=n68 CP=sbcto_ht1_0 CDN=HFSNET_28 Q=col0_q1[2]
+ VDD=VDD VSS=VSS
Xcol0_q1_reg_1_ dfcrq2 $PINS D=copt_net_2923 CP=ZCTSNET_5 CDN=HFSNET_27
+ Q=col0_q1[1] VDD=VDD VSS=VSS
Xcol0_q1_reg_0_ dfcrq2 $PINS D=copt_net_2361 CP=ZCTSNET_5 CDN=HFSNET_29
+ Q=col0_q1[0] VDD=VDD VSS=VSS
Xcol0_q2_reg_31_ dfcrq2 $PINS D=copt_net_2853 CP=sbcto_ht1_0 CDN=HFSNET_27
+ Q=col0_q2[31] VDD=VDD VSS=VSS
Xcol0_q2_reg_30_ dfcrq2 $PINS D=copt_net_2919 CP=ZCTSNET_5 CDN=HFSNET_29
+ Q=col0_q2[30] VDD=VDD VSS=VSS
Xcol0_q2_reg_29_ dfcrq2 $PINS D=copt_net_2925 CP=sbcto_ht1_0 CDN=HFSNET_27
+ Q=col0_q2[29] VDD=VDD VSS=VSS
Xcol0_q2_reg_28_ dfcrq2 $PINS D=n59 CP=ZCTSNET_5 CDN=HFSNET_27 Q=col0_q2[28]
+ VDD=VDD VSS=VSS
Xcol0_q2_reg_27_ dfcrq2 $PINS D=n57 CP=sbcto_ht1_0 CDN=HFSNET_24 Q=col0_q2[27]
+ VDD=VDD VSS=VSS
Xcol0_q2_reg_26_ dfcrq2 $PINS D=n55 CP=ZCTSNET_8 CDN=HFSNET_24 Q=col0_q2[26]
+ VDD=VDD VSS=VSS
Xcol0_q2_reg_25_ dfcrq2 $PINS D=copt_net_2914 CP=sbcto_ht1_0 CDN=HFSNET_24
+ Q=col0_q2[25] VDD=VDD VSS=VSS
Xcol0_q2_reg_24_ dfcrq2 $PINS D=n51 CP=ZCTSNET_4 CDN=HFSNET_25 Q=col0_q2[24]
+ VDD=VDD VSS=VSS
Xcol0_q2_reg_23_ dfcrq2 $PINS D=copt_net_2934 CP=ZCTSNET_4 CDN=HFSNET_28
+ Q=col0_q2[23] VDD=VDD VSS=VSS
Xcol0_q2_reg_22_ dfcrq2 $PINS D=n47 CP=sbcto_ht1_0 CDN=HFSNET_27 Q=col0_q2[22]
+ VDD=VDD VSS=VSS
Xcol0_q2_reg_21_ dfcrq2 $PINS D=n45 CP=ZCTSNET_8 CDN=HFSNET_24 Q=col0_q2[21]
+ VDD=VDD VSS=VSS
Xcol0_q2_reg_20_ dfcrq2 $PINS D=copt_net_2875 CP=sbcto_ht1_0 CDN=HFSNET_28
+ Q=col0_q2[20] VDD=VDD VSS=VSS
Xcol0_q2_reg_19_ dfcrq2 $PINS D=copt_net_2927 CP=ZCTSNET_8 CDN=HFSNET_24
+ Q=col0_q2[19] VDD=VDD VSS=VSS
Xcol0_q2_reg_18_ dfcrq2 $PINS D=n39 CP=ZCTSNET_8 CDN=HFSNET_25 Q=col0_q2[18]
+ VDD=VDD VSS=VSS
Xcol0_q2_reg_17_ dfcrq2 $PINS D=copt_net_2820 CP=ZCTSNET_4 CDN=HFSNET_26
+ Q=col0_q2[17] VDD=VDD VSS=VSS
Xcol0_q2_reg_16_ dfcrq2 $PINS D=n35 CP=sbcto_ht1_0 CDN=HFSNET_28 Q=col0_q2[16]
+ VDD=VDD VSS=VSS
Xcol0_q2_reg_15_ dfcrq2 $PINS D=n33 CP=ZCTSNET_8 CDN=HFSNET_27 Q=col0_q2[15]
+ VDD=VDD VSS=VSS
Xcol0_q2_reg_14_ dfcrq2 $PINS D=n31 CP=sbcto_ht1_0 CDN=HFSNET_25 Q=col0_q2[14]
+ VDD=VDD VSS=VSS
Xcol0_q2_reg_13_ dfcrq2 $PINS D=copt_net_2819 CP=ZCTSNET_5 CDN=HFSNET_28
+ Q=col0_q2[13] VDD=VDD VSS=VSS
Xcol0_q2_reg_12_ dfcrq2 $PINS D=n27 CP=sbcto_ht1_0 CDN=HFSNET_25 Q=col0_q2[12]
+ VDD=VDD VSS=VSS
Xcol0_q2_reg_11_ dfcrq2 $PINS D=n25 CP=sbcto_ht1_0 CDN=HFSNET_27 Q=col0_q2[11]
+ VDD=VDD VSS=VSS
Xcol0_q2_reg_10_ dfcrq2 $PINS D=n23 CP=sbcto_ht1_0 CDN=HFSNET_25 Q=col0_q2[10]
+ VDD=VDD VSS=VSS
Xcol0_q2_reg_9_ dfcrq2 $PINS D=copt_net_2935 CP=sbcto_ht1_0 CDN=HFSNET_27
+ Q=col0_q2[9] VDD=VDD VSS=VSS
Xcol0_q2_reg_8_ dfcrq2 $PINS D=n19 CP=ZCTSNET_2 CDN=HFSNET_26 Q=col0_q2[8]
+ VDD=VDD VSS=VSS
Xcol0_q2_reg_7_ dfcrq2 $PINS D=copt_net_2922 CP=sbcto_ht1_0 CDN=HFSNET_28
+ Q=col0_q2[7] VDD=VDD VSS=VSS
Xcol0_q2_reg_6_ dfcrq2 $PINS D=copt_net_2926 CP=ZCTSNET_4 CDN=HFSNET_28
+ Q=col0_q2[6] VDD=VDD VSS=VSS
Xcol0_q2_reg_5_ dfcrq2 $PINS D=n13 CP=ZCTSNET_39 CDN=HFSNET_28 Q=col0_q2[5]
+ VDD=VDD VSS=VSS
Xcol0_q2_reg_4_ dfcrq2 $PINS D=copt_net_2938 CP=sbcto_ht1_0 CDN=HFSNET_25
+ Q=col0_q2[4] VDD=VDD VSS=VSS
Xcol0_q2_reg_3_ dfcrq2 $PINS D=copt_net_2907 CP=ZCTSNET_5 CDN=HFSNET_27
+ Q=col0_q2[3] VDD=VDD VSS=VSS
Xcol0_q2_reg_2_ dfcrq2 $PINS D=n7 CP=sbcto_ht1_0 CDN=HFSNET_28 Q=col0_q2[2]
+ VDD=VDD VSS=VSS
Xcol0_q2_reg_1_ dfcrq2 $PINS D=copt_net_2928 CP=ZCTSNET_4 CDN=HFSNET_25
+ Q=col0_q2[1] VDD=VDD VSS=VSS
Xcol0_q2_reg_0_ dfcrq2 $PINS D=n3 CP=sbcto_ht1_0 CDN=HFSNET_28 Q=col0_q2[0]
+ VDD=VDD VSS=VSS
Xcol2_q1_reg_31_ dfcrq2 $PINS D=copt_net_2745 CP=ZCTSNET_40 CDN=rst_n
+ Q=aps_rename_78_ VDD=VDD VSS=VSS
Xcol2_q1_reg_30_ dfcrq2 $PINS D=copt_net_2899 CP=ZCTSNET_40 CDN=rst_n
+ Q=c_out[94] VDD=VDD VSS=VSS
Xcol2_q1_reg_29_ dfcrq2 $PINS D=copt_net_2888 CP=ZCTSNET_40 CDN=rst_n
+ Q=c_out[93] VDD=VDD VSS=VSS
Xcol2_q1_reg_28_ dfcrq2 $PINS D=n190 CP=ZCTSNET_40 CDN=rst_n Q=aps_rename_79_
+ VDD=VDD VSS=VSS
Xcol2_q1_reg_27_ dfcrq2 $PINS D=n189 CP=ZCTSNET_40 CDN=rst_n Q=c_out[91]
+ VDD=VDD VSS=VSS
Xcol2_q1_reg_26_ dfcrq2 $PINS D=n188 CP=ZCTSNET_40 CDN=rst_n Q=c_out[90]
+ VDD=VDD VSS=VSS
Xcol2_q1_reg_25_ dfcrq2 $PINS D=n187 CP=ZCTSNET_40 CDN=HFSNET_33
+ Q=aps_rename_80_ VDD=VDD VSS=VSS
Xcol2_q1_reg_24_ dfcrq2 $PINS D=n186 CP=ZCTSNET_43 CDN=rst_n Q=aps_rename_81_
+ VDD=VDD VSS=VSS
Xcol2_q1_reg_23_ dfcrq2 $PINS D=n185 CP=ZCTSNET_43 CDN=HFSNET_33
+ Q=aps_rename_82_ VDD=VDD VSS=VSS
Xcol2_q1_reg_22_ dfcrq2 $PINS D=n184 CP=ZCTSNET_43 CDN=HFSNET_33
+ Q=aps_rename_83_ VDD=VDD VSS=VSS
Xcol2_q1_reg_21_ dfcrq2 $PINS D=n183 CP=ZCTSNET_43 CDN=HFSNET_33
+ Q=aps_rename_84_ VDD=VDD VSS=VSS
Xcol2_q1_reg_20_ dfcrq2 $PINS D=n182 CP=ZCTSNET_43 CDN=HFSNET_34
+ Q=aps_rename_85_ VDD=VDD VSS=VSS
Xcol2_q1_reg_19_ dfcrq2 $PINS D=n181 CP=ZCTSNET_43 CDN=HFSNET_33
+ Q=aps_rename_86_ VDD=VDD VSS=VSS
Xcol2_q1_reg_18_ dfcrq2 $PINS D=n180 CP=ZCTSNET_43 CDN=HFSNET_33
+ Q=aps_rename_87_ VDD=VDD VSS=VSS
Xcol2_q1_reg_17_ dfcrq2 $PINS D=n179 CP=ZCTSNET_43 CDN=HFSNET_33
+ Q=aps_rename_88_ VDD=VDD VSS=VSS
Xcol2_q1_reg_16_ dfcrq2 $PINS D=n178 CP=ZCTSNET_43 CDN=HFSNET_33
+ Q=aps_rename_89_ VDD=VDD VSS=VSS
Xcol2_q1_reg_15_ dfcrq2 $PINS D=n177 CP=ZCTSNET_43 CDN=HFSNET_33
+ Q=aps_rename_90_ VDD=VDD VSS=VSS
Xcol2_q1_reg_14_ dfcrq2 $PINS D=n176 CP=ZCTSNET_43 CDN=HFSNET_33
+ Q=aps_rename_91_ VDD=VDD VSS=VSS
Xcol2_q1_reg_13_ dfcrq2 $PINS D=n175 CP=ZCTSNET_40 CDN=HFSNET_33
+ Q=aps_rename_92_ VDD=VDD VSS=VSS
Xcol2_q1_reg_12_ dfcrq2 $PINS D=n174 CP=ZCTSNET_2 CDN=HFSNET_33 Q=c_out[76]
+ VDD=VDD VSS=VSS
Xcol2_q1_reg_11_ dfcrq2 $PINS D=n173 CP=ZCTSNET_40 CDN=HFSNET_33
+ Q=aps_rename_93_ VDD=VDD VSS=VSS
Xcol2_q1_reg_10_ dfcrq2 $PINS D=n172 CP=ZCTSNET_40 CDN=HFSNET_33
+ Q=aps_rename_94_ VDD=VDD VSS=VSS
Xcol2_q1_reg_9_ dfcrq2 $PINS D=n171 CP=ZCTSNET_40 CDN=HFSNET_33 Q=c_out[73]
+ VDD=VDD VSS=VSS
Xcol2_q1_reg_8_ dfcrq2 $PINS D=n170 CP=ZCTSNET_40 CDN=HFSNET_33 Q=c_out[72]
+ VDD=VDD VSS=VSS
Xcol2_q1_reg_7_ dfcrq2 $PINS D=n169 CP=ZCTSNET_40 CDN=HFSNET_33
+ Q=aps_rename_95_ VDD=VDD VSS=VSS
Xcol2_q1_reg_6_ dfcrq2 $PINS D=n168 CP=ZCTSNET_40 CDN=HFSNET_33 Q=c_out[70]
+ VDD=VDD VSS=VSS
Xcol2_q1_reg_5_ dfcrq2 $PINS D=n167 CP=ZCTSNET_40 CDN=HFSNET_33
+ Q=aps_rename_96_ VDD=VDD VSS=VSS
Xcol2_q1_reg_4_ dfcrq2 $PINS D=n166 CP=ZCTSNET_40 CDN=HFSNET_33
+ Q=aps_rename_97_ VDD=VDD VSS=VSS
Xcol2_q1_reg_3_ dfcrq2 $PINS D=n165 CP=ZCTSNET_43 CDN=HFSNET_33
+ Q=aps_rename_98_ VDD=VDD VSS=VSS
Xcol2_q1_reg_2_ dfcrq2 $PINS D=n164 CP=ZCTSNET_43 CDN=HFSNET_33 Q=c_out[66]
+ VDD=VDD VSS=VSS
Xcol2_q1_reg_1_ dfcrq2 $PINS D=n163 CP=ZCTSNET_40 CDN=HFSNET_33 Q=c_out[65]
+ VDD=VDD VSS=VSS
Xcol2_q1_reg_0_ dfcrq2 $PINS D=n162 CP=ZCTSNET_43 CDN=HFSNET_33
+ Q=aps_rename_99_ VDD=VDD VSS=VSS
Xcol1_q2_reg_31_ dfcrq2 $PINS D=n160 CP=ZCTSNET_2 CDN=HFSNET_33
+ Q=aps_rename_100_ VDD=VDD VSS=VSS
Xcol1_q2_reg_30_ dfcrq2 $PINS D=n158 CP=ZCTSNET_40 CDN=HFSNET_33
+ Q=aps_rename_101_ VDD=VDD VSS=VSS
Xcol1_q2_reg_29_ dfcrq2 $PINS D=n156 CP=sbcto_ht1_0 CDN=HFSNET_29 Q=c_out[61]
+ VDD=VDD VSS=VSS
Xcol1_q2_reg_28_ dfcrq2 $PINS D=n154 CP=ZCTSNET_36 CDN=HFSNET_32
+ Q=aps_rename_102_ VDD=VDD VSS=VSS
Xcol1_q2_reg_27_ dfcrq2 $PINS D=n152 CP=ZCTSNET_36 CDN=HFSNET_29
+ Q=aps_rename_103_ VDD=VDD VSS=VSS
Xcol1_q2_reg_26_ dfcrq2 $PINS D=n150 CP=sbcto_ht1_0 CDN=HFSNET_29
+ Q=aps_rename_104_ VDD=VDD VSS=VSS
Xcol1_q2_reg_25_ dfcrq2 $PINS D=n148 CP=ZCTSNET_39 CDN=HFSNET_31 Q=c_out[57]
+ VDD=VDD VSS=VSS
Xcol1_q2_reg_24_ dfcrq2 $PINS D=n146 CP=ZCTSNET_39 CDN=HFSNET_31 Q=c_out[56]
+ VDD=VDD VSS=VSS
Xcol1_q2_reg_23_ dfcrq2 $PINS D=n144 CP=ZCTSNET_39 CDN=HFSNET_31 Q=c_out[55]
+ VDD=VDD VSS=VSS
Xcol1_q2_reg_22_ dfcrq2 $PINS D=n142 CP=ZCTSNET_39 CDN=HFSNET_31
+ Q=aps_rename_105_ VDD=VDD VSS=VSS
Xcol1_q2_reg_21_ dfcrq2 $PINS D=n140 CP=ZCTSNET_39 CDN=HFSNET_31
+ Q=aps_rename_106_ VDD=VDD VSS=VSS
Xcol1_q2_reg_20_ dfcrq2 $PINS D=copt_net_2887 CP=ZCTSNET_39 CDN=HFSNET_31
+ Q=c_out[52] VDD=VDD VSS=VSS
Xcol1_q2_reg_19_ dfcrq2 $PINS D=n136 CP=ZCTSNET_39 CDN=HFSNET_31 Q=c_out[51]
+ VDD=VDD VSS=VSS
Xcol1_q2_reg_18_ dfcrq2 $PINS D=n134 CP=ZCTSNET_39 CDN=HFSNET_31 Q=c_out[50]
+ VDD=VDD VSS=VSS
Xcol1_q2_reg_17_ dfcrq2 $PINS D=n132 CP=ZCTSNET_39 CDN=HFSNET_31 Q=c_out[49]
+ VDD=VDD VSS=VSS
Xcol1_q2_reg_16_ dfcrq2 $PINS D=n130 CP=ZCTSNET_4 CDN=HFSNET_26 Q=c_out[48]
+ VDD=VDD VSS=VSS
Xcol1_q2_reg_15_ dfcrq2 $PINS D=copt_net_2929 CP=ZCTSNET_4 CDN=HFSNET_26
+ Q=aps_rename_107_ VDD=VDD VSS=VSS
Xcol1_q2_reg_14_ dfcrq2 $PINS D=n126 CP=ZCTSNET_2 CDN=HFSNET_26
+ Q=aps_rename_108_ VDD=VDD VSS=VSS
Xcol1_q2_reg_13_ dfcrq2 $PINS D=copt_net_249 CP=ZCTSNET_4 CDN=HFSNET_26
+ Q=c_out[45] VDD=VDD VSS=VSS
Xcol1_q2_reg_12_ dfcrq2 $PINS D=n122 CP=ZCTSNET_4 CDN=HFSNET_26
+ Q=aps_rename_109_ VDD=VDD VSS=VSS
Xcol1_q2_reg_11_ dfcrq2 $PINS D=copt_net_251 CP=ZCTSNET_4 CDN=HFSNET_26
+ Q=c_out[43] VDD=VDD VSS=VSS
Xcol1_q2_reg_10_ dfcrq2 $PINS D=n118 CP=ZCTSNET_43 CDN=HFSNET_33
+ Q=aps_rename_110_ VDD=VDD VSS=VSS
Xcol1_q2_reg_9_ dfcrq2 $PINS D=n116 CP=sbcto_ht1_0 CDN=HFSNET_28
+ Q=aps_rename_111_ VDD=VDD VSS=VSS
Xcol1_q2_reg_8_ dfcrq2 $PINS D=n114 CP=sbcto_ht1_0 CDN=HFSNET_28
+ Q=aps_rename_112_ VDD=VDD VSS=VSS
Xcol1_q2_reg_7_ dfcrq2 $PINS D=n112 CP=ZCTSNET_39 CDN=HFSNET_31 Q=c_out[39]
+ VDD=VDD VSS=VSS
Xcol1_q2_reg_6_ dfcrq2 $PINS D=n110 CP=ZCTSNET_39 CDN=HFSNET_31
+ Q=aps_rename_113_ VDD=VDD VSS=VSS
Xcol1_q2_reg_5_ dfcrq2 $PINS D=n108 CP=sbcto_ht1_0 CDN=HFSNET_28
+ Q=aps_rename_114_ VDD=VDD VSS=VSS
Xcol1_q2_reg_4_ dfcrq2 $PINS D=n106 CP=ZCTSNET_4 CDN=HFSNET_26
+ Q=aps_rename_115_ VDD=VDD VSS=VSS
Xcol1_q2_reg_3_ dfcrq2 $PINS D=n104 CP=ZCTSNET_2 CDN=HFSNET_33
+ Q=aps_rename_116_ VDD=VDD VSS=VSS
Xcol1_q2_reg_2_ dfcrq2 $PINS D=n102 CP=ZCTSNET_4 CDN=HFSNET_25 Q=c_out[34]
+ VDD=VDD VSS=VSS
Xcol1_q2_reg_1_ dfcrq2 $PINS D=n100 CP=ZCTSNET_4 CDN=HFSNET_25
+ Q=aps_rename_117_ VDD=VDD VSS=VSS
Xcol1_q2_reg_0_ dfcrq2 $PINS D=n98 CP=ZCTSNET_4 CDN=HFSNET_25 Q=aps_rename_118_
+ VDD=VDD VSS=VSS
Xcol0_q3_reg_31_ dfcrq2 $PINS D=n64 CP=sbcto_ht1_0 CDN=HFSNET_27
+ Q=aps_rename_119_ VDD=VDD VSS=VSS
Xcol0_q3_reg_30_ dfcrq2 $PINS D=copt_net_2904 CP=ZCTSNET_5 CDN=HFSNET_27
+ Q=c_out[30] VDD=VDD VSS=VSS
Xcol0_q3_reg_29_ dfcrq2 $PINS D=n60 CP=sbcto_ht1_0 CDN=HFSNET_27
+ Q=aps_rename_120_ VDD=VDD VSS=VSS
Xcol0_q3_reg_28_ dfcrq2 $PINS D=n58 CP=sbcto_ht1_0 CDN=HFSNET_25
+ Q=aps_rename_121_ VDD=VDD VSS=VSS
Xcol0_q3_reg_27_ dfcrq2 $PINS D=n56 CP=ZCTSNET_8 CDN=HFSNET_24 Q=c_out[27]
+ VDD=VDD VSS=VSS
Xcol0_q3_reg_26_ dfcrq2 $PINS D=n54 CP=ZCTSNET_8 CDN=HFSNET_24
+ Q=aps_rename_122_ VDD=VDD VSS=VSS
Xcol0_q3_reg_25_ dfcrq2 $PINS D=copt_net_2930 CP=ZCTSNET_8 CDN=HFSNET_24
+ Q=aps_rename_123_ VDD=VDD VSS=VSS
Xcol0_q3_reg_24_ dfcrq2 $PINS D=n50 CP=ZCTSNET_8 CDN=HFSNET_24 Q=c_out[24]
+ VDD=VDD VSS=VSS
Xcol0_q3_reg_23_ dfcrq2 $PINS D=copt_net_2902 CP=ZCTSNET_4 CDN=HFSNET_26
+ Q=aps_rename_124_ VDD=VDD VSS=VSS
Xcol0_q3_reg_22_ dfcrq2 $PINS D=copt_net_2937 CP=sbcto_ht1_0 CDN=HFSNET_24
+ Q=aps_rename_125_ VDD=VDD VSS=VSS
Xcol0_q3_reg_21_ dfcrq2 $PINS D=n44 CP=ZCTSNET_8 CDN=HFSNET_24 Q=c_out[21]
+ VDD=VDD VSS=VSS
Xcol0_q3_reg_20_ dfcrq2 $PINS D=n42 CP=ZCTSNET_4 CDN=HFSNET_25 Q=c_out[20]
+ VDD=VDD VSS=VSS
Xcol0_q3_reg_19_ dfcrq2 $PINS D=copt_net_2921 CP=ZCTSNET_8 CDN=HFSNET_24
+ Q=aps_rename_126_ VDD=VDD VSS=VSS
Xcol0_q3_reg_18_ dfcrq2 $PINS D=n38 CP=ZCTSNET_8 CDN=HFSNET_27
+ Q=aps_rename_127_ VDD=VDD VSS=VSS
Xcol0_q3_reg_17_ dfcrq2 $PINS D=n36 CP=ZCTSNET_4 CDN=HFSNET_25 Q=c_out[17]
+ VDD=VDD VSS=VSS
Xcol0_q3_reg_16_ dfcrq2 $PINS D=copt_net_2932 CP=sbcto_ht1_0 CDN=HFSNET_27
+ Q=c_out[16] VDD=VDD VSS=VSS
Xcol0_q3_reg_15_ dfcrq2 $PINS D=n32 CP=ZCTSNET_5 CDN=HFSNET_28
+ Q=aps_rename_128_ VDD=VDD VSS=VSS
Xcol0_q3_reg_14_ dfcrq2 $PINS D=n30 CP=ZCTSNET_8 CDN=HFSNET_25
+ Q=aps_rename_129_ VDD=VDD VSS=VSS
Xcol0_q3_reg_13_ dfcrq2 $PINS D=n28 CP=sbcto_ht1_0 CDN=HFSNET_25
+ Q=aps_rename_130_ VDD=VDD VSS=VSS
Xcol0_q3_reg_12_ dfcrq2 $PINS D=n26 CP=sbcto_ht1_0 CDN=HFSNET_27
+ Q=aps_rename_131_ VDD=VDD VSS=VSS
Xcol0_q3_reg_11_ dfcrq2 $PINS D=copt_net_2852 CP=ZCTSNET_8 CDN=HFSNET_24
+ Q=aps_rename_132_ VDD=VDD VSS=VSS
Xcol0_q3_reg_10_ dfcrq2 $PINS D=n22 CP=sbcto_ht1_0 CDN=HFSNET_27
+ Q=aps_rename_133_ VDD=VDD VSS=VSS
Xcol0_q3_reg_9_ dfcrq2 $PINS D=n20 CP=sbcto_ht1_0 CDN=HFSNET_25
+ Q=aps_rename_134_ VDD=VDD VSS=VSS
Xcol0_q3_reg_8_ dfcrq2 $PINS D=copt_net_299 CP=ZCTSNET_4 CDN=HFSNET_25
+ Q=c_out[8] VDD=VDD VSS=VSS
Xcol0_q3_reg_7_ dfcrq2 $PINS D=n16 CP=sbcto_ht1_0 CDN=HFSNET_25
+ Q=aps_rename_135_ VDD=VDD VSS=VSS
Xcol0_q3_reg_6_ dfcrq2 $PINS D=copt_net_2913 CP=ZCTSNET_4 CDN=HFSNET_28
+ Q=aps_rename_136_ VDD=VDD VSS=VSS
Xcol0_q3_reg_5_ dfcrq2 $PINS D=n12 CP=ZCTSNET_4 CDN=HFSNET_26 Q=c_out[5]
+ VDD=VDD VSS=VSS
Xcol0_q3_reg_4_ dfcrq2 $PINS D=copt_net_2931 CP=sbcto_ht1_0 CDN=HFSNET_28
+ Q=aps_rename_137_ VDD=VDD VSS=VSS
Xcol0_q3_reg_3_ dfcrq2 $PINS D=n8 CP=ZCTSNET_4 CDN=HFSNET_25 Q=c_out[3] VDD=VDD
+ VSS=VSS
Xcol0_q3_reg_2_ dfcrq2 $PINS D=n6 CP=ZCTSNET_4 CDN=HFSNET_26 Q=c_out[2] VDD=VDD
+ VSS=VSS
Xcol0_q3_reg_1_ dfcrq2 $PINS D=copt_net_2900 CP=ZCTSNET_4 CDN=HFSNET_25
+ Q=aps_rename_138_ VDD=VDD VSS=VSS
Xcol0_q3_reg_0_ dfcrq2 $PINS D=n2 CP=ZCTSNET_5 CDN=HFSNET_27 Q=aps_rename_139_
+ VDD=VDD VSS=VSS
XU2 mx02d1 $PINS I0=copt_net_1557 I1=c_out[15] S=HFSNET_15 Z=n32 VDD=VDD
+ VSS=VSS
XHFSINV_5661_602 inv0d1 $PINS I=HFSNET_18 ZN=HFSNET_13 VDD=VDD VSS=VSS
XHFSINV_13858_604 inv0d2 $PINS I=HFSNET_18 ZN=HFSNET_15 VDD=VDD VSS=VSS
XHFSBUF_10095_606 buffd1 $PINS I=HFSNET_18 Z=HFSNET_17 VDD=VDD VSS=VSS
XHFSBUF_5424_608 buffd1 $PINS I=HFSNET_18 Z=HFSNET_19 VDD=VDD VSS=VSS
XHFSBUF_13933_609 buffd1 $PINS I=HFSNET_18 Z=HFSNET_20 VDD=VDD VSS=VSS
Xcopt_h_inst_3070 dl02d1 $PINS I=c_out[49] Z=copt_net_240 VDD=VDD VSS=VSS
XHFSINV_15371_650 inv0d2 $PINS I=HFSNET_30 ZN=HFSNET_28 VDD=VDD VSS=VSS
Xcopt_h_inst_3079 dl04d1 $PINS I=n124 Z=copt_net_249 VDD=VDD VSS=VSS
Xcopt_h_inst_3081 dl04d1 $PINS I=n120 Z=copt_net_251 VDD=VDD VSS=VSS
Xcopt_h_inst_3083 dl04d1 $PINS I=col1_q1[16] Z=copt_net_253 VDD=VDD VSS=VSS
Xcopt_h_inst_3084 dl02d1 $PINS I=col1_q1[16] Z=copt_net_254 VDD=VDD VSS=VSS
Xcopt_h_inst_3100 dl04d1 $PINS I=col1_q1[4] Z=copt_net_270 VDD=VDD VSS=VSS
Xcopt_h_inst_3101 dl02d1 $PINS I=col1_q1[4] Z=copt_net_271 VDD=VDD VSS=VSS
Xcopt_h_inst_3115 dl04d1 $PINS I=col1_q1[12] Z=copt_net_285 VDD=VDD VSS=VSS
Xcopt_h_inst_3116 dl02d1 $PINS I=col1_q1[12] Z=copt_net_286 VDD=VDD VSS=VSS
Xcopt_h_inst_3123 dl02d1 $PINS I=col0_q2[5] Z=copt_net_293 VDD=VDD VSS=VSS
Xcopt_h_inst_3128 dl02d1 $PINS I=n133 Z=copt_net_298 VDD=VDD VSS=VSS
Xcopt_h_inst_3129 dl02d1 $PINS I=n18 Z=copt_net_299 VDD=VDD VSS=VSS
Xcopt_h_inst_3135 dl02d1 $PINS I=n79 Z=copt_net_305 VDD=VDD VSS=VSS
Xcopt_h_inst_3136 dl02d1 $PINS I=n90 Z=copt_net_306 VDD=VDD VSS=VSS
Xcopt_h_inst_3167 dl02d1 $PINS I=col1_q1[5] Z=copt_net_337 VDD=VDD VSS=VSS
Xcopt_h_inst_3183 dl02d1 $PINS I=col1_q1[8] Z=copt_net_353 VDD=VDD VSS=VSS
Xcopt_h_inst_3184 dl02d1 $PINS I=col1_q1[8] Z=copt_net_354 VDD=VDD VSS=VSS
Xcopt_h_inst_3221 dl02d1 $PINS I=c_out[50] Z=copt_net_391 VDD=VDD VSS=VSS
Xcopt_h_inst_3523 dl02d1 $PINS I=c_out[57] Z=copt_net_693 VDD=VDD VSS=VSS
Xcopt_h_inst_3576 dl02d1 $PINS I=col1_q1[23] Z=copt_net_745 VDD=VDD VSS=VSS
Xcopt_h_inst_3988 dl02d1 $PINS I=col1_q1[7] Z=copt_net_1156 VDD=VDD VSS=VSS
Xcopt_h_inst_4002 dl01d1 $PINS I=aps_rename_116_ Z=c_out[35] VDD=VDD VSS=VSS
Xcopt_h_inst_4018 dl02d1 $PINS I=col1_q1[19] Z=copt_net_1186 VDD=VDD VSS=VSS
Xcopt_h_inst_4029 dl02d1 $PINS I=col1_q1[30] Z=copt_net_1197 VDD=VDD VSS=VSS
Xcopt_h_inst_4032 dl02d1 $PINS I=col0_q2[0] Z=copt_net_1200 VDD=VDD VSS=VSS
Xcopt_h_inst_4033 dl02d1 $PINS I=col0_q2[0] Z=copt_net_1201 VDD=VDD VSS=VSS
Xcopt_h_inst_4056 dl01d1 $PINS I=c_out[52] Z=copt_net_1224 VDD=VDD VSS=VSS
Xcopt_h_inst_4058 dl02d1 $PINS I=col1_q1[24] Z=copt_net_1226 VDD=VDD VSS=VSS
Xcopt_h_inst_4083 dl02d1 $PINS I=aps_rename_113_ Z=c_out[38] VDD=VDD VSS=VSS
Xcopt_h_inst_4115 dl02d1 $PINS I=col1_q1[21] Z=copt_net_1283 VDD=VDD VSS=VSS
Xcopt_h_inst_4116 dl02d1 $PINS I=col1_q1[22] Z=copt_net_1284 VDD=VDD VSS=VSS
Xcopt_h_inst_4189 dl02d1 $PINS I=col1_q1[26] Z=copt_net_1357 VDD=VDD VSS=VSS
Xcopt_h_inst_4200 dl02d1 $PINS I=col0_q2[2] Z=copt_net_1368 VDD=VDD VSS=VSS
Xcopt_h_inst_4225 dl02d1 $PINS I=col0_q1[4] Z=copt_net_1393 VDD=VDD VSS=VSS
Xcopt_h_inst_4246 dl02d1 $PINS I=col0_q1[2] Z=copt_net_1414 VDD=VDD VSS=VSS
Xcopt_h_inst_4282 dl02d1 $PINS I=col0_q1[6] Z=copt_net_1450 VDD=VDD VSS=VSS
Xcopt_h_inst_4303 dl02d1 $PINS I=col0_q2[20] Z=copt_net_1471 VDD=VDD VSS=VSS
Xcopt_h_inst_4310 dl02d1 $PINS I=aps_rename_111_ Z=c_out[41] VDD=VDD VSS=VSS
Xcopt_h_inst_4335 dl02d1 $PINS I=col1_q1[0] Z=copt_net_1503 VDD=VDD VSS=VSS
Xcopt_h_inst_4356 dl02d1 $PINS I=col1_q1[10] Z=copt_net_1524 VDD=VDD VSS=VSS
Xcopt_h_inst_4375 dl02d1 $PINS I=col0_q1[30] Z=copt_net_1543 VDD=VDD VSS=VSS
Xcopt_h_inst_4383 dl02d1 $PINS I=col0_q1[16] Z=copt_net_1551 VDD=VDD VSS=VSS
Xcopt_h_inst_4387 dl02d1 $PINS I=col0_q2[10] Z=copt_net_1555 VDD=VDD VSS=VSS
Xcopt_h_inst_4389 dl02d1 $PINS I=col0_q2[15] Z=copt_net_1557 VDD=VDD VSS=VSS
Xcopt_h_inst_4394 dl02d1 $PINS I=psum_in[10] Z=copt_net_1562 VDD=VDD VSS=VSS
Xcopt_h_inst_4395 dl02d1 $PINS I=col0_q1[23] Z=copt_net_1563 VDD=VDD VSS=VSS
Xcopt_h_inst_4399 dl02d1 $PINS I=col0_q1[5] Z=copt_net_1567 VDD=VDD VSS=VSS
Xcopt_h_inst_4410 dl02d1 $PINS I=psum_in[41] Z=copt_net_1578 VDD=VDD VSS=VSS
Xcopt_h_inst_4438 dl02d1 $PINS I=col0_q2[12] Z=copt_net_1606 VDD=VDD VSS=VSS
Xcopt_h_inst_4450 dl02d1 $PINS I=psum_in[35] Z=copt_net_1618 VDD=VDD VSS=VSS
Xcopt_h_inst_4464 dl02d1 $PINS I=psum_in[50] Z=copt_net_1632 VDD=VDD VSS=VSS
Xcopt_h_inst_4496 dl02d1 $PINS I=c_out[24] Z=copt_net_1664 VDD=VDD VSS=VSS
Xcopt_h_inst_4499 dl02d1 $PINS I=col1_q1[20] Z=copt_net_1667 VDD=VDD VSS=VSS
Xcopt_h_inst_4504 dl02d1 $PINS I=col0_q1[20] Z=copt_net_1672 VDD=VDD VSS=VSS
Xcopt_h_inst_4506 dl02d1 $PINS I=psum_in[72] Z=copt_net_1674 VDD=VDD VSS=VSS
Xcopt_h_inst_4519 dl02d1 $PINS I=col1_q1[2] Z=copt_net_1687 VDD=VDD VSS=VSS
Xcopt_h_inst_4522 dl02d1 $PINS I=col0_q1[14] Z=copt_net_1690 VDD=VDD VSS=VSS
Xcopt_h_inst_4532 dl02d1 $PINS I=col1_q1[25] Z=copt_net_1700 VDD=VDD VSS=VSS
Xcopt_h_inst_4547 dl02d1 $PINS I=col1_q1[1] Z=copt_net_1715 VDD=VDD VSS=VSS
Xcopt_h_inst_4560 dl02d1 $PINS I=psum_in[75] Z=copt_net_1728 VDD=VDD VSS=VSS
Xcopt_h_inst_4563 dl02d1 $PINS I=psum_in[69] Z=copt_net_1731 VDD=VDD VSS=VSS
Xcopt_h_inst_4573 dl02d1 $PINS I=col0_q1[8] Z=copt_net_1741 VDD=VDD VSS=VSS
Xcopt_h_inst_4583 dl02d1 $PINS I=psum_in[70] Z=copt_net_1751 VDD=VDD VSS=VSS
Xcopt_h_inst_4592 dl02d1 $PINS I=aps_rename_130_ Z=c_out[13] VDD=VDD VSS=VSS
Xcopt_h_inst_4593 dl02d1 $PINS I=col0_q1[21] Z=copt_net_1761 VDD=VDD VSS=VSS
Xcopt_h_inst_4598 dl02d1 $PINS I=col0_q2[18] Z=copt_net_1766 VDD=VDD VSS=VSS
Xcopt_h_inst_4600 dl02d1 $PINS I=col0_q1[22] Z=copt_net_1768 VDD=VDD VSS=VSS
Xcopt_h_inst_4601 dl02d1 $PINS I=col0_q1[22] Z=copt_net_1769 VDD=VDD VSS=VSS
Xcopt_h_inst_4604 dl02d1 $PINS I=col0_q1[27] Z=copt_net_1772 VDD=VDD VSS=VSS
Xcopt_h_inst_4605 dl02d1 $PINS I=psum_in[73] Z=copt_net_1773 VDD=VDD VSS=VSS
Xcopt_h_inst_4612 dl02d1 $PINS I=psum_in[76] Z=copt_net_1780 VDD=VDD VSS=VSS
Xcopt_h_inst_4628 dl02d1 $PINS I=col1_q1[6] Z=copt_net_1796 VDD=VDD VSS=VSS
Xcopt_h_inst_4630 dl02d1 $PINS I=psum_in[65] Z=copt_net_1798 VDD=VDD VSS=VSS
Xcopt_h_inst_4637 dl02d1 $PINS I=aps_rename_121_ Z=c_out[28] VDD=VDD VSS=VSS
Xcopt_h_inst_4638 dl02d1 $PINS I=psum_in[61] Z=copt_net_1806 VDD=VDD VSS=VSS
Xcopt_h_inst_4644 dl02d1 $PINS I=col0_q1[25] Z=copt_net_1812 VDD=VDD VSS=VSS
Xcopt_h_inst_4645 dl02d1 $PINS I=col0_q1[25] Z=copt_net_1813 VDD=VDD VSS=VSS
Xcopt_h_inst_4663 dl02d1 $PINS I=col0_q2[11] Z=copt_net_1831 VDD=VDD VSS=VSS
Xcopt_h_inst_4685 dl01d1 $PINS I=col0_q1[26] Z=copt_net_1853 VDD=VDD VSS=VSS
Xcopt_h_inst_4739 dl02d1 $PINS I=psum_in[66] Z=copt_net_1907 VDD=VDD VSS=VSS
Xcopt_h_inst_4747 dl02d1 $PINS I=psum_in[90] Z=copt_net_1915 VDD=VDD VSS=VSS
Xcopt_h_inst_4758 dl02d1 $PINS I=psum_in[67] Z=copt_net_1926 VDD=VDD VSS=VSS
Xcopt_h_inst_4777 dl02d1 $PINS I=psum_in[64] Z=copt_net_1945 VDD=VDD VSS=VSS
Xcopt_h_inst_4800 dl02d1 $PINS I=col1_q1[27] Z=copt_net_1967 VDD=VDD VSS=VSS
Xcopt_h_inst_4829 dl02d1 $PINS I=psum_in[91] Z=copt_net_1996 VDD=VDD VSS=VSS
Xcopt_h_inst_4831 dl02d1 $PINS I=col1_q1[28] Z=copt_net_1998 VDD=VDD VSS=VSS
Xcopt_h_inst_4836 dl02d1 $PINS I=psum_in[92] Z=copt_net_2003 VDD=VDD VSS=VSS
Xcopt_h_inst_4837 dl02d1 $PINS I=psum_in[88] Z=copt_net_2004 VDD=VDD VSS=VSS
Xcopt_h_inst_4850 dl02d1 $PINS I=psum_in[89] Z=copt_net_2017 VDD=VDD VSS=VSS
Xcopt_h_inst_4860 dl02d1 $PINS I=psum_in[84] Z=copt_net_2027 VDD=VDD VSS=VSS
Xcopt_h_inst_4864 dl01d1 $PINS I=col0_q1[9] Z=copt_net_2031 VDD=VDD VSS=VSS
Xcopt_h_inst_4884 dl01d1 $PINS I=psum_in[94] Z=copt_net_2051 VDD=VDD VSS=VSS
Xcopt_h_inst_4893 dl02d1 $PINS I=psum_in[85] Z=copt_net_2060 VDD=VDD VSS=VSS
Xcopt_h_inst_4896 dl02d1 $PINS I=col1_q1[31] Z=copt_net_2063 VDD=VDD VSS=VSS
Xcopt_h_inst_4902 dl02d1 $PINS I=col1_q1[14] Z=copt_net_2069 VDD=VDD VSS=VSS
Xcopt_h_inst_4903 dl02d1 $PINS I=col1_q1[14] Z=copt_net_2070 VDD=VDD VSS=VSS
Xcopt_h_inst_4923 dl01d1 $PINS I=psum_in[93] Z=copt_net_2090 VDD=VDD VSS=VSS
Xcopt_h_inst_4932 dl02d1 $PINS I=psum_in[71] Z=copt_net_2099 VDD=VDD VSS=VSS
Xcopt_h_inst_4934 dl02d1 $PINS I=psum_in[74] Z=copt_net_2101 VDD=VDD VSS=VSS
Xcopt_h_inst_4951 dl02d1 $PINS I=psum_in[83] Z=copt_net_2118 VDD=VDD VSS=VSS
Xcopt_h_inst_4952 dl02d1 $PINS I=psum_in[87] Z=copt_net_2119 VDD=VDD VSS=VSS
Xcopt_h_inst_4959 dl02d1 $PINS I=col0_q2[26] Z=copt_net_2126 VDD=VDD VSS=VSS
Xcopt_h_inst_4962 dl02d1 $PINS I=psum_in[86] Z=copt_net_2129 VDD=VDD VSS=VSS
Xcopt_h_inst_4964 dl02d1 $PINS I=psum_in[68] Z=copt_net_2131 VDD=VDD VSS=VSS
Xcopt_h_inst_4967 dl01d1 $PINS I=col0_q2[6] Z=copt_net_2134 VDD=VDD VSS=VSS
Xcopt_h_inst_4968 dl02d1 $PINS I=col0_q2[3] Z=copt_net_2135 VDD=VDD VSS=VSS
Xcopt_h_inst_4969 dl02d1 $PINS I=psum_in[80] Z=copt_net_2136 VDD=VDD VSS=VSS
Xcopt_h_inst_4972 dl01d1 $PINS I=col0_q2[4] Z=copt_net_2139 VDD=VDD VSS=VSS
Xcopt_h_inst_4975 dl02d1 $PINS I=col0_q2[31] Z=copt_net_2142 VDD=VDD VSS=VSS
Xcopt_h_inst_4976 dl02d1 $PINS I=psum_in[79] Z=copt_net_2143 VDD=VDD VSS=VSS
Xcopt_h_inst_4978 dl02d1 $PINS I=col0_q1[28] Z=copt_net_2145 VDD=VDD VSS=VSS
Xcopt_h_inst_4980 dl02d1 $PINS I=col0_q2[21] Z=copt_net_2147 VDD=VDD VSS=VSS
Xcopt_h_inst_4984 dl02d1 $PINS I=psum_in[77] Z=copt_net_2151 VDD=VDD VSS=VSS
Xcopt_h_inst_5000 dl01d1 $PINS I=col0_q2[19] Z=copt_net_2167 VDD=VDD VSS=VSS
Xcopt_h_inst_5003 dl01d1 $PINS I=col0_q2[1] Z=copt_net_2170 VDD=VDD VSS=VSS
Xcopt_h_inst_5004 dl02d1 $PINS I=c_out[61] Z=copt_net_2171 VDD=VDD VSS=VSS
Xcopt_h_inst_5008 dl02d1 $PINS I=col0_q2[17] Z=copt_net_2175 VDD=VDD VSS=VSS
Xcopt_h_inst_5009 dl02d1 $PINS I=psum_in[82] Z=copt_net_2176 VDD=VDD VSS=VSS
Xcopt_h_inst_5010 dl02d1 $PINS I=psum_in[81] Z=copt_net_2177 VDD=VDD VSS=VSS
Xcopt_h_inst_5011 dl01d1 $PINS I=col0_q1[29] Z=copt_net_2178 VDD=VDD VSS=VSS
Xcopt_h_inst_5012 dl01d1 $PINS I=col0_q1[7] Z=copt_net_2179 VDD=VDD VSS=VSS
Xcopt_h_inst_5013 dl02d1 $PINS I=psum_in[78] Z=copt_net_2180 VDD=VDD VSS=VSS
Xcopt_h_inst_5015 dl02d1 $PINS I=col0_q2[29] Z=copt_net_2182 VDD=VDD VSS=VSS
Xcopt_h_inst_5016 dl02d1 $PINS I=psum_in[23] Z=copt_net_2183 VDD=VDD VSS=VSS
Xcopt_h_inst_5022 dl01d1 $PINS I=col0_q2[30] Z=copt_net_2189 VDD=VDD VSS=VSS
Xcopt_h_inst_5023 dl01d1 $PINS I=col1_q1[15] Z=copt_net_2190 VDD=VDD VSS=VSS
Xcopt_h_inst_5025 dl01d1 $PINS I=col0_q1[3] Z=copt_net_2192 VDD=VDD VSS=VSS
Xcopt_h_inst_5027 dl02d1 $PINS I=psum_in[12] Z=copt_net_2194 VDD=VDD VSS=VSS
Xcopt_h_inst_5028 dl01d1 $PINS I=aps_rename_132_ Z=c_out[11] VDD=VDD VSS=VSS
Xcopt_h_inst_5036 dl01d1 $PINS I=col0_q1[31] Z=copt_net_2203 VDD=VDD VSS=VSS
Xcopt_h_inst_5037 dl01d1 $PINS I=col0_q2[22] Z=copt_net_2204 VDD=VDD VSS=VSS
Xcopt_h_inst_5038 dl02d1 $PINS I=aps_rename_129_ Z=c_out[14] VDD=VDD VSS=VSS
Xcopt_h_inst_5044 dl02d1 $PINS I=col0_q2[9] Z=copt_net_2211 VDD=VDD VSS=VSS
Xcopt_h_inst_5046 dl01d1 $PINS I=aps_rename_80_ Z=c_out[89] VDD=VDD VSS=VSS
Xcopt_h_inst_5047 dl02d1 $PINS I=psum_in[18] Z=copt_net_2214 VDD=VDD VSS=VSS
Xcopt_h_inst_5048 dl01d1 $PINS I=col0_q2[23] Z=copt_net_2215 VDD=VDD VSS=VSS
Xcopt_h_inst_5050 dl01d1 $PINS I=col0_q2[16] Z=copt_net_2217 VDD=VDD VSS=VSS
Xcopt_h_inst_5051 dl01d1 $PINS I=psum_in[31] Z=copt_net_2218 VDD=VDD VSS=VSS
Xcopt_h_inst_5052 dl01d1 $PINS I=col0_q2[25] Z=copt_net_2219 VDD=VDD VSS=VSS
Xcopt_h_inst_5053 dl01d1 $PINS I=col0_q1[19] Z=copt_net_2220 VDD=VDD VSS=VSS
Xcopt_h_inst_5055 dl02d1 $PINS I=col0_q2[7] Z=copt_net_2222 VDD=VDD VSS=VSS
Xcopt_h_inst_5056 dl01d1 $PINS I=col0_q1[1] Z=copt_net_2223 VDD=VDD VSS=VSS
Xcopt_h_inst_5068 dl02d1 $PINS I=psum_in[60] Z=copt_net_2235 VDD=VDD VSS=VSS
Xcopt_h_inst_5069 dl02d1 $PINS I=psum_in[30] Z=copt_net_2236 VDD=VDD VSS=VSS
Xcopt_h_inst_5074 dl02d1 $PINS I=psum_in[15] Z=copt_net_2241 VDD=VDD VSS=VSS
Xcopt_h_inst_5077 dl01d1 $PINS I=c_out[27] Z=copt_net_2244 VDD=VDD VSS=VSS
Xcopt_h_inst_5078 dl02d1 $PINS I=psum_in[11] Z=copt_net_2245 VDD=VDD VSS=VSS
Xcopt_h_inst_5080 dl01d1 $PINS I=psum_in[7] Z=copt_net_2247 VDD=VDD VSS=VSS
Xcopt_h_inst_5087 dl02d1 $PINS I=aps_rename_110_ Z=c_out[42] VDD=VDD VSS=VSS
Xcopt_h_inst_5088 dl02d1 $PINS I=aps_rename_133_ Z=c_out[10] VDD=VDD VSS=VSS
Xcopt_h_inst_5090 dl01d1 $PINS I=aps_rename_127_ Z=c_out[18] VDD=VDD VSS=VSS
Xcopt_h_inst_5091 dl02d1 $PINS I=c_out[90] Z=copt_net_2258 VDD=VDD VSS=VSS
Xcopt_h_inst_5093 dl02d1 $PINS I=aps_rename_131_ Z=c_out[12] VDD=VDD VSS=VSS
Xcopt_h_inst_5094 dl01d1 $PINS I=aps_rename_126_ Z=c_out[19] VDD=VDD VSS=VSS
Xcopt_h_inst_5095 dl01d1 $PINS I=aps_rename_98_ Z=c_out[67] VDD=VDD VSS=VSS
Xcopt_h_inst_5096 dl01d1 $PINS I=aps_rename_81_ Z=c_out[88] VDD=VDD VSS=VSS
Xcopt_h_inst_5098 dl01d1 $PINS I=aps_rename_99_ Z=c_out[64] VDD=VDD VSS=VSS
Xcopt_h_inst_5099 dl02d1 $PINS I=aps_rename_101_ Z=c_out[62] VDD=VDD VSS=VSS
Xcopt_h_inst_5100 dl02d1 $PINS I=c_out[16] Z=copt_net_2267 VDD=VDD VSS=VSS
Xcopt_h_inst_5103 dl02d1 $PINS I=aps_rename_108_ Z=c_out[46] VDD=VDD VSS=VSS
Xcopt_h_inst_5104 dl01d1 $PINS I=aps_rename_104_ Z=c_out[58] VDD=VDD VSS=VSS
Xcopt_h_inst_5106 dl02d1 $PINS I=aps_rename_86_ Z=c_out[83] VDD=VDD VSS=VSS
Xcopt_h_inst_5108 dl02d1 $PINS I=aps_rename_135_ Z=c_out[7] VDD=VDD VSS=VSS
Xcopt_h_inst_5110 dl02d1 $PINS I=aps_rename_112_ Z=c_out[40] VDD=VDD VSS=VSS
Xcopt_h_inst_5114 dl01d1 $PINS I=aps_rename_93_ Z=c_out[75] VDD=VDD VSS=VSS
Xcopt_h_inst_5118 dl02d1 $PINS I=c_out[73] Z=copt_net_2285 VDD=VDD VSS=VSS
Xcopt_h_inst_5120 dl02d1 $PINS I=c_out[65] Z=copt_net_2287 VDD=VDD VSS=VSS
Xcopt_h_inst_5122 dl02d1 $PINS I=aps_rename_122_ Z=c_out[26] VDD=VDD VSS=VSS
Xcopt_h_inst_5123 dl02d1 $PINS I=aps_rename_115_ Z=c_out[36] VDD=VDD VSS=VSS
Xcopt_h_inst_5124 dl02d1 $PINS I=aps_rename_92_ Z=c_out[77] VDD=VDD VSS=VSS
Xcopt_h_inst_5125 dl02d1 $PINS I=c_out[5] Z=copt_net_2292 VDD=VDD VSS=VSS
Xcopt_h_inst_5130 dl02d1 $PINS I=c_out[91] Z=copt_net_2297 VDD=VDD VSS=VSS
Xcopt_h_inst_5132 dl02d1 $PINS I=aps_rename_134_ Z=c_out[9] VDD=VDD VSS=VSS
Xcopt_h_inst_5135 dl02d1 $PINS I=aps_rename_97_ Z=c_out[68] VDD=VDD VSS=VSS
Xcopt_h_inst_5137 dl02d1 $PINS I=aps_rename_88_ Z=c_out[81] VDD=VDD VSS=VSS
Xcopt_h_inst_5138 dl02d1 $PINS I=c_out[34] Z=copt_net_2305 VDD=VDD VSS=VSS
Xcopt_h_inst_5140 dl02d1 $PINS I=aps_rename_83_ Z=c_out[86] VDD=VDD VSS=VSS
Xcopt_h_inst_5145 dl02d1 $PINS I=aps_rename_120_ Z=c_out[29] VDD=VDD VSS=VSS
Xcopt_h_inst_5147 dl01d1 $PINS I=c_out[94] Z=copt_net_2314 VDD=VDD VSS=VSS
Xcopt_h_inst_5148 dl01d1 $PINS I=aps_rename_96_ Z=c_out[69] VDD=VDD VSS=VSS
Xcopt_h_inst_5150 dl02d1 $PINS I=aps_rename_91_ Z=c_out[78] VDD=VDD VSS=VSS
Xcopt_h_inst_5152 dl02d1 $PINS I=aps_rename_100_ Z=c_out[63] VDD=VDD VSS=VSS
Xcopt_h_inst_5154 dl02d1 $PINS I=c_out[56] Z=copt_net_2321 VDD=VDD VSS=VSS
Xcopt_h_inst_5157 dl02d1 $PINS I=c_out[76] Z=copt_net_2324 VDD=VDD VSS=VSS
Xcopt_h_inst_5158 dl02d1 $PINS I=aps_rename_107_ Z=c_out[47] VDD=VDD VSS=VSS
Xcopt_h_inst_5159 dl02d1 $PINS I=aps_rename_87_ Z=c_out[82] VDD=VDD VSS=VSS
Xcopt_h_inst_5163 dl02d1 $PINS I=aps_rename_109_ Z=c_out[44] VDD=VDD VSS=VSS
Xcopt_h_inst_5166 dl02d1 $PINS I=c_out[72] Z=copt_net_2333 VDD=VDD VSS=VSS
Xcopt_h_inst_5170 dl02d1 $PINS I=c_out[51] Z=copt_net_2337 VDD=VDD VSS=VSS
Xcopt_h_inst_5173 dl01d1 $PINS I=aps_rename_78_ Z=c_out[95] VDD=VDD VSS=VSS
Xcopt_h_inst_5174 dl02d1 $PINS I=c_out[48] Z=copt_net_2341 VDD=VDD VSS=VSS
Xcopt_h_inst_5176 dl02d1 $PINS I=col1_q1[29] Z=copt_net_2343 VDD=VDD VSS=VSS
Xcopt_h_inst_5177 dl01d1 $PINS I=col1_q1[29] Z=copt_net_2344 VDD=VDD VSS=VSS
Xcopt_h_inst_5178 dl01d1 $PINS I=aps_rename_82_ Z=c_out[87] VDD=VDD VSS=VSS
Xcopt_h_inst_5182 dl02d1 $PINS I=col1_q1[9] Z=copt_net_2349 VDD=VDD VSS=VSS
Xcopt_h_inst_5184 dl02d1 $PINS I=col0_q2[27] Z=copt_net_2351 VDD=VDD VSS=VSS
Xcopt_h_inst_5187 dl02d1 $PINS I=col0_q2[14] Z=copt_net_2354 VDD=VDD VSS=VSS
Xcopt_h_inst_5192 dl02d1 $PINS I=col0_q1[15] Z=copt_net_2359 VDD=VDD VSS=VSS
Xcopt_h_inst_5193 dl02d1 $PINS I=n69 Z=copt_net_2360 VDD=VDD VSS=VSS
Xcopt_h_inst_5194 dl02d1 $PINS I=n66 Z=copt_net_2361 VDD=VDD VSS=VSS
Xcopt_h_inst_5214 dl02d1 $PINS I=col0_q1[18] Z=copt_net_2381 VDD=VDD VSS=VSS
Xcopt_h_inst_5218 dl02d1 $PINS I=aps_rename_79_ Z=c_out[92] VDD=VDD VSS=VSS
Xcopt_h_inst_5229 dl02d1 $PINS I=col0_q1[10] Z=copt_net_2396 VDD=VDD VSS=VSS
Xcopt_h_inst_5232 dl02d1 $PINS I=aps_rename_95_ Z=c_out[71] VDD=VDD VSS=VSS
Xcopt_h_inst_5235 dl02d1 $PINS I=col1_q1[3] Z=copt_net_2402 VDD=VDD VSS=VSS
Xcopt_h_inst_5236 dl01d1 $PINS I=col1_q1[3] Z=copt_net_2403 VDD=VDD VSS=VSS
Xcopt_h_inst_5238 dl02d1 $PINS I=c_out[55] Z=copt_net_2405 VDD=VDD VSS=VSS
Xcopt_h_inst_5252 dl02d1 $PINS I=aps_rename_89_ Z=c_out[80] VDD=VDD VSS=VSS
Xcopt_h_inst_5254 dl02d1 $PINS I=aps_rename_118_ Z=c_out[32] VDD=VDD VSS=VSS
Xcopt_h_inst_5255 dl02d1 $PINS I=aps_rename_94_ Z=c_out[74] VDD=VDD VSS=VSS
Xcopt_h_inst_5258 dl02d1 $PINS I=aps_rename_128_ Z=c_out[15] VDD=VDD VSS=VSS
Xcopt_h_inst_5261 dl02d1 $PINS I=aps_rename_90_ Z=c_out[79] VDD=VDD VSS=VSS
Xcopt_h_inst_5262 dl02d1 $PINS I=psum_in[6] Z=copt_net_2429 VDD=VDD VSS=VSS
Xcopt_h_inst_5267 dl02d1 $PINS I=aps_rename_84_ Z=c_out[85] VDD=VDD VSS=VSS
Xcopt_h_inst_5271 dl02d1 $PINS I=aps_rename_105_ Z=c_out[54] VDD=VDD VSS=VSS
Xcopt_h_inst_5274 dl02d1 $PINS I=aps_rename_106_ Z=c_out[53] VDD=VDD VSS=VSS
Xcopt_h_inst_5285 dl01d1 $PINS I=aps_rename_103_ Z=c_out[59] VDD=VDD VSS=VSS
Xcopt_h_inst_5289 dl02d1 $PINS I=col0_q2[8] Z=copt_net_2456 VDD=VDD VSS=VSS
Xcopt_h_inst_5290 dl02d1 $PINS I=col0_q1[11] Z=copt_net_2457 VDD=VDD VSS=VSS
Xcopt_h_inst_5292 dl02d1 $PINS I=col0_q2[28] Z=copt_net_2459 VDD=VDD VSS=VSS
Xcopt_h_inst_5297 dl02d1 $PINS I=col1_q1[11] Z=copt_net_2464 VDD=VDD VSS=VSS
Xcopt_h_inst_5298 dl01d1 $PINS I=psum_in[46] Z=copt_net_2465 VDD=VDD VSS=VSS
Xcopt_h_inst_5304 dl02d1 $PINS I=col0_q1[12] Z=copt_net_2471 VDD=VDD VSS=VSS
Xcopt_h_inst_5305 dl01d1 $PINS I=col0_q1[12] Z=copt_net_2472 VDD=VDD VSS=VSS
Xcopt_h_inst_5306 dl02d1 $PINS I=col1_q1[13] Z=copt_net_2473 VDD=VDD VSS=VSS
Xcopt_h_inst_5309 dl02d1 $PINS I=aps_rename_114_ Z=c_out[37] VDD=VDD VSS=VSS
Xcopt_h_inst_5310 dl01d1 $PINS I=psum_in[20] Z=copt_net_2477 VDD=VDD VSS=VSS
Xcopt_h_inst_5314 dl02d1 $PINS I=aps_rename_139_ Z=c_out[0] VDD=VDD VSS=VSS
Xcopt_h_inst_5316 dl01d1 $PINS I=psum_in[58] Z=copt_net_2483 VDD=VDD VSS=VSS
Xcopt_h_inst_5317 dl02d1 $PINS I=aps_rename_117_ Z=c_out[33] VDD=VDD VSS=VSS
Xcopt_h_inst_5319 dl01d1 $PINS I=aps_rename_102_ Z=c_out[60] VDD=VDD VSS=VSS
Xcopt_h_inst_5321 dl02d1 $PINS I=col1_q1[18] Z=copt_net_2488 VDD=VDD VSS=VSS
Xcopt_h_inst_5326 dl01d1 $PINS I=psum_in[8] Z=copt_net_2493 VDD=VDD VSS=VSS
Xcopt_h_inst_5327 dl01d1 $PINS I=col0_q2[13] Z=copt_net_2494 VDD=VDD VSS=VSS
Xcopt_h_inst_5329 dl01d1 $PINS I=psum_in[27] Z=copt_net_2496 VDD=VDD VSS=VSS
Xcopt_h_inst_5330 dl01d1 $PINS I=psum_in[26] Z=copt_net_2497 VDD=VDD VSS=VSS
Xcopt_h_inst_5336 dl02d1 $PINS I=c_out[66] Z=copt_net_2503 VDD=VDD VSS=VSS
Xcopt_h_inst_5342 dl01d1 $PINS I=psum_in[21] Z=copt_net_2509 VDD=VDD VSS=VSS
Xcopt_h_inst_5344 dl01d1 $PINS I=psum_in[38] Z=copt_net_2511 VDD=VDD VSS=VSS
Xcopt_h_inst_5348 dl01d1 $PINS I=aps_rename_124_ Z=c_out[23] VDD=VDD VSS=VSS
Xcopt_h_inst_5350 dl01d1 $PINS I=psum_in[22] Z=copt_net_2517 VDD=VDD VSS=VSS
Xcopt_h_inst_5351 dl01d1 $PINS I=psum_in[25] Z=copt_net_2518 VDD=VDD VSS=VSS
Xcopt_h_inst_5354 dl01d1 $PINS I=psum_in[57] Z=copt_net_2521 VDD=VDD VSS=VSS
Xcopt_h_inst_5356 dl01d1 $PINS I=psum_in[14] Z=copt_net_2523 VDD=VDD VSS=VSS
Xcopt_h_inst_5357 dl01d1 $PINS I=c_out[30] Z=copt_net_2524 VDD=VDD VSS=VSS
Xcopt_h_inst_5362 dl01d1 $PINS I=psum_in[16] Z=copt_net_2529 VDD=VDD VSS=VSS
Xcopt_h_inst_5366 dl01d1 $PINS I=psum_in[42] Z=copt_net_2533 VDD=VDD VSS=VSS
Xcopt_h_inst_5372 dl01d1 $PINS I=c_out[70] Z=copt_net_2539 VDD=VDD VSS=VSS
Xcopt_h_inst_5374 dl01d1 $PINS I=aps_rename_123_ Z=c_out[25] VDD=VDD VSS=VSS
Xcopt_h_inst_5375 dl01d1 $PINS I=psum_in[52] Z=copt_net_2542 VDD=VDD VSS=VSS
Xcopt_h_inst_5386 dl01d1 $PINS I=psum_in[5] Z=copt_net_2553 VDD=VDD VSS=VSS
Xcopt_h_inst_5390 dl02d1 $PINS I=col0_q2[24] Z=copt_net_2557 VDD=VDD VSS=VSS
Xcopt_h_inst_5409 dl01d1 $PINS I=psum_in[2] Z=copt_net_2576 VDD=VDD VSS=VSS
Xcopt_h_inst_5417 dl01d1 $PINS I=aps_rename_136_ Z=c_out[6] VDD=VDD VSS=VSS
Xcopt_h_inst_5419 dl01d1 $PINS I=psum_in[4] Z=copt_net_2586 VDD=VDD VSS=VSS
Xcopt_h_inst_5422 dl02d1 $PINS I=c_out[17] Z=copt_net_2589 VDD=VDD VSS=VSS
Xcopt_h_inst_5425 dl02d1 $PINS I=c_out[20] Z=copt_net_2592 VDD=VDD VSS=VSS
Xcopt_h_inst_5438 dl01d1 $PINS I=psum_in[39] Z=copt_net_2605 VDD=VDD VSS=VSS
Xcopt_h_inst_5439 dl01d1 $PINS I=psum_in[54] Z=copt_net_2606 VDD=VDD VSS=VSS
Xcopt_h_inst_5451 dl01d1 $PINS I=psum_in[53] Z=copt_net_2618 VDD=VDD VSS=VSS
Xcopt_h_inst_5455 dl01d1 $PINS I=psum_in[56] Z=copt_net_2622 VDD=VDD VSS=VSS
Xcopt_h_inst_5458 dl02d1 $PINS I=c_out[2] Z=copt_net_2625 VDD=VDD VSS=VSS
Xcopt_h_inst_5473 dl01d1 $PINS I=c_out[93] Z=copt_net_2640 VDD=VDD VSS=VSS
Xcopt_h_inst_5476 dl01d1 $PINS I=psum_in[62] Z=copt_net_2643 VDD=VDD VSS=VSS
Xcopt_h_inst_5477 dl02d1 $PINS I=aps_rename_85_ Z=c_out[84] VDD=VDD VSS=VSS
Xcopt_h_inst_5480 dl01d1 $PINS I=aps_rename_125_ Z=c_out[22] VDD=VDD VSS=VSS
Xcopt_h_inst_5487 buffd1 $PINS I=aps_rename_138_ Z=c_out[1] VDD=VDD VSS=VSS
Xcopt_h_inst_5489 dl02d1 $PINS I=aps_rename_119_ Z=c_out[31] VDD=VDD VSS=VSS
Xcopt_h_inst_5495 dl01d1 $PINS I=psum_in[51] Z=copt_net_2662 VDD=VDD VSS=VSS
Xcopt_h_inst_5500 dl01d1 $PINS I=psum_in[37] Z=copt_net_2667 VDD=VDD VSS=VSS
Xcopt_h_inst_5502 dl01d1 $PINS I=aps_rename_137_ Z=c_out[4] VDD=VDD VSS=VSS
Xcopt_h_inst_5503 dl02d1 $PINS I=psum_in[1] Z=copt_net_2670 VDD=VDD VSS=VSS
Xcopt_h_inst_5504 dl01d1 $PINS I=psum_in[44] Z=copt_net_2671 VDD=VDD VSS=VSS
Xcopt_h_inst_5512 dl01d1 $PINS I=psum_in[47] Z=copt_net_2679 VDD=VDD VSS=VSS
Xcopt_h_inst_5515 dl01d1 $PINS I=psum_in[9] Z=copt_net_2682 VDD=VDD VSS=VSS
Xcopt_h_inst_5518 dl01d1 $PINS I=psum_in[19] Z=copt_net_2685 VDD=VDD VSS=VSS
Xcopt_h_inst_5520 dl01d1 $PINS I=psum_in[36] Z=copt_net_2687 VDD=VDD VSS=VSS
Xcopt_h_inst_5522 dl01d1 $PINS I=psum_in[40] Z=copt_net_2689 VDD=VDD VSS=VSS
Xcopt_h_inst_5523 dl02d1 $PINS I=c_out[21] Z=copt_net_2690 VDD=VDD VSS=VSS
Xcopt_h_inst_5527 dl02d1 $PINS I=psum_in[28] Z=copt_net_2694 VDD=VDD VSS=VSS
Xcopt_h_inst_5528 dl02d1 $PINS I=psum_in[29] Z=copt_net_2695 VDD=VDD VSS=VSS
Xcopt_h_inst_5530 buffd1 $PINS I=col1_q1[17] Z=copt_net_2697 VDD=VDD VSS=VSS
Xcopt_h_inst_5540 buffd1 $PINS I=psum_in[48] Z=copt_net_2707 VDD=VDD VSS=VSS
Xcopt_h_inst_5545 buffd1 $PINS I=psum_in[55] Z=copt_net_2712 VDD=VDD VSS=VSS
Xcopt_h_inst_5546 dl02d1 $PINS I=c_out[3] Z=copt_net_2713 VDD=VDD VSS=VSS
Xcopt_h_inst_5555 dl01d1 $PINS I=psum_in[63] Z=copt_net_2722 VDD=VDD VSS=VSS
Xcopt_h_inst_5558 dl02d1 $PINS I=col0_q1[24] Z=copt_net_2725 VDD=VDD VSS=VSS
Xcopt_h_inst_5571 dl02d1 $PINS I=n153 Z=copt_net_2738 VDD=VDD VSS=VSS
Xcopt_h_inst_5575 dl02d1 $PINS I=n83 Z=copt_net_2742 VDD=VDD VSS=VSS
Xcopt_h_inst_5578 dl02d1 $PINS I=n193 Z=copt_net_2745 VDD=VDD VSS=VSS
Xcopt_h_inst_5579 dl02d1 $PINS I=n103 Z=copt_net_2746 VDD=VDD VSS=VSS
Xcopt_h_inst_5603 dl01d1 $PINS I=col0_q1[0] Z=copt_net_2770 VDD=VDD VSS=VSS
Xcopt_h_inst_5632 dl01d1 $PINS I=psum_in[45] Z=copt_net_2799 VDD=VDD VSS=VSS
Xcopt_h_inst_5633 dl01d1 $PINS I=psum_in[43] Z=copt_net_2800 VDD=VDD VSS=VSS
Xcopt_h_inst_5653 dl02d1 $PINS I=n29 Z=copt_net_2819 VDD=VDD VSS=VSS
Xcopt_h_inst_5654 dl02d1 $PINS I=n37 Z=copt_net_2820 VDD=VDD VSS=VSS
Xcopt_h_inst_5655 dl02d1 $PINS I=n99 Z=copt_net_2821 VDD=VDD VSS=VSS
Xcopt_h_inst_5660 dl02d1 $PINS I=c_out[39] Z=copt_net_2826 VDD=VDD VSS=VSS
Xcopt_h_inst_5686 dl02d1 $PINS I=n24 Z=copt_net_2852 VDD=VDD VSS=VSS
Xcopt_h_inst_5687 dl02d1 $PINS I=n65 Z=copt_net_2853 VDD=VDD VSS=VSS
Xcopt_h_inst_5709 dl02d1 $PINS I=n43 Z=copt_net_2875 VDD=VDD VSS=VSS
Xcopt_h_inst_5710 dl02d1 $PINS I=n101 Z=copt_net_2876 VDD=VDD VSS=VSS
Xcopt_h_inst_5721 dl01d1 $PINS I=n138 Z=copt_net_2887 VDD=VDD VSS=VSS
Xcopt_h_inst_5722 dl01d1 $PINS I=n191 Z=copt_net_2888 VDD=VDD VSS=VSS
Xcopt_h_inst_5724 dl01d1 $PINS I=n97 Z=copt_net_2890 VDD=VDD VSS=VSS
Xcopt_h_inst_5733 dl01d1 $PINS I=n192 Z=copt_net_2899 VDD=VDD VSS=VSS
Xcopt_h_inst_5734 dl01d1 $PINS I=n4 Z=copt_net_2900 VDD=VDD VSS=VSS
Xcopt_h_inst_5736 dl01d1 $PINS I=n48 Z=copt_net_2902 VDD=VDD VSS=VSS
Xcopt_h_inst_5737 buffd1 $PINS I=n73 Z=copt_net_2903 VDD=VDD VSS=VSS
Xcopt_h_inst_5738 buffd1 $PINS I=n62 Z=copt_net_2904 VDD=VDD VSS=VSS
Xcopt_h_inst_5741 buffd1 $PINS I=n9 Z=copt_net_2907 VDD=VDD VSS=VSS
Xcopt_h_inst_5746 buffd1 $PINS I=n95 Z=copt_net_2912 VDD=VDD VSS=VSS
Xcopt_h_inst_5747 buffd1 $PINS I=n14 Z=copt_net_2913 VDD=VDD VSS=VSS
Xcopt_h_inst_5748 buffd1 $PINS I=n53 Z=copt_net_2914 VDD=VDD VSS=VSS
Xcopt_h_inst_5751 buffd1 $PINS I=n85 Z=copt_net_2917 VDD=VDD VSS=VSS
Xcopt_h_inst_5752 buffd1 $PINS I=n129 Z=copt_net_2918 VDD=VDD VSS=VSS
Xcopt_h_inst_5753 buffd1 $PINS I=n63 Z=copt_net_2919 VDD=VDD VSS=VSS
Xcopt_h_inst_5755 buffd1 $PINS I=n40 Z=copt_net_2921 VDD=VDD VSS=VSS
Xcopt_h_inst_5756 buffd1 $PINS I=n17 Z=copt_net_2922 VDD=VDD VSS=VSS
Xcopt_h_inst_5757 buffd1 $PINS I=n67 Z=copt_net_2923 VDD=VDD VSS=VSS
Xcopt_h_inst_5759 buffd1 $PINS I=n61 Z=copt_net_2925 VDD=VDD VSS=VSS
Xcopt_h_inst_5760 buffd1 $PINS I=n15 Z=copt_net_2926 VDD=VDD VSS=VSS
Xcopt_h_inst_5761 buffd1 $PINS I=n41 Z=copt_net_2927 VDD=VDD VSS=VSS
Xcopt_h_inst_5762 buffd1 $PINS I=n5 Z=copt_net_2928 VDD=VDD VSS=VSS
Xcopt_h_inst_5763 buffd1 $PINS I=n128 Z=copt_net_2929 VDD=VDD VSS=VSS
Xcopt_h_inst_5764 buffd1 $PINS I=n52 Z=copt_net_2930 VDD=VDD VSS=VSS
Xcopt_h_inst_5765 buffd1 $PINS I=n10 Z=copt_net_2931 VDD=VDD VSS=VSS
Xcopt_h_inst_5766 buffd1 $PINS I=n34 Z=copt_net_2932 VDD=VDD VSS=VSS
Xcopt_h_inst_5768 buffd1 $PINS I=n49 Z=copt_net_2934 VDD=VDD VSS=VSS
Xcopt_h_inst_5769 buffd1 $PINS I=n21 Z=copt_net_2935 VDD=VDD VSS=VSS
Xcopt_h_inst_5771 buffd1 $PINS I=n46 Z=copt_net_2937 VDD=VDD VSS=VSS
Xcopt_h_inst_5772 buffd1 $PINS I=n11 Z=copt_net_2938 VDD=VDD VSS=VSS
.ENDS

.SUBCKT unpu_pe_0_DW_mult_tc_0 a[7] a[6] a[5] a[4] a[3] a[2] a[1] a[0] b[7]
+ b[6] b[5] b[4] b[3] b[2] b[1] b[0] product[15] product[14] product[13]
+ product[12] product[11] product[10] product[9] product[8] product[7]
+ product[6] product[5] product[4] product[3] product[2] product[1] product[0]
+ VDD VSS
XU2 ad01d0 $PINS A=n196 B=n61 CI=n2 CO=n1 S=product[14] VDD=VDD VSS=VSS
XU3 ad01d0 $PINS A=n17 B=n16 CI=n3 CO=n2 S=product[13] VDD=VDD VSS=VSS
XU4 ad01d0 $PINS A=n18 B=n19 CI=n4 CO=n3 S=product[12] VDD=VDD VSS=VSS
XU5 ad01d0 $PINS A=n20 B=n23 CI=n5 CO=n4 S=product[11] VDD=VDD VSS=VSS
XU6 ad01d0 $PINS A=n27 B=n24 CI=n6 CO=n5 S=product[10] VDD=VDD VSS=VSS
XU7 ad01d0 $PINS A=n33 B=n28 CI=n7 CO=n6 S=product[9] VDD=VDD VSS=VSS
XU8 ad01d0 $PINS A=n39 B=n34 CI=n8 CO=n7 S=product[8] VDD=VDD VSS=VSS
XU9 ad01d0 $PINS A=n45 B=n40 CI=n9 CO=n8 S=product[7] VDD=VDD VSS=VSS
XU10 ad01d0 $PINS A=n49 B=n46 CI=n10 CO=n9 S=product[6] VDD=VDD VSS=VSS
XU11 ad01d0 $PINS A=n53 B=n50 CI=n11 CO=n10 S=product[5] VDD=VDD VSS=VSS
XU12 ad01d0 $PINS A=n55 B=n54 CI=n12 CO=n11 S=product[4] VDD=VDD VSS=VSS
XU13 ad01d0 $PINS A=n59 B=n56 CI=n13 CO=n12 S=product[3] VDD=VDD VSS=VSS
XU14 ad01d0 $PINS A=n84 B=n91 CI=n14 CO=n13 S=product[2] VDD=VDD VSS=VSS
XctmTdsLR_1_3020 an02d1 $PINS A1=n90 A2=n83 Z=n55 VDD=VDD VSS=VSS
XU17 ad01d0 $PINS A=n195 B=n62 CI=n69 CO=n17 S=n18 VDD=VDD VSS=VSS
XU18 ad01d0 $PINS A=n63 B=n25 CI=n22 CO=n19 S=n20 VDD=VDD VSS=VSS
XU20 ad01d0 $PINS A=n64 B=n26 CI=n29 CO=n23 S=n24 VDD=VDD VSS=VSS
XU21 ad01d0 $PINS A=n194 B=n70 CI=n77 CO=n25 S=n26 VDD=VDD VSS=VSS
XU22 ad01d0 $PINS A=n32 B=n35 CI=n30 CO=n27 S=n28 VDD=VDD VSS=VSS
XU23 ad01d0 $PINS A=n71 B=n65 CI=n37 CO=n29 S=n30 VDD=VDD VSS=VSS
XU25 ad01d0 $PINS A=n38 B=n41 CI=n36 CO=n33 S=n34 VDD=VDD VSS=VSS
XU26 ad01d0 $PINS A=n72 B=n85 CI=n43 CO=n35 S=n36 VDD=VDD VSS=VSS
XU29 ad01d0 $PINS A=n44 B=n47 CI=n42 CO=n39 S=n40 VDD=VDD VSS=VSS
XU30 ad01d0 $PINS A=n86 B=n73 CI=n79 CO=n41 S=n42 VDD=VDD VSS=VSS
XctmTdsLR_1_3018 an02d1 $PINS A1=n60 A2=n92 Z=n14 VDD=VDD VSS=VSS
XU32 ad01d0 $PINS A=n74 B=n51 CI=n48 CO=n45 S=n46 VDD=VDD VSS=VSS
XU33 ad01d0 $PINS A=n68 B=n87 CI=n80 CO=n47 S=n48 VDD=VDD VSS=VSS
XU34 ad01d0 $PINS A=n88 B=n81 CI=n52 CO=n49 S=n50 VDD=VDD VSS=VSS
XctmTdsLR_2_3019 aoim21d1 $PINS B1=n92 B2=n60 A=n14 ZN=product[1] VDD=VDD
+ VSS=VSS
XU36 ad01d0 $PINS A=n76 B=n89 CI=n82 CO=n53 S=n54 VDD=VDD VSS=VSS
XU145 oai21d1 $PINS B1=n203 B2=n249 A=n222 ZN=n77 VDD=VDD VSS=VSS
XU146 oai21d1 $PINS B1=n201 B2=n250 A=n232 ZN=n69 VDD=VDD VSS=VSS
XU147 oai21d1 $PINS B1=n199 B2=n251 A=n242 ZN=n61 VDD=VDD VSS=VSS
XU148 inv0d0 $PINS I=n16 ZN=n196 VDD=VDD VSS=VSS
XU149 inv0d0 $PINS I=n223 ZN=n201 VDD=VDD VSS=VSS
XU150 inv0d0 $PINS I=n214 ZN=n203 VDD=VDD VSS=VSS
XU151 inv0d0 $PINS I=n233 ZN=n199 VDD=VDD VSS=VSS
XU152 inv0d0 $PINS I=n32 ZN=n194 VDD=VDD VSS=VSS
XU153 inv0d0 $PINS I=n22 ZN=n195 VDD=VDD VSS=VSS
XU154 nd02d1 $PINS A1=n214 A2=n249 ZN=n216 VDD=VDD VSS=VSS
XU155 xr02d1 $PINS A1=a[2] A2=n204 Z=n214 VDD=VDD VSS=VSS
XU156 inv0d1 $PINS I=a[1] ZN=n204 VDD=VDD VSS=VSS
XU157 nd02d1 $PINS A1=n223 A2=n250 ZN=n225 VDD=VDD VSS=VSS
XU158 xr02d1 $PINS A1=a[4] A2=n202 Z=n223 VDD=VDD VSS=VSS
XU159 inv0d1 $PINS I=a[3] ZN=n202 VDD=VDD VSS=VSS
XU160 nd02d1 $PINS A1=a[1] A2=a[0] ZN=n206 VDD=VDD VSS=VSS
XU162 inv0d0 $PINS I=b[0] ZN=n197 VDD=VDD VSS=VSS
XU163 xr02d1 $PINS A1=a[6] A2=n200 Z=n233 VDD=VDD VSS=VSS
XU164 inv0d1 $PINS I=a[5] ZN=n200 VDD=VDD VSS=VSS
XU165 nd02d1 $PINS A1=n233 A2=n251 ZN=n235 VDD=VDD VSS=VSS
XU166 inv0d1 $PINS I=a[7] ZN=n198 VDD=VDD VSS=VSS
XU167 inv0d0 $PINS I=n1 ZN=product[15] VDD=VDD VSS=VSS
XU168 nr02d0 $PINS A1=a[0] A2=n197 ZN=product[0] VDD=VDD VSS=VSS
XU169 oai22d1 $PINS A1=b[0] A2=n206 B1=n207 B2=a[0] ZN=n92 VDD=VDD VSS=VSS
XU170 oai22d1 $PINS A1=n207 A2=n206 B1=n208 B2=a[0] ZN=n91 VDD=VDD VSS=VSS
XU171 xr02d1 $PINS A1=b[1] A2=n204 Z=n207 VDD=VDD VSS=VSS
XU172 oai22d1 $PINS A1=n208 A2=n206 B1=n209 B2=a[0] ZN=n90 VDD=VDD VSS=VSS
XU173 xr02d1 $PINS A1=b[2] A2=n204 Z=n208 VDD=VDD VSS=VSS
XU174 oai22d1 $PINS A1=n209 A2=n206 B1=n210 B2=a[0] ZN=n89 VDD=VDD VSS=VSS
XU175 xr02d1 $PINS A1=b[3] A2=n204 Z=n209 VDD=VDD VSS=VSS
XU176 oai22d1 $PINS A1=n210 A2=n206 B1=n211 B2=a[0] ZN=n88 VDD=VDD VSS=VSS
XU177 xr02d1 $PINS A1=b[4] A2=n204 Z=n210 VDD=VDD VSS=VSS
XU178 oai22d1 $PINS A1=n211 A2=n206 B1=n212 B2=a[0] ZN=n87 VDD=VDD VSS=VSS
XU179 xr02d1 $PINS A1=b[5] A2=n204 Z=n211 VDD=VDD VSS=VSS
XU180 oai22d1 $PINS A1=n212 A2=n206 B1=n213 B2=a[0] ZN=n86 VDD=VDD VSS=VSS
XU181 xr02d1 $PINS A1=b[6] A2=n204 Z=n212 VDD=VDD VSS=VSS
XU182 aor21d1 $PINS B1=a[0] B2=n206 A=n213 Z=n85 VDD=VDD VSS=VSS
XU183 xr02d1 $PINS A1=b[7] A2=n204 Z=n213 VDD=VDD VSS=VSS
XU184 nr02d0 $PINS A1=n214 A2=n197 ZN=n84 VDD=VDD VSS=VSS
XU185 oai22d1 $PINS A1=n216 A2=n215 B1=n214 B2=n217 ZN=n83 VDD=VDD VSS=VSS
XctmTdsLR_1_2897 an02d1 $PINS A1=n58 A2=n75 Z=n51 VDD=VDD VSS=VSS
XU187 oai22d1 $PINS A1=n217 A2=n216 B1=n214 B2=n218 ZN=n82 VDD=VDD VSS=VSS
XU188 xr02d1 $PINS A1=b[1] A2=n202 Z=n217 VDD=VDD VSS=VSS
XU189 oai22d1 $PINS A1=n218 A2=n216 B1=n214 B2=n219 ZN=n81 VDD=VDD VSS=VSS
XU190 xr02d1 $PINS A1=b[2] A2=n202 Z=n218 VDD=VDD VSS=VSS
XU191 oai22d1 $PINS A1=n219 A2=n216 B1=n214 B2=n220 ZN=n80 VDD=VDD VSS=VSS
XU192 xr02d1 $PINS A1=b[3] A2=n202 Z=n219 VDD=VDD VSS=VSS
XU193 oai22d1 $PINS A1=n220 A2=n216 B1=n214 B2=n221 ZN=n79 VDD=VDD VSS=VSS
XU194 xr02d1 $PINS A1=b[4] A2=n202 Z=n220 VDD=VDD VSS=VSS
XU195 nr02d0 $PINS A1=n223 A2=n197 ZN=n76 VDD=VDD VSS=VSS
XU196 oai22d1 $PINS A1=n225 A2=n224 B1=n223 B2=n226 ZN=n75 VDD=VDD VSS=VSS
XctmTdsLR_2_2898 aoim21d1 $PINS B1=n58 B2=n75 A=n51 ZN=n52 VDD=VDD VSS=VSS
XU198 oai22d1 $PINS A1=n226 A2=n225 B1=n223 B2=n227 ZN=n74 VDD=VDD VSS=VSS
XU199 xr02d1 $PINS A1=b[1] A2=n200 Z=n226 VDD=VDD VSS=VSS
XU200 oai22d1 $PINS A1=n227 A2=n225 B1=n223 B2=n228 ZN=n73 VDD=VDD VSS=VSS
XU201 xr02d1 $PINS A1=b[2] A2=n200 Z=n227 VDD=VDD VSS=VSS
XU202 oai22d1 $PINS A1=n228 A2=n225 B1=n223 B2=n229 ZN=n72 VDD=VDD VSS=VSS
XU203 xr02d1 $PINS A1=b[3] A2=n200 Z=n228 VDD=VDD VSS=VSS
XU204 oai22d1 $PINS A1=n229 A2=n225 B1=n223 B2=n230 ZN=n71 VDD=VDD VSS=VSS
XU205 xr02d1 $PINS A1=b[4] A2=n200 Z=n229 VDD=VDD VSS=VSS
XU206 oai22d1 $PINS A1=n230 A2=n225 B1=n223 B2=n231 ZN=n70 VDD=VDD VSS=VSS
XU207 xr02d1 $PINS A1=b[5] A2=n200 Z=n230 VDD=VDD VSS=VSS
XU208 nr02d0 $PINS A1=n233 A2=n197 ZN=n68 VDD=VDD VSS=VSS
XU209 oai22d1 $PINS A1=n235 A2=n234 B1=n233 B2=n236 ZN=n67 VDD=VDD VSS=VSS
XctmTdsLR_1_2899 an02d1 $PINS A1=n57 A2=n67 Z=n43 VDD=VDD VSS=VSS
XU211 oai22d1 $PINS A1=n237 A2=n235 B1=n233 B2=n238 ZN=n65 VDD=VDD VSS=VSS
XU212 oai22d1 $PINS A1=n238 A2=n235 B1=n233 B2=n239 ZN=n64 VDD=VDD VSS=VSS
XU213 xr02d1 $PINS A1=b[3] A2=n198 Z=n238 VDD=VDD VSS=VSS
XU214 oai22d1 $PINS A1=n239 A2=n235 B1=n233 B2=n240 ZN=n63 VDD=VDD VSS=VSS
XU215 xr02d1 $PINS A1=b[4] A2=n198 Z=n239 VDD=VDD VSS=VSS
XU216 oai22d1 $PINS A1=n240 A2=n235 B1=n233 B2=n241 ZN=n62 VDD=VDD VSS=VSS
XU217 xr02d1 $PINS A1=b[5] A2=n198 Z=n240 VDD=VDD VSS=VSS
XU218 oai21d1 $PINS B1=b[0] B2=n204 A=n206 ZN=n60 VDD=VDD VSS=VSS
XU219 oai21d1 $PINS B1=n202 B2=n216 A=n243 ZN=n59 VDD=VDD VSS=VSS
XU220 nd03d0 $PINS A1=n203 A2=n197 A3=a[3] ZN=n243 VDD=VDD VSS=VSS
XU221 oai21d1 $PINS B1=n225 B2=n200 A=n244 ZN=n58 VDD=VDD VSS=VSS
XU222 nd03d0 $PINS A1=n201 A2=n197 A3=a[5] ZN=n244 VDD=VDD VSS=VSS
XU223 oai21d1 $PINS B1=n235 B2=n198 A=n245 ZN=n57 VDD=VDD VSS=VSS
XU224 nd03d0 $PINS A1=n199 A2=n197 A3=a[7] ZN=n245 VDD=VDD VSS=VSS
XU225 xn02d1 $PINS A1=n246 A2=n247 ZN=n38 VDD=VDD VSS=VSS
XU226 or02d0 $PINS A1=n247 A2=n246 Z=n37 VDD=VDD VSS=VSS
XU227 oai22d1 $PINS A1=n236 A2=n235 B1=n233 B2=n237 ZN=n246 VDD=VDD VSS=VSS
XU228 xr02d1 $PINS A1=b[2] A2=n198 Z=n237 VDD=VDD VSS=VSS
XU229 xr02d1 $PINS A1=b[1] A2=n198 Z=n236 VDD=VDD VSS=VSS
XU230 oai22d1 $PINS A1=n221 A2=n216 B1=n214 B2=n248 ZN=n247 VDD=VDD VSS=VSS
XU231 xr02d1 $PINS A1=b[5] A2=n202 Z=n221 VDD=VDD VSS=VSS
XU232 aoim22d1 $PINS A1=n203 A2=n222 B1=n248 B2=n216 Z=n32 VDD=VDD VSS=VSS
XU233 xr02d1 $PINS A1=a[3] A2=a[2] Z=n249 VDD=VDD VSS=VSS
XU234 xr02d1 $PINS A1=b[6] A2=n202 Z=n248 VDD=VDD VSS=VSS
XU235 xr02d1 $PINS A1=b[7] A2=a[3] Z=n222 VDD=VDD VSS=VSS
XU236 aoim22d1 $PINS A1=n201 A2=n232 B1=n231 B2=n225 Z=n22 VDD=VDD VSS=VSS
XU237 xr02d1 $PINS A1=a[5] A2=a[4] Z=n250 VDD=VDD VSS=VSS
XU238 xr02d1 $PINS A1=b[6] A2=n200 Z=n231 VDD=VDD VSS=VSS
XU239 xr02d1 $PINS A1=b[7] A2=a[5] Z=n232 VDD=VDD VSS=VSS
XU240 aoim22d1 $PINS A1=n199 A2=n242 B1=n241 B2=n235 Z=n16 VDD=VDD VSS=VSS
XU241 xr02d1 $PINS A1=a[7] A2=a[6] Z=n251 VDD=VDD VSS=VSS
XU242 xr02d1 $PINS A1=b[6] A2=n198 Z=n241 VDD=VDD VSS=VSS
XU243 xr02d1 $PINS A1=b[7] A2=a[7] Z=n242 VDD=VDD VSS=VSS
XctmTdsLR_1_1390 aoim22d1 $PINS A1=n202 A2=b[0] B1=n202 B2=b[0] Z=n215 VDD=VDD
+ VSS=VSS
XctmTdsLR_1_1391 aoim22d1 $PINS A1=n200 A2=b[0] B1=n200 B2=b[0] Z=n224 VDD=VDD
+ VSS=VSS
XctmTdsLR_1_1392 aoim22d1 $PINS A1=n198 A2=b[0] B1=n198 B2=b[0] Z=n234 VDD=VDD
+ VSS=VSS
XctmTdsLR_2_2900 aoim21d1 $PINS B1=n57 B2=n67 A=n43 ZN=n44 VDD=VDD VSS=VSS
XctmTdsLR_2_3021 aoim21d1 $PINS B1=n90 B2=n83 A=n55 ZN=n56 VDD=VDD VSS=VSS
.ENDS

.SUBCKT unpu_pe_0_DW_mult_uns_0_DW_mult_uns_1 a[7] a[6] a[5] a[4] a[3] a[2]
+ a[1] a[0] b[7] b[6] b[5] b[4] b[3] b[2] b[1] b[0] product[15] product[14]
+ product[13] product[12] product[11] product[10] product[9] product[8]
+ product[7] product[6] product[5] product[4] product[3] product[2] product[1]
+ product[0] VDD VSS
XU2 ad01d0 $PINS A=n99 B=n15 CI=n2 CO=product[15] S=product[14] VDD=VDD VSS=VSS
XU3 ad01d0 $PINS A=n16 B=n17 CI=n3 CO=n2 S=product[13] VDD=VDD VSS=VSS
XU4 ad01d0 $PINS A=n18 B=n21 CI=n4 CO=n3 S=product[12] VDD=VDD VSS=VSS
XU5 ad01d0 $PINS A=n27 B=n22 CI=n5 CO=n4 S=product[11] VDD=VDD VSS=VSS
XU6 ad01d0 $PINS A=n35 B=n28 CI=n6 CO=n5 S=product[10] VDD=VDD VSS=VSS
XU7 ad01d0 $PINS A=n45 B=n36 CI=n7 CO=n6 S=product[9] VDD=VDD VSS=VSS
XU8 ad01d0 $PINS A=n57 B=n46 CI=n8 CO=n7 S=product[8] VDD=VDD VSS=VSS
XU9 ad01d0 $PINS A=n69 B=n58 CI=n9 CO=n8 S=product[7] VDD=VDD VSS=VSS
XU10 ad01d0 $PINS A=n79 B=n70 CI=n10 CO=n9 S=product[6] VDD=VDD VSS=VSS
XU11 ad01d0 $PINS A=n87 B=n80 CI=n11 CO=n10 S=product[5] VDD=VDD VSS=VSS
XU12 ad01d0 $PINS A=n93 B=n88 CI=n12 CO=n11 S=product[4] VDD=VDD VSS=VSS
XU13 ad01d0 $PINS A=n96 B=n13 CI=n94 CO=n12 S=product[3] VDD=VDD VSS=VSS
XU14 ad01d0 $PINS A=n146 B=n14 CI=n98 CO=n13 S=product[2] VDD=VDD VSS=VSS
XU15 ah01d1 $PINS A=n161 B=n154 CO=n14 S=product[1] VDD=VDD VSS=VSS
XU16 ad01d0 $PINS A=n107 B=n100 CI=n19 CO=n15 S=n16 VDD=VDD VSS=VSS
XU17 ad01d0 $PINS A=n25 B=n20 CI=n23 CO=n17 S=n18 VDD=VDD VSS=VSS
XU18 ad01d0 $PINS A=n115 B=n101 CI=n108 CO=n19 S=n20 VDD=VDD VSS=VSS
XU19 ad01d0 $PINS A=n31 B=n24 CI=n29 CO=n21 S=n22 VDD=VDD VSS=VSS
XU20 ad01d0 $PINS A=n116 B=n33 CI=n26 CO=n23 S=n24 VDD=VDD VSS=VSS
XU21 ad01d0 $PINS A=n123 B=n102 CI=n109 CO=n25 S=n26 VDD=VDD VSS=VSS
XU22 ad01d0 $PINS A=n32 B=n37 CI=n30 CO=n27 S=n28 VDD=VDD VSS=VSS
XU23 ad01d0 $PINS A=n41 B=n34 CI=n39 CO=n29 S=n30 VDD=VDD VSS=VSS
XU24 ad01d0 $PINS A=n124 B=n117 CI=n43 CO=n31 S=n32 VDD=VDD VSS=VSS
XU25 ad01d0 $PINS A=n131 B=n103 CI=n110 CO=n33 S=n34 VDD=VDD VSS=VSS
XU26 ad01d0 $PINS A=n40 B=n47 CI=n38 CO=n35 S=n36 VDD=VDD VSS=VSS
XU27 ad01d0 $PINS A=n44 B=n51 CI=n49 CO=n37 S=n38 VDD=VDD VSS=VSS
XU28 ad01d0 $PINS A=n55 B=n53 CI=n42 CO=n39 S=n40 VDD=VDD VSS=VSS
XU29 ad01d0 $PINS A=n118 B=n125 CI=n132 CO=n41 S=n42 VDD=VDD VSS=VSS
XU30 ad01d0 $PINS A=n139 B=n104 CI=n111 CO=n43 S=n44 VDD=VDD VSS=VSS
XU31 ad01d0 $PINS A=n50 B=n59 CI=n48 CO=n45 S=n46 VDD=VDD VSS=VSS
XU32 ad01d0 $PINS A=n54 B=n52 CI=n61 CO=n47 S=n48 VDD=VDD VSS=VSS
XU33 ad01d0 $PINS A=n56 B=n65 CI=n63 CO=n49 S=n50 VDD=VDD VSS=VSS
XU34 ad01d0 $PINS A=n140 B=n133 CI=n67 CO=n51 S=n52 VDD=VDD VSS=VSS
XU35 ad01d0 $PINS A=n126 B=n119 CI=n147 CO=n53 S=n54 VDD=VDD VSS=VSS
XU36 ah01d1 $PINS A=n105 B=n112 CO=n55 S=n56 VDD=VDD VSS=VSS
XU37 ad01d0 $PINS A=n71 B=n62 CI=n60 CO=n57 S=n58 VDD=VDD VSS=VSS
XU38 ad01d0 $PINS A=n64 B=n66 CI=n73 CO=n59 S=n60 VDD=VDD VSS=VSS
XU39 ad01d0 $PINS A=n77 B=n68 CI=n75 CO=n61 S=n62 VDD=VDD VSS=VSS
XU40 ad01d0 $PINS A=n141 B=n127 CI=n134 CO=n63 S=n64 VDD=VDD VSS=VSS
XU41 ad01d0 $PINS A=n155 B=n120 CI=n148 CO=n65 S=n66 VDD=VDD VSS=VSS
XU42 ah01d1 $PINS A=n106 B=n113 CO=n67 S=n68 VDD=VDD VSS=VSS
XU43 ad01d0 $PINS A=n81 B=n74 CI=n72 CO=n69 S=n70 VDD=VDD VSS=VSS
XU44 ad01d0 $PINS A=n78 B=n83 CI=n76 CO=n71 S=n72 VDD=VDD VSS=VSS
XU45 ad01d0 $PINS A=n142 B=n135 CI=n85 CO=n73 S=n74 VDD=VDD VSS=VSS
XU46 ad01d0 $PINS A=n156 B=n128 CI=n149 CO=n75 S=n76 VDD=VDD VSS=VSS
XU47 ah01d1 $PINS A=n114 B=n121 CO=n77 S=n78 VDD=VDD VSS=VSS
XU48 ad01d0 $PINS A=n89 B=n84 CI=n82 CO=n79 S=n80 VDD=VDD VSS=VSS
XU49 ad01d0 $PINS A=n150 B=n91 CI=n86 CO=n81 S=n82 VDD=VDD VSS=VSS
XU50 ad01d0 $PINS A=n157 B=n136 CI=n143 CO=n83 S=n84 VDD=VDD VSS=VSS
XU51 ah01d1 $PINS A=n122 B=n129 CO=n85 S=n86 VDD=VDD VSS=VSS
XU52 ad01d0 $PINS A=n95 B=n92 CI=n90 CO=n87 S=n88 VDD=VDD VSS=VSS
XU53 ad01d0 $PINS A=n158 B=n144 CI=n151 CO=n89 S=n90 VDD=VDD VSS=VSS
XU54 ah01d1 $PINS A=n130 B=n137 CO=n91 S=n92 VDD=VDD VSS=VSS
XU55 ad01d0 $PINS A=n159 B=n152 CI=n97 CO=n93 S=n94 VDD=VDD VSS=VSS
XU56 ah01d1 $PINS A=n138 B=n145 CO=n95 S=n96 VDD=VDD VSS=VSS
XU57 ah01d1 $PINS A=n153 B=n160 CO=n97 S=n98 VDD=VDD VSS=VSS
XU140 inv0d0 $PINS I=b[4] ZN=n217 VDD=VDD VSS=VSS
XU141 inv0d0 $PINS I=a[1] ZN=n228 VDD=VDD VSS=VSS
XU142 inv0d0 $PINS I=b[2] ZN=n219 VDD=VDD VSS=VSS
XU144 inv0d0 $PINS I=a[2] ZN=n227 VDD=VDD VSS=VSS
XU145 inv0d0 $PINS I=b[3] ZN=n218 VDD=VDD VSS=VSS
XU146 inv0d0 $PINS I=a[5] ZN=n224 VDD=VDD VSS=VSS
XU147 inv0d0 $PINS I=b[1] ZN=n220 VDD=VDD VSS=VSS
XU148 inv0d0 $PINS I=b[0] ZN=n221 VDD=VDD VSS=VSS
XU149 inv0d0 $PINS I=a[4] ZN=n225 VDD=VDD VSS=VSS
XU150 inv0d0 $PINS I=b[6] ZN=n215 VDD=VDD VSS=VSS
XU151 inv0d0 $PINS I=a[3] ZN=n226 VDD=VDD VSS=VSS
XU152 inv0d0 $PINS I=b[5] ZN=n216 VDD=VDD VSS=VSS
XU153 inv0d0 $PINS I=b[7] ZN=n214 VDD=VDD VSS=VSS
XU154 inv0d0 $PINS I=a[6] ZN=n223 VDD=VDD VSS=VSS
XU155 inv0d0 $PINS I=a[7] ZN=n222 VDD=VDD VSS=VSS
XU156 nr02d0 $PINS A1=a[0] A2=n221 ZN=product[0] VDD=VDD VSS=VSS
XU157 nr02d0 $PINS A1=n222 A2=n214 ZN=n99 VDD=VDD VSS=VSS
XU158 nr02d0 $PINS A1=a[0] A2=n220 ZN=n161 VDD=VDD VSS=VSS
XU159 nr02d0 $PINS A1=a[0] A2=n219 ZN=n160 VDD=VDD VSS=VSS
XU160 nr02d0 $PINS A1=a[0] A2=n218 ZN=n159 VDD=VDD VSS=VSS
XU161 nr02d0 $PINS A1=a[0] A2=n217 ZN=n158 VDD=VDD VSS=VSS
XU162 nr02d0 $PINS A1=a[0] A2=n216 ZN=n157 VDD=VDD VSS=VSS
XU163 nr02d0 $PINS A1=a[0] A2=n215 ZN=n156 VDD=VDD VSS=VSS
XU164 nr02d0 $PINS A1=a[0] A2=n214 ZN=n155 VDD=VDD VSS=VSS
XU165 nr02d0 $PINS A1=n221 A2=n228 ZN=n154 VDD=VDD VSS=VSS
XU166 nr02d0 $PINS A1=n220 A2=n228 ZN=n153 VDD=VDD VSS=VSS
XU167 nr02d0 $PINS A1=n219 A2=n228 ZN=n152 VDD=VDD VSS=VSS
XU168 nr02d0 $PINS A1=n218 A2=n228 ZN=n151 VDD=VDD VSS=VSS
XU169 nr02d0 $PINS A1=n217 A2=n228 ZN=n150 VDD=VDD VSS=VSS
XU170 nr02d0 $PINS A1=n216 A2=n228 ZN=n149 VDD=VDD VSS=VSS
XU171 nr02d0 $PINS A1=n215 A2=n228 ZN=n148 VDD=VDD VSS=VSS
XU172 nr02d0 $PINS A1=n214 A2=n228 ZN=n147 VDD=VDD VSS=VSS
XU173 nr02d0 $PINS A1=n221 A2=n227 ZN=n146 VDD=VDD VSS=VSS
XU174 nr02d0 $PINS A1=n220 A2=n227 ZN=n145 VDD=VDD VSS=VSS
XU175 nr02d0 $PINS A1=n219 A2=n227 ZN=n144 VDD=VDD VSS=VSS
XU176 nr02d0 $PINS A1=n218 A2=n227 ZN=n143 VDD=VDD VSS=VSS
XU177 nr02d0 $PINS A1=n217 A2=n227 ZN=n142 VDD=VDD VSS=VSS
XU178 nr02d0 $PINS A1=n216 A2=n227 ZN=n141 VDD=VDD VSS=VSS
XU179 nr02d0 $PINS A1=n215 A2=n227 ZN=n140 VDD=VDD VSS=VSS
XU180 nr02d0 $PINS A1=n214 A2=n227 ZN=n139 VDD=VDD VSS=VSS
XU181 nr02d0 $PINS A1=n221 A2=n226 ZN=n138 VDD=VDD VSS=VSS
XU182 nr02d0 $PINS A1=n220 A2=n226 ZN=n137 VDD=VDD VSS=VSS
XU183 nr02d0 $PINS A1=n219 A2=n226 ZN=n136 VDD=VDD VSS=VSS
XU184 nr02d0 $PINS A1=n218 A2=n226 ZN=n135 VDD=VDD VSS=VSS
XU185 nr02d0 $PINS A1=n217 A2=n226 ZN=n134 VDD=VDD VSS=VSS
XU186 nr02d0 $PINS A1=n216 A2=n226 ZN=n133 VDD=VDD VSS=VSS
XU187 nr02d0 $PINS A1=n215 A2=n226 ZN=n132 VDD=VDD VSS=VSS
XU188 nr02d0 $PINS A1=n214 A2=n226 ZN=n131 VDD=VDD VSS=VSS
XU189 nr02d0 $PINS A1=n221 A2=n225 ZN=n130 VDD=VDD VSS=VSS
XU190 nr02d0 $PINS A1=n220 A2=n225 ZN=n129 VDD=VDD VSS=VSS
XU191 nr02d0 $PINS A1=n219 A2=n225 ZN=n128 VDD=VDD VSS=VSS
XU192 nr02d0 $PINS A1=n218 A2=n225 ZN=n127 VDD=VDD VSS=VSS
XU193 nr02d0 $PINS A1=n217 A2=n225 ZN=n126 VDD=VDD VSS=VSS
XU194 nr02d0 $PINS A1=n216 A2=n225 ZN=n125 VDD=VDD VSS=VSS
XU195 nr02d0 $PINS A1=n215 A2=n225 ZN=n124 VDD=VDD VSS=VSS
XU196 nr02d0 $PINS A1=n214 A2=n225 ZN=n123 VDD=VDD VSS=VSS
XU197 nr02d0 $PINS A1=n221 A2=n224 ZN=n122 VDD=VDD VSS=VSS
XU198 nr02d0 $PINS A1=n220 A2=n224 ZN=n121 VDD=VDD VSS=VSS
XU199 nr02d0 $PINS A1=n219 A2=n224 ZN=n120 VDD=VDD VSS=VSS
XU200 nr02d0 $PINS A1=n218 A2=n224 ZN=n119 VDD=VDD VSS=VSS
XU201 nr02d0 $PINS A1=n217 A2=n224 ZN=n118 VDD=VDD VSS=VSS
XU202 nr02d0 $PINS A1=n216 A2=n224 ZN=n117 VDD=VDD VSS=VSS
XU203 nr02d0 $PINS A1=n215 A2=n224 ZN=n116 VDD=VDD VSS=VSS
XU204 nr02d0 $PINS A1=n214 A2=n224 ZN=n115 VDD=VDD VSS=VSS
XU205 nr02d0 $PINS A1=n221 A2=n223 ZN=n114 VDD=VDD VSS=VSS
XU206 nr02d0 $PINS A1=n220 A2=n223 ZN=n113 VDD=VDD VSS=VSS
XU207 nr02d0 $PINS A1=n219 A2=n223 ZN=n112 VDD=VDD VSS=VSS
XU208 nr02d0 $PINS A1=n218 A2=n223 ZN=n111 VDD=VDD VSS=VSS
XU209 nr02d0 $PINS A1=n217 A2=n223 ZN=n110 VDD=VDD VSS=VSS
XU210 nr02d0 $PINS A1=n216 A2=n223 ZN=n109 VDD=VDD VSS=VSS
XU211 nr02d0 $PINS A1=n215 A2=n223 ZN=n108 VDD=VDD VSS=VSS
XU212 nr02d0 $PINS A1=n214 A2=n223 ZN=n107 VDD=VDD VSS=VSS
XU213 nr02d0 $PINS A1=n221 A2=n222 ZN=n106 VDD=VDD VSS=VSS
XU214 nr02d0 $PINS A1=n222 A2=n220 ZN=n105 VDD=VDD VSS=VSS
XU215 nr02d0 $PINS A1=n222 A2=n219 ZN=n104 VDD=VDD VSS=VSS
XU216 nr02d0 $PINS A1=n222 A2=n218 ZN=n103 VDD=VDD VSS=VSS
XU217 nr02d0 $PINS A1=n222 A2=n217 ZN=n102 VDD=VDD VSS=VSS
XU218 nr02d0 $PINS A1=n222 A2=n216 ZN=n101 VDD=VDD VSS=VSS
XU219 nr02d0 $PINS A1=n222 A2=n215 ZN=n100 VDD=VDD VSS=VSS
.ENDS

.SUBCKT unpu_pe_0_DW01_add_0_DW01_add_1 A[31] A[30] A[29] A[28] A[27] A[26]
+ A[25] A[24] A[23] A[22] A[21] A[20] A[19] A[18] A[17] A[16] A[15] A[14] A[13]
+ A[12] A[11] A[10] A[9] A[8] A[7] A[6] A[5] A[4] A[3] A[2] A[1] A[0] B[31]
+ B[30] B[29] B[28] B[27] B[26] B[25] B[24] B[23] B[22] B[21] B[20] B[19] B[18]
+ B[17] B[16] B[15] B[14] B[13] B[12] B[11] B[10] B[9] B[8] B[7] B[6] B[5] B[4]
+ B[3] B[2] B[1] B[0] CI SUM[31] SUM[30] SUM[29] SUM[28] SUM[27] SUM[26]
+ SUM[25] SUM[24] SUM[23] SUM[22] SUM[21] SUM[20] SUM[19] SUM[18] SUM[17]
+ SUM[16] SUM[15] SUM[14] SUM[13] SUM[12] SUM[11] SUM[10] SUM[9] SUM[8] SUM[7]
+ SUM[6] SUM[5] SUM[4] SUM[3] SUM[2] SUM[1] SUM[0] CO VDD VSS
XU1_31 ad01d0 $PINS A=copt_net_1613 B=B[31] CI=carry[31] S=SUM[31] VDD=VDD
+ VSS=VSS
XU1_30 ad01d0 $PINS A=copt_net_1592 B=B[30] CI=carry[30] CO=carry[31] S=SUM[30]
+ VDD=VDD VSS=VSS
XU1_29 ad01d0 $PINS A=copt_net_1126 B=B[29] CI=carry[29] CO=carry[30] S=SUM[29]
+ VDD=VDD VSS=VSS
XU1_28 ad01d0 $PINS A=copt_net_2578 B=B[28] CI=carry[28] CO=carry[29] S=SUM[28]
+ VDD=VDD VSS=VSS
XU1_27 ad01d0 $PINS A=copt_net_1630 B=B[27] CI=carry[27] CO=carry[28] S=SUM[27]
+ VDD=VDD VSS=VSS
XU1_26 ad01d0 $PINS A=copt_net_1500 B=B[26] CI=carry[26] CO=carry[27] S=SUM[26]
+ VDD=VDD VSS=VSS
XU1_25 ad01d0 $PINS A=copt_net_1643 B=B[25] CI=carry[25] CO=carry[26] S=SUM[25]
+ VDD=VDD VSS=VSS
XU1_24 ad01d1 $PINS A=copt_net_1519 B=B[24] CI=carry[24] CO=carry[25] S=SUM[24]
+ VDD=VDD VSS=VSS
XU1_23 ad01d0 $PINS A=copt_net_1617 B=B[23] CI=carry[23] CO=carry[24] S=SUM[23]
+ VDD=VDD VSS=VSS
XU1_22 ad01d0 $PINS A=copt_net_1628 B=B[22] CI=carry[22] CO=carry[23] S=SUM[22]
+ VDD=VDD VSS=VSS
XU1_21 ad01d0 $PINS A=copt_net_1536 B=B[21] CI=carry[21] CO=carry[22] S=SUM[21]
+ VDD=VDD VSS=VSS
XU1_20 ad01d0 $PINS A=copt_net_1568 B=B[20] CI=carry[20] CO=carry[21] S=SUM[20]
+ VDD=VDD VSS=VSS
XU1_19 ad01d0 $PINS A=copt_net_1659 B=B[19] CI=carry[19] CO=carry[20] S=SUM[19]
+ VDD=VDD VSS=VSS
XU1_18 ad01d0 $PINS A=copt_net_1556 B=B[18] CI=carry[18] CO=carry[19] S=SUM[18]
+ VDD=VDD VSS=VSS
XU1_17 ad01d0 $PINS A=copt_net_1544 B=B[17] CI=carry[17] CO=carry[18] S=SUM[17]
+ VDD=VDD VSS=VSS
XU1_16 ad01d0 $PINS A=copt_net_1462 B=B[16] CI=carry[16] CO=carry[17] S=SUM[16]
+ VDD=VDD VSS=VSS
XU1_15 ad01d0 $PINS A=copt_net_1490 B=B[15] CI=carry[15] CO=carry[16] S=SUM[15]
+ VDD=VDD VSS=VSS
XU1_14 ad01d0 $PINS A=copt_net_1654 B=B[14] CI=carry[14] CO=carry[15] S=SUM[14]
+ VDD=VDD VSS=VSS
XU1_13 ad01d0 $PINS A=copt_net_1527 B=B[13] CI=carry[13] CO=carry[14] S=SUM[13]
+ VDD=VDD VSS=VSS
XU1_12 ad01d0 $PINS A=copt_net_1534 B=B[12] CI=carry[12] CO=carry[13] S=SUM[12]
+ VDD=VDD VSS=VSS
XU1_11 ad01d0 $PINS A=copt_net_1621 B=B[11] CI=carry[11] CO=carry[12] S=SUM[11]
+ VDD=VDD VSS=VSS
XU1_10 ad01d0 $PINS A=copt_net_1614 B=B[10] CI=carry[10] CO=carry[11] S=SUM[10]
+ VDD=VDD VSS=VSS
XU1_9 ad01d0 $PINS A=copt_net_1576 B=B[9] CI=carry[9] CO=carry[10] S=SUM[9]
+ VDD=VDD VSS=VSS
XU1_8 ad01d0 $PINS A=copt_net_1607 B=B[8] CI=carry[8] CO=carry[9] S=SUM[8]
+ VDD=VDD VSS=VSS
XU1_7 ad01d0 $PINS A=copt_net_1627 B=B[7] CI=carry[7] CO=carry[8] S=SUM[7]
+ VDD=VDD VSS=VSS
XU1_6 ad01d0 $PINS A=copt_net_1528 B=B[6] CI=carry[6] CO=carry[7] S=SUM[6]
+ VDD=VDD VSS=VSS
XU1_5 ad01d0 $PINS A=copt_net_1129 B=B[5] CI=carry[5] CO=carry[6] S=SUM[5]
+ VDD=VDD VSS=VSS
XU1_4 ad01d0 $PINS A=copt_net_2531 B=B[4] CI=carry[4] CO=carry[5] S=SUM[4]
+ VDD=VDD VSS=VSS
XU1_3 ad01d0 $PINS A=copt_net_1060 B=B[3] CI=carry[3] CO=carry[4] S=SUM[3]
+ VDD=VDD VSS=VSS
XU1_2 ad01d0 $PINS A=copt_net_2212 B=B[2] CI=carry[2] CO=carry[3] S=SUM[2]
+ VDD=VDD VSS=VSS
XU1_1 ad01d0 $PINS A=copt_net_2120 B=B[1] CI=n1 CO=carry[2] S=SUM[1] VDD=VDD
+ VSS=VSS
XU1 an02d1 $PINS A1=B[0] A2=A[0] Z=n1 VDD=VDD VSS=VSS
XU2 xr02d1 $PINS A1=A[0] A2=B[0] Z=SUM[0] VDD=VDD VSS=VSS
Xcopt_h_inst_3892 dl02d1 $PINS I=A[3] Z=copt_net_1060 VDD=VDD VSS=VSS
Xcopt_h_inst_3958 dl01d1 $PINS I=A[29] Z=copt_net_1126 VDD=VDD VSS=VSS
Xcopt_h_inst_3961 dl01d1 $PINS I=A[5] Z=copt_net_1129 VDD=VDD VSS=VSS
Xcopt_h_inst_4294 dl01d1 $PINS I=A[16] Z=copt_net_1462 VDD=VDD VSS=VSS
Xcopt_h_inst_4322 dl01d1 $PINS I=A[15] Z=copt_net_1490 VDD=VDD VSS=VSS
Xcopt_h_inst_4332 dl02d1 $PINS I=A[26] Z=copt_net_1500 VDD=VDD VSS=VSS
Xcopt_h_inst_4351 dl02d1 $PINS I=A[24] Z=copt_net_1519 VDD=VDD VSS=VSS
Xcopt_h_inst_4359 dl02d1 $PINS I=A[13] Z=copt_net_1527 VDD=VDD VSS=VSS
Xcopt_h_inst_4360 dl01d1 $PINS I=A[6] Z=copt_net_1528 VDD=VDD VSS=VSS
Xcopt_h_inst_4366 dl01d1 $PINS I=A[12] Z=copt_net_1534 VDD=VDD VSS=VSS
Xcopt_h_inst_4368 dl02d1 $PINS I=A[21] Z=copt_net_1536 VDD=VDD VSS=VSS
Xcopt_h_inst_4376 dl01d1 $PINS I=A[17] Z=copt_net_1544 VDD=VDD VSS=VSS
Xcopt_h_inst_4388 dl02d1 $PINS I=A[18] Z=copt_net_1556 VDD=VDD VSS=VSS
Xcopt_h_inst_4400 dl02d1 $PINS I=A[20] Z=copt_net_1568 VDD=VDD VSS=VSS
Xcopt_h_inst_4408 dl01d1 $PINS I=A[9] Z=copt_net_1576 VDD=VDD VSS=VSS
Xcopt_h_inst_4424 dl01d1 $PINS I=A[30] Z=copt_net_1592 VDD=VDD VSS=VSS
Xcopt_h_inst_4439 dl02d1 $PINS I=A[8] Z=copt_net_1607 VDD=VDD VSS=VSS
Xcopt_h_inst_4445 dl02d1 $PINS I=A[31] Z=copt_net_1613 VDD=VDD VSS=VSS
Xcopt_h_inst_4446 dl01d1 $PINS I=A[10] Z=copt_net_1614 VDD=VDD VSS=VSS
Xcopt_h_inst_4449 dl01d1 $PINS I=A[23] Z=copt_net_1617 VDD=VDD VSS=VSS
Xcopt_h_inst_4453 dl01d1 $PINS I=A[11] Z=copt_net_1621 VDD=VDD VSS=VSS
Xcopt_h_inst_4459 dl01d1 $PINS I=A[7] Z=copt_net_1627 VDD=VDD VSS=VSS
Xcopt_h_inst_4460 dl01d1 $PINS I=A[22] Z=copt_net_1628 VDD=VDD VSS=VSS
Xcopt_h_inst_4462 dl01d1 $PINS I=A[27] Z=copt_net_1630 VDD=VDD VSS=VSS
Xcopt_h_inst_4475 dl02d1 $PINS I=A[25] Z=copt_net_1643 VDD=VDD VSS=VSS
Xcopt_h_inst_4486 dl01d1 $PINS I=A[14] Z=copt_net_1654 VDD=VDD VSS=VSS
Xcopt_h_inst_4491 dl02d1 $PINS I=A[19] Z=copt_net_1659 VDD=VDD VSS=VSS
Xcopt_h_inst_4953 buffd1 $PINS I=A[1] Z=copt_net_2120 VDD=VDD VSS=VSS
Xcopt_h_inst_5045 dl01d1 $PINS I=A[2] Z=copt_net_2212 VDD=VDD VSS=VSS
Xcopt_h_inst_5364 dl01d1 $PINS I=A[4] Z=copt_net_2531 VDD=VDD VSS=VSS
Xcopt_h_inst_5411 dl01d1 $PINS I=A[28] Z=copt_net_2578 VDD=VDD VSS=VSS
.ENDS

.SUBCKT unpu_pe_0 clk rst_n array_en weight_load mode_unsigned weight_in[7]
+ weight_in[6] weight_in[5] weight_in[4] weight_in[3] weight_in[2] weight_in[1]
+ weight_in[0] act_in[7] act_in[6] act_in[5] act_in[4] act_in[3] act_in[2]
+ act_in[1] act_in[0] psum_in[31] psum_in[30] psum_in[29] psum_in[28]
+ psum_in[27] psum_in[26] psum_in[25] psum_in[24] psum_in[23] psum_in[22]
+ psum_in[21] psum_in[20] psum_in[19] psum_in[18] psum_in[17] psum_in[16]
+ psum_in[15] psum_in[14] psum_in[13] psum_in[12] psum_in[11] psum_in[10]
+ psum_in[9] psum_in[8] psum_in[7] psum_in[6] psum_in[5] psum_in[4] psum_in[3]
+ psum_in[2] psum_in[1] psum_in[0] act_out[7] act_out[6] act_out[5] act_out[4]
+ act_out[3] act_out[2] act_out[1] act_out[0] psum_out[31] psum_out[30]
+ psum_out[29] psum_out[28] psum_out[27] psum_out[26] psum_out[25] psum_out[24]
+ psum_out[23] psum_out[22] psum_out[21] psum_out[20] psum_out[19] psum_out[18]
+ psum_out[17] psum_out[16] psum_out[15] psum_out[14] psum_out[13] psum_out[12]
+ psum_out[11] psum_out[10] psum_out[9] psum_out[8] psum_out[7] psum_out[6]
+ psum_out[5] psum_out[4] psum_out[3] psum_out[2] psum_out[1] psum_out[0] VDD
+ VSS ZCTSNET_12 ZCTSNET_0 HFSNET_2 HFSNET_3 HFSNET_4 HFSNET_6 HFSNET_9
+ HFSNET_10 HFSNET_11 ZCTSNET_2 ZCTSNET_3 ZCTSNET_4
XU2 aor22d1 $PINS A1=N_uc_30 A2=HFSNET_2 B1=mode_unsigned B2=N_uc_14
+ Z=product[9] VDD=VDD VSS=VSS
XU3 aor22d1 $PINS A1=N_uc_29 A2=HFSNET_2 B1=N_uc_13 B2=mode_unsigned
+ Z=product[8] VDD=VDD VSS=VSS
XU5 aor22d1 $PINS A1=N_uc_28 A2=HFSNET_2 B1=N_uc_12 B2=mode_unsigned
+ Z=product[7] VDD=VDD VSS=VSS
XU6 aor22d1 $PINS A1=N_uc_27 A2=HFSNET_2 B1=N_uc_11 B2=mode_unsigned
+ Z=product[6] VDD=VDD VSS=VSS
XU7 aor22d1 $PINS A1=N_uc_26 A2=HFSNET_2 B1=N_uc_10 B2=mode_unsigned
+ Z=product[5] VDD=VDD VSS=VSS
XU8 aor22d1 $PINS A1=N_uc_9 A2=mode_unsigned B1=N_uc_25 B2=HFSNET_2
+ Z=product[4] VDD=VDD VSS=VSS
XU9 aor22d1 $PINS A1=N_uc_8 A2=mode_unsigned B1=N_uc_24 B2=HFSNET_2
+ Z=product[3] VDD=VDD VSS=VSS
XU10 aor22d1 $PINS A1=N_uc_7 A2=mode_unsigned B1=N_uc_23 B2=HFSNET_2
+ Z=product[2] VDD=VDD VSS=VSS
XU11 aor22d1 $PINS A1=N_uc_6 A2=HFSNET_4 B1=N_uc_22 B2=HFSNET_3 Z=product[1]
+ VDD=VDD VSS=VSS
XU12 oaim21d1 $PINS B1=N_uc_20 B2=mode_unsigned A=n14 ZN=product[15] VDD=VDD
+ VSS=VSS
XU13 aor22d1 $PINS A1=N_uc_35 A2=HFSNET_2 B1=N_uc_19 B2=mode_unsigned
+ Z=product[14] VDD=VDD VSS=VSS
XU14 aor22d1 $PINS A1=N_uc_34 A2=HFSNET_2 B1=N_uc_18 B2=mode_unsigned
+ Z=product[13] VDD=VDD VSS=VSS
XU15 aor22d1 $PINS A1=N_uc_33 A2=HFSNET_2 B1=N_uc_17 B2=mode_unsigned
+ Z=product[12] VDD=VDD VSS=VSS
XU16 aor22d1 $PINS A1=N_uc_32 A2=HFSNET_2 B1=N_uc_16 B2=mode_unsigned
+ Z=product[11] VDD=VDD VSS=VSS
XU17 aor22d1 $PINS A1=N_uc_31 A2=HFSNET_2 B1=N_uc_15 B2=mode_unsigned
+ Z=product[10] VDD=VDD VSS=VSS
XU18 aor22d1 $PINS A1=N_uc_5 A2=HFSNET_4 B1=N_uc_21 B2=HFSNET_3 Z=product[0]
+ VDD=VDD VSS=VSS
Xadd_42 unpu_pe_0_DW01_add_0_DW01_add_1 $PINS A[31]=psum_in[31]
+ A[30]=psum_in[30] A[29]=psum_in[29] A[28]=psum_in[28] A[27]=psum_in[27]
+ A[26]=psum_in[26] A[25]=psum_in[25] A[24]=psum_in[24] A[23]=psum_in[23]
+ A[22]=psum_in[22] A[21]=psum_in[21] A[20]=psum_in[20] A[19]=psum_in[19]
+ A[18]=psum_in[18] A[17]=psum_in[17] A[16]=psum_in[16] A[15]=psum_in[15]
+ A[14]=psum_in[14] A[13]=psum_in[13] A[12]=psum_in[12] A[11]=psum_in[11]
+ A[10]=psum_in[10] A[9]=psum_in[9] A[8]=psum_in[8] A[7]=psum_in[7]
+ A[6]=psum_in[6] A[5]=psum_in[5] A[4]=psum_in[4] A[3]=psum_in[3] A[2]=psum_in[2]
+ A[1]=psum_in[1] A[0]=psum_in[0] B[31]=n2 B[30]=n2 B[29]=n2 B[28]=n2 B[27]=n2
+ B[26]=n2 B[25]=n2 B[24]=n2 B[23]=n2 B[22]=n2 B[21]=n2 B[20]=n2 B[19]=n2
+ B[18]=n2 B[17]=n2 B[16]=n2 B[15]=product[15] B[14]=product[14]
+ B[13]=product[13] B[12]=product[12] B[11]=product[11] B[10]=product[10]
+ B[9]=product[9] B[8]=product[8] B[7]=product[7] B[6]=product[6] B[5]=product[5]
+ B[4]=product[4] B[3]=product[3] B[2]=product[2] B[1]=product[1] B[0]=product[0]
+ CI=VSS SUM[31]=N_uc_71 SUM[30]=N_uc_70 SUM[29]=N_uc_69 SUM[28]=N_uc_68
+ SUM[27]=N_uc_67 SUM[26]=N_uc_66 SUM[25]=N_uc_65 SUM[24]=N_uc_64 SUM[23]=N_uc_63
+ SUM[22]=N_uc_62 SUM[21]=N_uc_61 SUM[20]=N_uc_60 SUM[19]=N_uc_59 SUM[18]=N_uc_58
+ SUM[17]=N_uc_57 SUM[16]=N_uc_56 SUM[15]=N_uc_55 SUM[14]=N_uc_54 SUM[13]=N_uc_53
+ SUM[12]=N_uc_52 SUM[11]=N_uc_51 SUM[10]=N_uc_50 SUM[9]=N_uc_49 SUM[8]=N_uc_48
+ SUM[7]=N_uc_47 SUM[6]=N_uc_46 SUM[5]=N_uc_45 SUM[4]=N_uc_44 SUM[3]=N_uc_43
+ SUM[2]=N_uc_42 SUM[1]=N_uc_41 SUM[0]=N_uc_40 VDD=VDD VSS=VSS
Xmult_28 unpu_pe_0_DW_mult_uns_0_DW_mult_uns_1 $PINS a[7]=weight_reg[7]
+ a[6]=weight_reg[6] a[5]=weight_reg[5] a[4]=weight_reg[4] a[3]=weight_reg[3]
+ a[2]=weight_reg[2] a[1]=weight_reg[1] a[0]=gre_a_INV_1362_3 b[7]=act_in[7]
+ b[6]=act_in[6] b[5]=act_in[5] b[4]=act_in[4] b[3]=act_in[3] b[2]=act_in[2]
+ b[1]=act_in[1] b[0]=act_in[0] product[15]=N_uc_20 product[14]=N_uc_19
+ product[13]=N_uc_18 product[12]=N_uc_17 product[11]=N_uc_16 product[10]=N_uc_15
+ product[9]=N_uc_14 product[8]=N_uc_13 product[7]=N_uc_12 product[6]=N_uc_11
+ product[5]=N_uc_10 product[4]=N_uc_9 product[3]=N_uc_8 product[2]=N_uc_7
+ product[1]=N_uc_6 product[0]=N_uc_5 VDD=VDD VSS=VSS
Xmult_30 unpu_pe_0_DW_mult_tc_0 $PINS a[7]=weight_reg[7] a[6]=weight_reg[6]
+ a[5]=weight_reg[5] a[4]=weight_reg[4] a[3]=weight_reg[3] a[2]=weight_reg[2]
+ a[1]=weight_reg[1] a[0]=gre_a_INV_1362_3 b[7]=act_in[7] b[6]=act_in[6]
+ b[5]=act_in[5] b[4]=act_in[4] b[3]=act_in[3] b[2]=act_in[2] b[1]=act_in[1]
+ b[0]=act_in[0] product[15]=N_uc_36 product[14]=N_uc_35 product[13]=N_uc_34
+ product[12]=N_uc_33 product[11]=N_uc_32 product[10]=N_uc_31 product[9]=N_uc_30
+ product[8]=N_uc_29 product[7]=N_uc_28 product[6]=N_uc_27 product[5]=N_uc_26
+ product[4]=N_uc_25 product[3]=N_uc_24 product[2]=N_uc_23 product[1]=N_uc_22
+ product[0]=N_uc_21 VDD=VDD VSS=VSS
Xact_out_reg_3_ decrq1 $PINS D=copt_net_1096 ENN=array_en CP=clk CDN=HFSNET_10
+ Q=_gOb17_act_out[3] VDD=VDD VSS=VSS
Xact_out_reg_2_ decrq1 $PINS D=copt_net_1254 ENN=HFSNET_8 CP=ZCTSNET_12
+ CDN=rst_n Q=_gOb19_act_out[2] VDD=VDD VSS=VSS
Xact_out_reg_1_ decrq1 $PINS D=copt_net_1297 ENN=HFSNET_8 CP=ZCTSNET_0
+ CDN=rst_n Q=_gOb21_act_out[1] VDD=VDD VSS=VSS
Xact_out_reg_7_ decrq1 $PINS D=copt_net_1335 ENN=array_en CP=ZCTSNET_3
+ CDN=HFSNET_11 Q=_gOb9_act_out[7] VDD=VDD VSS=VSS
Xact_out_reg_6_ decrq1 $PINS D=copt_net_1080 ENN=array_en CP=ZCTSNET_3
+ CDN=HFSNET_11 Q=_gOb11_act_out[6] VDD=VDD VSS=VSS
Xact_out_reg_5_ decrq1 $PINS D=copt_net_641 ENN=array_en CP=clk CDN=HFSNET_11
+ Q=_gOb13_act_out[5] VDD=VDD VSS=VSS
Xact_out_reg_4_ decrq1 $PINS D=copt_net_1075 ENN=array_en CP=clk CDN=HFSNET_11
+ Q=_gOb15_act_out[4] VDD=VDD VSS=VSS
Xact_out_reg_0_ decrq1 $PINS D=copt_net_2764 ENN=HFSNET_8 CP=ZCTSNET_2
+ CDN=rst_n Q=_gOb23_act_out[0] VDD=VDD VSS=VSS
Xpsum_out_reg_4_ decrq1 $PINS D=N_uc_44 ENN=array_en CP=ZCTSNET_2 CDN=HFSNET_10
+ Q=psum_out[4] VDD=VDD VSS=VSS
Xpsum_out_reg_3_ decrq1 $PINS D=N_uc_43 ENN=array_en CP=ZCTSNET_2 CDN=HFSNET_10
+ Q=psum_out[3] VDD=VDD VSS=VSS
Xpsum_out_reg_2_ decrq1 $PINS D=copt_net_2838 ENN=HFSNET_8 CP=ZCTSNET_2
+ CDN=HFSNET_10 Q=psum_out[2] VDD=VDD VSS=VSS
Xpsum_out_reg_1_ decrq1 $PINS D=copt_net_2427 ENN=HFSNET_8 CP=ZCTSNET_2
+ CDN=HFSNET_10 Q=psum_out[1] VDD=VDD VSS=VSS
Xpsum_out_reg_0_ decrq1 $PINS D=copt_net_603 ENN=array_en CP=ZCTSNET_2
+ CDN=HFSNET_10 Q=psum_out[0] VDD=VDD VSS=VSS
Xpsum_out_reg_5_ decrq1 $PINS D=N_uc_45 ENN=HFSNET_8 CP=ZCTSNET_0 CDN=HFSNET_9
+ Q=psum_out[5] VDD=VDD VSS=VSS
Xpsum_out_reg_6_ decrq1 $PINS D=N_uc_46 ENN=HFSNET_8 CP=ZCTSNET_12 CDN=rst_n
+ Q=psum_out[6] VDD=VDD VSS=VSS
Xpsum_out_reg_7_ decrq1 $PINS D=N_uc_47 ENN=HFSNET_8 CP=ZCTSNET_0 CDN=rst_n
+ Q=psum_out[7] VDD=VDD VSS=VSS
Xweight_reg_reg_7_ decrq1 $PINS D=weight_in[7] ENN=n13 CP=ZCTSNET_3
+ CDN=HFSNET_11 Q=weight_reg[7] VDD=VDD VSS=VSS
Xweight_reg_reg_6_ decrq1 $PINS D=weight_in[6] ENN=n13 CP=ZCTSNET_3
+ CDN=HFSNET_11 Q=weight_reg[6] VDD=VDD VSS=VSS
Xpsum_out_reg_8_ decrq1 $PINS D=N_uc_48 ENN=HFSNET_8 CP=ZCTSNET_12 CDN=rst_n
+ Q=psum_out[8] VDD=VDD VSS=VSS
Xweight_reg_reg_5_ decrq1 $PINS D=weight_in[5] ENN=n13 CP=ZCTSNET_2
+ CDN=HFSNET_11 Q=weight_reg[5] VDD=VDD VSS=VSS
Xweight_reg_reg_4_ decrq1 $PINS D=weight_in[4] ENN=n13 CP=ZCTSNET_2
+ CDN=HFSNET_11 Q=weight_reg[4] VDD=VDD VSS=VSS
Xweight_reg_reg_3_ decrq1 $PINS D=weight_in[3] ENN=n13 CP=ZCTSNET_3
+ CDN=HFSNET_11 Q=weight_reg[3] VDD=VDD VSS=VSS
Xweight_reg_reg_2_ decrq1 $PINS D=weight_in[2] ENN=n13 CP=ZCTSNET_3
+ CDN=HFSNET_11 Q=weight_reg[2] VDD=VDD VSS=VSS
Xweight_reg_reg_1_ decrq1 $PINS D=weight_in[1] ENN=n13 CP=ZCTSNET_3
+ CDN=HFSNET_11 Q=weight_reg[1] VDD=VDD VSS=VSS
Xweight_reg_reg_0_ decrq1 $PINS D=weight_in[0] ENN=n13 CP=ZCTSNET_3
+ CDN=HFSNET_11 Q=weight_reg[0] VDD=VDD VSS=VSS
Xpsum_out_reg_9_ decrq1 $PINS D=N_uc_49 ENN=HFSNET_8 CP=ZCTSNET_12 CDN=rst_n
+ Q=psum_out[9] VDD=VDD VSS=VSS
Xpsum_out_reg_10_ decrq1 $PINS D=N_uc_50 ENN=HFSNET_8 CP=ZCTSNET_12 CDN=rst_n
+ Q=psum_out[10] VDD=VDD VSS=VSS
Xpsum_out_reg_11_ decrq1 $PINS D=N_uc_51 ENN=HFSNET_8 CP=ZCTSNET_12 CDN=rst_n
+ Q=psum_out[11] VDD=VDD VSS=VSS
Xpsum_out_reg_12_ decrq1 $PINS D=N_uc_52 ENN=array_en CP=clk CDN=HFSNET_10
+ Q=psum_out[12] VDD=VDD VSS=VSS
Xpsum_out_reg_13_ decrq1 $PINS D=N_uc_53 ENN=HFSNET_8 CP=ZCTSNET_12 CDN=rst_n
+ Q=psum_out[13] VDD=VDD VSS=VSS
Xpsum_out_reg_14_ decrq1 $PINS D=N_uc_54 ENN=HFSNET_8 CP=ZCTSNET_12 CDN=rst_n
+ Q=psum_out[14] VDD=VDD VSS=VSS
Xpsum_out_reg_15_ decrq1 $PINS D=N_uc_55 ENN=HFSNET_8 CP=ZCTSNET_12 CDN=rst_n
+ Q=psum_out[15] VDD=VDD VSS=VSS
Xpsum_out_reg_16_ decrq1 $PINS D=N_uc_56 ENN=HFSNET_8 CP=ZCTSNET_0 CDN=rst_n
+ Q=psum_out[16] VDD=VDD VSS=VSS
Xpsum_out_reg_17_ decrq1 $PINS D=N_uc_57 ENN=array_en CP=ZCTSNET_3
+ CDN=HFSNET_11 Q=psum_out[17] VDD=VDD VSS=VSS
Xpsum_out_reg_18_ decrq1 $PINS D=N_uc_58 ENN=HFSNET_8 CP=ZCTSNET_2
+ CDN=HFSNET_10 Q=psum_out[18] VDD=VDD VSS=VSS
Xpsum_out_reg_19_ decrq1 $PINS D=N_uc_59 ENN=array_en CP=ZCTSNET_2
+ CDN=HFSNET_10 Q=psum_out[19] VDD=VDD VSS=VSS
Xpsum_out_reg_20_ decrq1 $PINS D=N_uc_60 ENN=array_en CP=ZCTSNET_2
+ CDN=HFSNET_10 Q=psum_out[20] VDD=VDD VSS=VSS
Xpsum_out_reg_21_ decrq1 $PINS D=N_uc_61 ENN=array_en CP=ZCTSNET_2
+ CDN=HFSNET_10 Q=psum_out[21] VDD=VDD VSS=VSS
Xpsum_out_reg_22_ decrq1 $PINS D=N_uc_62 ENN=array_en CP=ZCTSNET_3
+ CDN=HFSNET_11 Q=psum_out[22] VDD=VDD VSS=VSS
Xpsum_out_reg_23_ decrq1 $PINS D=N_uc_63 ENN=HFSNET_8 CP=ZCTSNET_0
+ CDN=HFSNET_10 Q=psum_out[23] VDD=VDD VSS=VSS
Xpsum_out_reg_24_ decrq1 $PINS D=N_uc_64 ENN=HFSNET_8 CP=ZCTSNET_0
+ CDN=HFSNET_10 Q=psum_out[24] VDD=VDD VSS=VSS
Xpsum_out_reg_25_ decrq1 $PINS D=N_uc_65 ENN=HFSNET_8 CP=ZCTSNET_2
+ CDN=HFSNET_10 Q=psum_out[25] VDD=VDD VSS=VSS
Xpsum_out_reg_26_ decrq1 $PINS D=N_uc_66 ENN=HFSNET_8 CP=ZCTSNET_0 CDN=rst_n
+ Q=psum_out[26] VDD=VDD VSS=VSS
Xpsum_out_reg_27_ decrq1 $PINS D=N_uc_67 ENN=HFSNET_8 CP=ZCTSNET_0 CDN=rst_n
+ Q=psum_out[27] VDD=VDD VSS=VSS
Xpsum_out_reg_28_ decrq1 $PINS D=N_uc_68 ENN=HFSNET_8 CP=ZCTSNET_0 CDN=rst_n
+ Q=psum_out[28] VDD=VDD VSS=VSS
Xpsum_out_reg_29_ decrq1 $PINS D=N_uc_69 ENN=HFSNET_8 CP=ZCTSNET_4
+ CDN=HFSNET_10 Q=psum_out[29] VDD=VDD VSS=VSS
Xpsum_out_reg_30_ decrq1 $PINS D=N_uc_70 ENN=HFSNET_8 CP=ZCTSNET_0 CDN=HFSNET_9
+ Q=psum_out[30] VDD=VDD VSS=VSS
Xpsum_out_reg_31_ decrq1 $PINS D=N_uc_71 ENN=HFSNET_8 CP=ZCTSNET_2
+ CDN=HFSNET_10 Q=psum_out[31] VDD=VDD VSS=VSS
XU19 inv0d2 $PINS I=n14 ZN=n2 VDD=VDD VSS=VSS
Xcopt_h_inst_3433 dl02d1 $PINS I=N_uc_40 Z=copt_net_603 VDD=VDD VSS=VSS
Xcopt_h_inst_3471 dl02d1 $PINS I=act_in[5] Z=copt_net_641 VDD=VDD VSS=VSS
XU22 nd02d1 $PINS A1=weight_load A2=HFSNET_6 ZN=n13 VDD=VDD VSS=VSS
Xcopt_h_inst_3907 dl02d1 $PINS I=act_in[4] Z=copt_net_1075 VDD=VDD VSS=VSS
Xcopt_h_inst_3912 dl02d1 $PINS I=act_in[6] Z=copt_net_1080 VDD=VDD VSS=VSS
Xcopt_h_inst_3928 dl01d1 $PINS I=act_in[3] Z=copt_net_1096 VDD=VDD VSS=VSS
XHFSINV_58569_571 inv0d1 $PINS I=HFSNET_6 ZN=HFSNET_8 VDD=VDD VSS=VSS
XU27 nd02d1 $PINS A1=N_uc_36 A2=HFSNET_2 ZN=n14 VDD=VDD VSS=VSS
Xcopt_h_inst_4086 dl01d1 $PINS I=act_in[2] Z=copt_net_1254 VDD=VDD VSS=VSS
Xcopt_h_inst_4129 dl01d1 $PINS I=act_in[1] Z=copt_net_1297 VDD=VDD VSS=VSS
Xcopt_h_inst_4167 dl01d1 $PINS I=act_in[7] Z=copt_net_1335 VDD=VDD VSS=VSS
Xcopt_h_inst_5260 dl02d1 $PINS I=N_uc_41 Z=copt_net_2427 VDD=VDD VSS=VSS
Xcopt_h_inst_5597 dl01d1 $PINS I=act_in[0] Z=copt_net_2764 VDD=VDD VSS=VSS
Xcopt_h_inst_5672 dl01d1 $PINS I=N_uc_42 Z=copt_net_2838 VDD=VDD VSS=VSS
Xgre_a_INV_1362_inst_5812 inv0d1 $PINS I=weight_reg[0] ZN=gre_a_INV_1362_3
+ VDD=VDD VSS=VSS
.ENDS

.SUBCKT unpu_pe_1_DW_mult_tc_0_DW_mult_tc_1 a[7] a[6] a[5] a[4] a[3] a[2] a[1]
+ a[0] b[7] b[6] b[5] b[4] b[3] b[2] b[1] b[0] product[15] product[14]
+ product[13] product[12] product[11] product[10] product[9] product[8]
+ product[7] product[6] product[5] product[4] product[3] product[2] product[1]
+ product[0] VDD VSS
XU2 ad01d0 $PINS A=n196 B=n61 CI=n2 CO=n1 S=product[14] VDD=VDD VSS=VSS
XU3 ad01d0 $PINS A=n17 B=n16 CI=n3 CO=n2 S=product[13] VDD=VDD VSS=VSS
XU4 ad01d0 $PINS A=n18 B=n19 CI=n4 CO=n3 S=product[12] VDD=VDD VSS=VSS
XU5 ad01d0 $PINS A=n20 B=n23 CI=n5 CO=n4 S=product[11] VDD=VDD VSS=VSS
XU6 ad01d0 $PINS A=n27 B=n24 CI=n6 CO=n5 S=product[10] VDD=VDD VSS=VSS
XU7 ad01d0 $PINS A=n33 B=n28 CI=n7 CO=n6 S=product[9] VDD=VDD VSS=VSS
XU8 ad01d0 $PINS A=n39 B=n34 CI=n8 CO=n7 S=product[8] VDD=VDD VSS=VSS
XU9 ad01d0 $PINS A=n45 B=n40 CI=n9 CO=n8 S=product[7] VDD=VDD VSS=VSS
XU10 ad01d0 $PINS A=n49 B=n46 CI=n10 CO=n9 S=product[6] VDD=VDD VSS=VSS
XU11 ad01d0 $PINS A=n53 B=n50 CI=n11 CO=n10 S=product[5] VDD=VDD VSS=VSS
XU12 ad01d0 $PINS A=n55 B=n54 CI=n12 CO=n11 S=product[4] VDD=VDD VSS=VSS
XU13 ad01d0 $PINS A=n59 B=n56 CI=n13 CO=n12 S=product[3] VDD=VDD VSS=VSS
XU14 ad01d0 $PINS A=n84 B=n91 CI=n14 CO=n13 S=product[2] VDD=VDD VSS=VSS
XctmTdsLR_1_3014 an02d1 $PINS A1=n58 A2=n75 Z=n51 VDD=VDD VSS=VSS
XU17 ad01d0 $PINS A=n195 B=n62 CI=n69 CO=n17 S=n18 VDD=VDD VSS=VSS
XU18 ad01d0 $PINS A=n63 B=n25 CI=n22 CO=n19 S=n20 VDD=VDD VSS=VSS
XU20 ad01d0 $PINS A=n64 B=n26 CI=n29 CO=n23 S=n24 VDD=VDD VSS=VSS
XU21 ad01d0 $PINS A=n194 B=n70 CI=n77 CO=n25 S=n26 VDD=VDD VSS=VSS
XU22 ad01d0 $PINS A=n32 B=n35 CI=n30 CO=n27 S=n28 VDD=VDD VSS=VSS
XU23 ad01d0 $PINS A=n71 B=n65 CI=n37 CO=n29 S=n30 VDD=VDD VSS=VSS
XU25 ad01d0 $PINS A=n38 B=n41 CI=n36 CO=n33 S=n34 VDD=VDD VSS=VSS
XU26 ad01d0 $PINS A=n72 B=n85 CI=n43 CO=n35 S=n36 VDD=VDD VSS=VSS
XU29 ad01d0 $PINS A=n44 B=n47 CI=n42 CO=n39 S=n40 VDD=VDD VSS=VSS
XU30 ad01d0 $PINS A=n86 B=n73 CI=n79 CO=n41 S=n42 VDD=VDD VSS=VSS
XU32 ad01d0 $PINS A=n74 B=n51 CI=n48 CO=n45 S=n46 VDD=VDD VSS=VSS
XU33 ad01d0 $PINS A=n68 B=n87 CI=n80 CO=n47 S=n48 VDD=VDD VSS=VSS
XU34 ad01d0 $PINS A=n88 B=n81 CI=n52 CO=n49 S=n50 VDD=VDD VSS=VSS
XU36 ad01d0 $PINS A=n76 B=n89 CI=n82 CO=n53 S=n54 VDD=VDD VSS=VSS
XU37 ah01d1 $PINS A=n83 B=n90 CO=n55 S=n56 VDD=VDD VSS=VSS
XU145 oai21d1 $PINS B1=n203 B2=n249 A=n222 ZN=n77 VDD=VDD VSS=VSS
XU146 oai21d1 $PINS B1=n201 B2=n250 A=n232 ZN=n69 VDD=VDD VSS=VSS
XU147 oai21d1 $PINS B1=n199 B2=n251 A=n242 ZN=n61 VDD=VDD VSS=VSS
XU148 inv0d0 $PINS I=n16 ZN=n196 VDD=VDD VSS=VSS
XU149 inv0d0 $PINS I=n223 ZN=n201 VDD=VDD VSS=VSS
XU150 inv0d0 $PINS I=n214 ZN=n203 VDD=VDD VSS=VSS
XU151 inv0d0 $PINS I=n233 ZN=n199 VDD=VDD VSS=VSS
XU152 inv0d0 $PINS I=n32 ZN=n194 VDD=VDD VSS=VSS
XU153 inv0d0 $PINS I=n22 ZN=n195 VDD=VDD VSS=VSS
XU154 nd02d1 $PINS A1=n214 A2=n249 ZN=n216 VDD=VDD VSS=VSS
XU155 xr02d1 $PINS A1=a[2] A2=n204 Z=n214 VDD=VDD VSS=VSS
XU156 inv0d1 $PINS I=a[1] ZN=n204 VDD=VDD VSS=VSS
XU157 nd02d1 $PINS A1=n223 A2=n250 ZN=n225 VDD=VDD VSS=VSS
XU158 xr02d1 $PINS A1=a[4] A2=n202 Z=n223 VDD=VDD VSS=VSS
XU159 inv0d1 $PINS I=a[3] ZN=n202 VDD=VDD VSS=VSS
XU160 nd02d1 $PINS A1=a[1] A2=a[0] ZN=n206 VDD=VDD VSS=VSS
XU162 inv0d0 $PINS I=b[0] ZN=n197 VDD=VDD VSS=VSS
XU163 xr02d1 $PINS A1=a[6] A2=n200 Z=n233 VDD=VDD VSS=VSS
XU164 inv0d1 $PINS I=a[5] ZN=n200 VDD=VDD VSS=VSS
XU165 nd02d1 $PINS A1=n233 A2=n251 ZN=n235 VDD=VDD VSS=VSS
XU166 inv0d1 $PINS I=a[7] ZN=n198 VDD=VDD VSS=VSS
XU167 inv0d0 $PINS I=n1 ZN=product[15] VDD=VDD VSS=VSS
XU168 nr02d0 $PINS A1=a[0] A2=n197 ZN=product[0] VDD=VDD VSS=VSS
XU169 oai22d1 $PINS A1=b[0] A2=n206 B1=n207 B2=a[0] ZN=n92 VDD=VDD VSS=VSS
XU170 oai22d1 $PINS A1=n207 A2=n206 B1=n208 B2=a[0] ZN=n91 VDD=VDD VSS=VSS
XU171 xr02d1 $PINS A1=b[1] A2=n204 Z=n207 VDD=VDD VSS=VSS
XU172 oai22d1 $PINS A1=n208 A2=n206 B1=n209 B2=a[0] ZN=n90 VDD=VDD VSS=VSS
XU173 xr02d1 $PINS A1=b[2] A2=n204 Z=n208 VDD=VDD VSS=VSS
XU174 oai22d1 $PINS A1=n209 A2=n206 B1=n210 B2=a[0] ZN=n89 VDD=VDD VSS=VSS
XU175 xr02d1 $PINS A1=b[3] A2=n204 Z=n209 VDD=VDD VSS=VSS
XU176 oai22d1 $PINS A1=n210 A2=n206 B1=n211 B2=a[0] ZN=n88 VDD=VDD VSS=VSS
XU177 xr02d1 $PINS A1=b[4] A2=n204 Z=n210 VDD=VDD VSS=VSS
XU178 oai22d1 $PINS A1=n211 A2=n206 B1=n212 B2=a[0] ZN=n87 VDD=VDD VSS=VSS
XU179 xr02d1 $PINS A1=b[5] A2=n204 Z=n211 VDD=VDD VSS=VSS
XU180 oai22d1 $PINS A1=n212 A2=n206 B1=n213 B2=a[0] ZN=n86 VDD=VDD VSS=VSS
XU181 xr02d1 $PINS A1=b[6] A2=n204 Z=n212 VDD=VDD VSS=VSS
XU182 aor21d1 $PINS B1=a[0] B2=n206 A=n213 Z=n85 VDD=VDD VSS=VSS
XU183 xr02d1 $PINS A1=b[7] A2=n204 Z=n213 VDD=VDD VSS=VSS
XU184 nr02d0 $PINS A1=n214 A2=n197 ZN=n84 VDD=VDD VSS=VSS
XU185 oai22d1 $PINS A1=n216 A2=n215 B1=n214 B2=n217 ZN=n83 VDD=VDD VSS=VSS
XctmTdsLR_1_3012 an02d1 $PINS A1=n60 A2=n92 Z=n14 VDD=VDD VSS=VSS
XU187 oai22d1 $PINS A1=n217 A2=n216 B1=n214 B2=n218 ZN=n82 VDD=VDD VSS=VSS
XU188 xr02d1 $PINS A1=b[1] A2=n202 Z=n217 VDD=VDD VSS=VSS
XU189 oai22d1 $PINS A1=n218 A2=n216 B1=n214 B2=n219 ZN=n81 VDD=VDD VSS=VSS
XU190 xr02d1 $PINS A1=b[2] A2=n202 Z=n218 VDD=VDD VSS=VSS
XU191 oai22d1 $PINS A1=n219 A2=n216 B1=n214 B2=n220 ZN=n80 VDD=VDD VSS=VSS
XU192 xr02d1 $PINS A1=b[3] A2=n202 Z=n219 VDD=VDD VSS=VSS
XU193 oai22d1 $PINS A1=n220 A2=n216 B1=n214 B2=n221 ZN=n79 VDD=VDD VSS=VSS
XU194 xr02d1 $PINS A1=b[4] A2=n202 Z=n220 VDD=VDD VSS=VSS
XU195 nr02d0 $PINS A1=n223 A2=n197 ZN=n76 VDD=VDD VSS=VSS
XU196 oai22d1 $PINS A1=n225 A2=n224 B1=n223 B2=n226 ZN=n75 VDD=VDD VSS=VSS
XctmTdsLR_2_3013 aoim21d1 $PINS B1=n92 B2=n60 A=n14 ZN=product[1] VDD=VDD
+ VSS=VSS
XU198 oai22d1 $PINS A1=n226 A2=n225 B1=n223 B2=n227 ZN=n74 VDD=VDD VSS=VSS
XU199 xr02d1 $PINS A1=b[1] A2=n200 Z=n226 VDD=VDD VSS=VSS
XU200 oai22d1 $PINS A1=n227 A2=n225 B1=n223 B2=n228 ZN=n73 VDD=VDD VSS=VSS
XU201 xr02d1 $PINS A1=b[2] A2=n200 Z=n227 VDD=VDD VSS=VSS
XU202 oai22d1 $PINS A1=n228 A2=n225 B1=n223 B2=n229 ZN=n72 VDD=VDD VSS=VSS
XU203 xr02d1 $PINS A1=b[3] A2=n200 Z=n228 VDD=VDD VSS=VSS
XU204 oai22d1 $PINS A1=n229 A2=n225 B1=n223 B2=n230 ZN=n71 VDD=VDD VSS=VSS
XU205 xr02d1 $PINS A1=b[4] A2=n200 Z=n229 VDD=VDD VSS=VSS
XU206 oai22d1 $PINS A1=n230 A2=n225 B1=n223 B2=n231 ZN=n70 VDD=VDD VSS=VSS
XU207 xr02d1 $PINS A1=b[5] A2=n200 Z=n230 VDD=VDD VSS=VSS
XU208 nr02d0 $PINS A1=n233 A2=n197 ZN=n68 VDD=VDD VSS=VSS
XU209 oai22d1 $PINS A1=n235 A2=n234 B1=n233 B2=n236 ZN=n67 VDD=VDD VSS=VSS
XctmTdsLR_2_3015 aoim21d1 $PINS B1=n58 B2=n75 A=n51 ZN=n52 VDD=VDD VSS=VSS
XU211 oai22d1 $PINS A1=n237 A2=n235 B1=n233 B2=n238 ZN=n65 VDD=VDD VSS=VSS
XU212 oai22d1 $PINS A1=n238 A2=n235 B1=n233 B2=n239 ZN=n64 VDD=VDD VSS=VSS
XU213 xr02d1 $PINS A1=b[3] A2=n198 Z=n238 VDD=VDD VSS=VSS
XU214 oai22d1 $PINS A1=n239 A2=n235 B1=n233 B2=n240 ZN=n63 VDD=VDD VSS=VSS
XU215 xr02d1 $PINS A1=b[4] A2=n198 Z=n239 VDD=VDD VSS=VSS
XU216 oai22d1 $PINS A1=n240 A2=n235 B1=n233 B2=n241 ZN=n62 VDD=VDD VSS=VSS
XU217 xr02d1 $PINS A1=b[5] A2=n198 Z=n240 VDD=VDD VSS=VSS
XU218 oai21d1 $PINS B1=b[0] B2=n204 A=n206 ZN=n60 VDD=VDD VSS=VSS
XU219 oai21d1 $PINS B1=n202 B2=n216 A=n243 ZN=n59 VDD=VDD VSS=VSS
XU220 nd03d0 $PINS A1=n203 A2=n197 A3=a[3] ZN=n243 VDD=VDD VSS=VSS
XU221 oai21d1 $PINS B1=n200 B2=n225 A=n244 ZN=n58 VDD=VDD VSS=VSS
XU222 nd03d0 $PINS A1=n201 A2=n197 A3=a[5] ZN=n244 VDD=VDD VSS=VSS
XU223 oai21d1 $PINS B1=n198 B2=n235 A=n245 ZN=n57 VDD=VDD VSS=VSS
XU224 nd03d0 $PINS A1=n199 A2=n197 A3=a[7] ZN=n245 VDD=VDD VSS=VSS
XU225 xn02d1 $PINS A1=n246 A2=n247 ZN=n38 VDD=VDD VSS=VSS
XU226 or02d0 $PINS A1=n247 A2=n246 Z=n37 VDD=VDD VSS=VSS
XU227 oai22d1 $PINS A1=n236 A2=n235 B1=n233 B2=n237 ZN=n246 VDD=VDD VSS=VSS
XU228 xr02d1 $PINS A1=b[2] A2=n198 Z=n237 VDD=VDD VSS=VSS
XU229 xr02d1 $PINS A1=b[1] A2=n198 Z=n236 VDD=VDD VSS=VSS
XU230 oai22d1 $PINS A1=n221 A2=n216 B1=n214 B2=n248 ZN=n247 VDD=VDD VSS=VSS
XU231 xr02d1 $PINS A1=b[5] A2=n202 Z=n221 VDD=VDD VSS=VSS
XU232 aoim22d1 $PINS A1=n203 A2=n222 B1=n248 B2=n216 Z=n32 VDD=VDD VSS=VSS
XU233 xr02d1 $PINS A1=a[3] A2=a[2] Z=n249 VDD=VDD VSS=VSS
XU234 xr02d1 $PINS A1=b[6] A2=n202 Z=n248 VDD=VDD VSS=VSS
XU235 xr02d1 $PINS A1=b[7] A2=a[3] Z=n222 VDD=VDD VSS=VSS
XU236 aoim22d1 $PINS A1=n201 A2=n232 B1=n231 B2=n225 Z=n22 VDD=VDD VSS=VSS
XU237 xr02d1 $PINS A1=a[5] A2=a[4] Z=n250 VDD=VDD VSS=VSS
XU238 xr02d1 $PINS A1=b[6] A2=n200 Z=n231 VDD=VDD VSS=VSS
XU239 xr02d1 $PINS A1=b[7] A2=a[5] Z=n232 VDD=VDD VSS=VSS
XU240 aoim22d1 $PINS A1=n199 A2=n242 B1=n241 B2=n235 Z=n16 VDD=VDD VSS=VSS
XU241 xr02d1 $PINS A1=a[7] A2=a[6] Z=n251 VDD=VDD VSS=VSS
XU242 xr02d1 $PINS A1=b[6] A2=n198 Z=n241 VDD=VDD VSS=VSS
XU243 xr02d1 $PINS A1=b[7] A2=a[7] Z=n242 VDD=VDD VSS=VSS
XctmTdsLR_1_1376 aoim22d1 $PINS A1=n202 A2=b[0] B1=n202 B2=b[0] Z=n215 VDD=VDD
+ VSS=VSS
XctmTdsLR_1_1377 aoim22d1 $PINS A1=n200 A2=b[0] B1=n200 B2=b[0] Z=n224 VDD=VDD
+ VSS=VSS
XctmTdsLR_1_1378 aoim22d1 $PINS A1=n198 A2=b[0] B1=n198 B2=b[0] Z=n234 VDD=VDD
+ VSS=VSS
XctmTdsLR_1_3016 an02d1 $PINS A1=n57 A2=n67 Z=n43 VDD=VDD VSS=VSS
XctmTdsLR_2_3017 aoim21d1 $PINS B1=n57 B2=n67 A=n43 ZN=n44 VDD=VDD VSS=VSS
.ENDS

.SUBCKT unpu_pe_1_DW_mult_uns_0_DW_mult_uns_2 a[7] a[6] a[5] a[4] a[3] a[2]
+ a[1] a[0] b[7] b[6] b[5] b[4] b[3] b[2] b[1] b[0] product[15] product[14]
+ product[13] product[12] product[11] product[10] product[9] product[8]
+ product[7] product[6] product[5] product[4] product[3] product[2] product[1]
+ product[0] VDD VSS
XU2 ad01d0 $PINS A=n99 B=n15 CI=n2 CO=product[15] S=product[14] VDD=VDD VSS=VSS
XU3 ad01d0 $PINS A=n16 B=n17 CI=n3 CO=n2 S=product[13] VDD=VDD VSS=VSS
XU4 ad01d0 $PINS A=n18 B=n21 CI=n4 CO=n3 S=product[12] VDD=VDD VSS=VSS
XU5 ad01d0 $PINS A=n27 B=n22 CI=n5 CO=n4 S=product[11] VDD=VDD VSS=VSS
XU6 ad01d0 $PINS A=n35 B=n28 CI=n6 CO=n5 S=product[10] VDD=VDD VSS=VSS
XU7 ad01d0 $PINS A=n45 B=n36 CI=n7 CO=n6 S=product[9] VDD=VDD VSS=VSS
XU8 ad01d0 $PINS A=n57 B=n46 CI=n8 CO=n7 S=product[8] VDD=VDD VSS=VSS
XU9 ad01d0 $PINS A=n69 B=n58 CI=n9 CO=n8 S=product[7] VDD=VDD VSS=VSS
XU10 ad01d0 $PINS A=n79 B=n70 CI=n10 CO=n9 S=product[6] VDD=VDD VSS=VSS
XU11 ad01d0 $PINS A=n87 B=n80 CI=n11 CO=n10 S=product[5] VDD=VDD VSS=VSS
XU12 ad01d0 $PINS A=n93 B=n88 CI=n12 CO=n11 S=product[4] VDD=VDD VSS=VSS
XU13 ad01d0 $PINS A=n96 B=n13 CI=n94 CO=n12 S=product[3] VDD=VDD VSS=VSS
XU14 ad01d0 $PINS A=n146 B=n14 CI=n98 CO=n13 S=product[2] VDD=VDD VSS=VSS
XU15 ah01d1 $PINS A=n161 B=n154 CO=n14 S=product[1] VDD=VDD VSS=VSS
XU16 ad01d0 $PINS A=n107 B=n100 CI=n19 CO=n15 S=n16 VDD=VDD VSS=VSS
XU17 ad01d0 $PINS A=n25 B=n20 CI=n23 CO=n17 S=n18 VDD=VDD VSS=VSS
XU18 ad01d0 $PINS A=n115 B=n101 CI=n108 CO=n19 S=n20 VDD=VDD VSS=VSS
XU19 ad01d0 $PINS A=n31 B=n24 CI=n29 CO=n21 S=n22 VDD=VDD VSS=VSS
XU20 ad01d0 $PINS A=n116 B=n33 CI=n26 CO=n23 S=n24 VDD=VDD VSS=VSS
XU21 ad01d0 $PINS A=n123 B=n102 CI=n109 CO=n25 S=n26 VDD=VDD VSS=VSS
XU22 ad01d0 $PINS A=n32 B=n37 CI=n30 CO=n27 S=n28 VDD=VDD VSS=VSS
XU23 ad01d0 $PINS A=n41 B=n34 CI=n39 CO=n29 S=n30 VDD=VDD VSS=VSS
XU24 ad01d0 $PINS A=n124 B=n117 CI=n43 CO=n31 S=n32 VDD=VDD VSS=VSS
XU25 ad01d0 $PINS A=n131 B=n103 CI=n110 CO=n33 S=n34 VDD=VDD VSS=VSS
XU26 ad01d0 $PINS A=n40 B=n47 CI=n38 CO=n35 S=n36 VDD=VDD VSS=VSS
XU27 ad01d0 $PINS A=n44 B=n51 CI=n49 CO=n37 S=n38 VDD=VDD VSS=VSS
XU28 ad01d0 $PINS A=n55 B=n53 CI=n42 CO=n39 S=n40 VDD=VDD VSS=VSS
XU29 ad01d0 $PINS A=n118 B=n125 CI=n132 CO=n41 S=n42 VDD=VDD VSS=VSS
XU30 ad01d0 $PINS A=n139 B=n104 CI=n111 CO=n43 S=n44 VDD=VDD VSS=VSS
XU31 ad01d0 $PINS A=n50 B=n59 CI=n48 CO=n45 S=n46 VDD=VDD VSS=VSS
XU32 ad01d0 $PINS A=n54 B=n52 CI=n61 CO=n47 S=n48 VDD=VDD VSS=VSS
XU33 ad01d0 $PINS A=n56 B=n65 CI=n63 CO=n49 S=n50 VDD=VDD VSS=VSS
XU34 ad01d0 $PINS A=n140 B=n133 CI=n67 CO=n51 S=n52 VDD=VDD VSS=VSS
XU35 ad01d0 $PINS A=n126 B=n119 CI=n147 CO=n53 S=n54 VDD=VDD VSS=VSS
XU36 ah01d1 $PINS A=n105 B=n112 CO=n55 S=n56 VDD=VDD VSS=VSS
XU37 ad01d0 $PINS A=n71 B=n62 CI=n60 CO=n57 S=n58 VDD=VDD VSS=VSS
XU38 ad01d0 $PINS A=n64 B=n66 CI=n73 CO=n59 S=n60 VDD=VDD VSS=VSS
XU39 ad01d0 $PINS A=n77 B=n68 CI=n75 CO=n61 S=n62 VDD=VDD VSS=VSS
XU40 ad01d0 $PINS A=n141 B=n127 CI=n134 CO=n63 S=n64 VDD=VDD VSS=VSS
XU41 ad01d0 $PINS A=n155 B=n120 CI=n148 CO=n65 S=n66 VDD=VDD VSS=VSS
XU42 ah01d1 $PINS A=n106 B=n113 CO=n67 S=n68 VDD=VDD VSS=VSS
XU43 ad01d0 $PINS A=n81 B=n74 CI=n72 CO=n69 S=n70 VDD=VDD VSS=VSS
XU44 ad01d0 $PINS A=n78 B=n83 CI=n76 CO=n71 S=n72 VDD=VDD VSS=VSS
XU45 ad01d0 $PINS A=n142 B=n135 CI=n85 CO=n73 S=n74 VDD=VDD VSS=VSS
XU46 ad01d0 $PINS A=n156 B=n128 CI=n149 CO=n75 S=n76 VDD=VDD VSS=VSS
XU47 ah01d1 $PINS A=n114 B=n121 CO=n77 S=n78 VDD=VDD VSS=VSS
XU48 ad01d0 $PINS A=n89 B=n84 CI=n82 CO=n79 S=n80 VDD=VDD VSS=VSS
XU49 ad01d0 $PINS A=n150 B=n91 CI=n86 CO=n81 S=n82 VDD=VDD VSS=VSS
XU50 ad01d0 $PINS A=n157 B=n136 CI=n143 CO=n83 S=n84 VDD=VDD VSS=VSS
XU51 ah01d1 $PINS A=n122 B=n129 CO=n85 S=n86 VDD=VDD VSS=VSS
XU52 ad01d0 $PINS A=n95 B=n92 CI=n90 CO=n87 S=n88 VDD=VDD VSS=VSS
XU53 ad01d0 $PINS A=n158 B=n144 CI=n151 CO=n89 S=n90 VDD=VDD VSS=VSS
XU54 ah01d1 $PINS A=n130 B=n137 CO=n91 S=n92 VDD=VDD VSS=VSS
XU55 ad01d0 $PINS A=n159 B=n152 CI=n97 CO=n93 S=n94 VDD=VDD VSS=VSS
XU56 ah01d1 $PINS A=n138 B=n145 CO=n95 S=n96 VDD=VDD VSS=VSS
XU57 ah01d1 $PINS A=n153 B=n160 CO=n97 S=n98 VDD=VDD VSS=VSS
XU140 inv0d0 $PINS I=b[4] ZN=n217 VDD=VDD VSS=VSS
XU141 inv0d0 $PINS I=a[1] ZN=n228 VDD=VDD VSS=VSS
XU142 inv0d0 $PINS I=b[2] ZN=n219 VDD=VDD VSS=VSS
XU144 inv0d0 $PINS I=a[2] ZN=n227 VDD=VDD VSS=VSS
XU145 inv0d0 $PINS I=b[3] ZN=n218 VDD=VDD VSS=VSS
XU146 inv0d0 $PINS I=a[5] ZN=n224 VDD=VDD VSS=VSS
XU147 inv0d0 $PINS I=b[1] ZN=n220 VDD=VDD VSS=VSS
XU148 inv0d0 $PINS I=b[0] ZN=n221 VDD=VDD VSS=VSS
XU149 inv0d0 $PINS I=a[4] ZN=n225 VDD=VDD VSS=VSS
XU150 inv0d0 $PINS I=b[6] ZN=n215 VDD=VDD VSS=VSS
XU151 inv0d0 $PINS I=a[3] ZN=n226 VDD=VDD VSS=VSS
XU152 inv0d0 $PINS I=b[5] ZN=n216 VDD=VDD VSS=VSS
XU153 inv0d0 $PINS I=b[7] ZN=n214 VDD=VDD VSS=VSS
XU154 inv0d0 $PINS I=a[6] ZN=n223 VDD=VDD VSS=VSS
XU155 inv0d0 $PINS I=a[7] ZN=n222 VDD=VDD VSS=VSS
XU156 nr02d0 $PINS A1=a[0] A2=n221 ZN=product[0] VDD=VDD VSS=VSS
XU157 nr02d0 $PINS A1=n222 A2=n214 ZN=n99 VDD=VDD VSS=VSS
XU158 nr02d0 $PINS A1=a[0] A2=n220 ZN=n161 VDD=VDD VSS=VSS
XU159 nr02d0 $PINS A1=a[0] A2=n219 ZN=n160 VDD=VDD VSS=VSS
XU160 nr02d0 $PINS A1=a[0] A2=n218 ZN=n159 VDD=VDD VSS=VSS
XU161 nr02d0 $PINS A1=a[0] A2=n217 ZN=n158 VDD=VDD VSS=VSS
XU162 nr02d0 $PINS A1=a[0] A2=n216 ZN=n157 VDD=VDD VSS=VSS
XU163 nr02d0 $PINS A1=a[0] A2=n215 ZN=n156 VDD=VDD VSS=VSS
XU164 nr02d0 $PINS A1=a[0] A2=n214 ZN=n155 VDD=VDD VSS=VSS
XU165 nr02d0 $PINS A1=n221 A2=n228 ZN=n154 VDD=VDD VSS=VSS
XU166 nr02d0 $PINS A1=n220 A2=n228 ZN=n153 VDD=VDD VSS=VSS
XU167 nr02d0 $PINS A1=n219 A2=n228 ZN=n152 VDD=VDD VSS=VSS
XU168 nr02d0 $PINS A1=n218 A2=n228 ZN=n151 VDD=VDD VSS=VSS
XU169 nr02d0 $PINS A1=n217 A2=n228 ZN=n150 VDD=VDD VSS=VSS
XU170 nr02d0 $PINS A1=n216 A2=n228 ZN=n149 VDD=VDD VSS=VSS
XU171 nr02d0 $PINS A1=n215 A2=n228 ZN=n148 VDD=VDD VSS=VSS
XU172 nr02d0 $PINS A1=n214 A2=n228 ZN=n147 VDD=VDD VSS=VSS
XU173 nr02d0 $PINS A1=n221 A2=n227 ZN=n146 VDD=VDD VSS=VSS
XU174 nr02d0 $PINS A1=n220 A2=n227 ZN=n145 VDD=VDD VSS=VSS
XU175 nr02d0 $PINS A1=n219 A2=n227 ZN=n144 VDD=VDD VSS=VSS
XU176 nr02d0 $PINS A1=n218 A2=n227 ZN=n143 VDD=VDD VSS=VSS
XU177 nr02d0 $PINS A1=n217 A2=n227 ZN=n142 VDD=VDD VSS=VSS
XU178 nr02d0 $PINS A1=n216 A2=n227 ZN=n141 VDD=VDD VSS=VSS
XU179 nr02d0 $PINS A1=n215 A2=n227 ZN=n140 VDD=VDD VSS=VSS
XU180 nr02d0 $PINS A1=n214 A2=n227 ZN=n139 VDD=VDD VSS=VSS
XU181 nr02d0 $PINS A1=n221 A2=n226 ZN=n138 VDD=VDD VSS=VSS
XU182 nr02d0 $PINS A1=n220 A2=n226 ZN=n137 VDD=VDD VSS=VSS
XU183 nr02d0 $PINS A1=n219 A2=n226 ZN=n136 VDD=VDD VSS=VSS
XU184 nr02d0 $PINS A1=n218 A2=n226 ZN=n135 VDD=VDD VSS=VSS
XU185 nr02d0 $PINS A1=n217 A2=n226 ZN=n134 VDD=VDD VSS=VSS
XU186 nr02d0 $PINS A1=n216 A2=n226 ZN=n133 VDD=VDD VSS=VSS
XU187 nr02d0 $PINS A1=n215 A2=n226 ZN=n132 VDD=VDD VSS=VSS
XU188 nr02d0 $PINS A1=n214 A2=n226 ZN=n131 VDD=VDD VSS=VSS
XU189 nr02d0 $PINS A1=n221 A2=n225 ZN=n130 VDD=VDD VSS=VSS
XU190 nr02d0 $PINS A1=n220 A2=n225 ZN=n129 VDD=VDD VSS=VSS
XU191 nr02d0 $PINS A1=n219 A2=n225 ZN=n128 VDD=VDD VSS=VSS
XU192 nr02d0 $PINS A1=n218 A2=n225 ZN=n127 VDD=VDD VSS=VSS
XU193 nr02d0 $PINS A1=n217 A2=n225 ZN=n126 VDD=VDD VSS=VSS
XU194 nr02d0 $PINS A1=n216 A2=n225 ZN=n125 VDD=VDD VSS=VSS
XU195 nr02d0 $PINS A1=n215 A2=n225 ZN=n124 VDD=VDD VSS=VSS
XU196 nr02d0 $PINS A1=n214 A2=n225 ZN=n123 VDD=VDD VSS=VSS
XU197 nr02d0 $PINS A1=n221 A2=n224 ZN=n122 VDD=VDD VSS=VSS
XU198 nr02d0 $PINS A1=n220 A2=n224 ZN=n121 VDD=VDD VSS=VSS
XU199 nr02d0 $PINS A1=n219 A2=n224 ZN=n120 VDD=VDD VSS=VSS
XU200 nr02d0 $PINS A1=n218 A2=n224 ZN=n119 VDD=VDD VSS=VSS
XU201 nr02d0 $PINS A1=n217 A2=n224 ZN=n118 VDD=VDD VSS=VSS
XU202 nr02d0 $PINS A1=n216 A2=n224 ZN=n117 VDD=VDD VSS=VSS
XU203 nr02d0 $PINS A1=n215 A2=n224 ZN=n116 VDD=VDD VSS=VSS
XU204 nr02d0 $PINS A1=n214 A2=n224 ZN=n115 VDD=VDD VSS=VSS
XU205 nr02d0 $PINS A1=n221 A2=n223 ZN=n114 VDD=VDD VSS=VSS
XU206 nr02d0 $PINS A1=n220 A2=n223 ZN=n113 VDD=VDD VSS=VSS
XU207 nr02d0 $PINS A1=n219 A2=n223 ZN=n112 VDD=VDD VSS=VSS
XU208 nr02d0 $PINS A1=n218 A2=n223 ZN=n111 VDD=VDD VSS=VSS
XU209 nr02d0 $PINS A1=n217 A2=n223 ZN=n110 VDD=VDD VSS=VSS
XU210 nr02d0 $PINS A1=n216 A2=n223 ZN=n109 VDD=VDD VSS=VSS
XU211 nr02d0 $PINS A1=n215 A2=n223 ZN=n108 VDD=VDD VSS=VSS
XU212 nr02d0 $PINS A1=n214 A2=n223 ZN=n107 VDD=VDD VSS=VSS
XU213 nr02d0 $PINS A1=n221 A2=n222 ZN=n106 VDD=VDD VSS=VSS
XU214 nr02d0 $PINS A1=n222 A2=n220 ZN=n105 VDD=VDD VSS=VSS
XU215 nr02d0 $PINS A1=n222 A2=n219 ZN=n104 VDD=VDD VSS=VSS
XU216 nr02d0 $PINS A1=n222 A2=n218 ZN=n103 VDD=VDD VSS=VSS
XU217 nr02d0 $PINS A1=n222 A2=n217 ZN=n102 VDD=VDD VSS=VSS
XU218 nr02d0 $PINS A1=n222 A2=n216 ZN=n101 VDD=VDD VSS=VSS
XU219 nr02d0 $PINS A1=n222 A2=n215 ZN=n100 VDD=VDD VSS=VSS
.ENDS

.SUBCKT unpu_pe_1_DW01_add_0_DW01_add_2 A[31] A[30] A[29] A[28] A[27] A[26]
+ A[25] A[24] A[23] A[22] A[21] A[20] A[19] A[18] A[17] A[16] A[15] A[14] A[13]
+ A[12] A[11] A[10] A[9] A[8] A[7] A[6] A[5] A[4] A[3] A[2] A[1] A[0] B[31]
+ B[30] B[29] B[28] B[27] B[26] B[25] B[24] B[23] B[22] B[21] B[20] B[19] B[18]
+ B[17] B[16] B[15] B[14] B[13] B[12] B[11] B[10] B[9] B[8] B[7] B[6] B[5] B[4]
+ B[3] B[2] B[1] B[0] CI SUM[31] SUM[30] SUM[29] SUM[28] SUM[27] SUM[26]
+ SUM[25] SUM[24] SUM[23] SUM[22] SUM[21] SUM[20] SUM[19] SUM[18] SUM[17]
+ SUM[16] SUM[15] SUM[14] SUM[13] SUM[12] SUM[11] SUM[10] SUM[9] SUM[8] SUM[7]
+ SUM[6] SUM[5] SUM[4] SUM[3] SUM[2] SUM[1] SUM[0] CO VDD VSS
XU1_31 ad01d0 $PINS A=copt_net_1656 B=B[31] CI=carry[31] S=SUM[31] VDD=VDD
+ VSS=VSS
XU1_30 ad01d0 $PINS A=copt_net_1253 B=B[30] CI=carry[30] CO=carry[31] S=SUM[30]
+ VDD=VDD VSS=VSS
XU1_29 ad01d0 $PINS A=copt_net_1566 B=B[29] CI=carry[29] CO=carry[30] S=SUM[29]
+ VDD=VDD VSS=VSS
XU1_28 ad01d0 $PINS A=copt_net_2123 B=B[28] CI=carry[28] CO=carry[29] S=SUM[28]
+ VDD=VDD VSS=VSS
XU1_27 ad01d0 $PINS A=copt_net_1538 B=B[27] CI=carry[27] CO=carry[28] S=SUM[27]
+ VDD=VDD VSS=VSS
XU1_26 ad01d0 $PINS A=copt_net_1227 B=B[26] CI=carry[26] CO=carry[27] S=SUM[26]
+ VDD=VDD VSS=VSS
XU1_25 ad01d0 $PINS A=copt_net_1363 B=B[25] CI=carry[25] CO=carry[26] S=SUM[25]
+ VDD=VDD VSS=VSS
XU1_24 ad01d0 $PINS A=copt_net_1927 B=B[24] CI=carry[24] CO=carry[25] S=SUM[24]
+ VDD=VDD VSS=VSS
XU1_23 ad01d0 $PINS A=copt_net_1396 B=B[23] CI=carry[23] CO=carry[24] S=SUM[23]
+ VDD=VDD VSS=VSS
XU1_22 ad01d0 $PINS A=copt_net_1494 B=B[22] CI=carry[22] CO=carry[23] S=SUM[22]
+ VDD=VDD VSS=VSS
XU1_21 ad01d0 $PINS A=copt_net_1646 B=B[21] CI=carry[21] CO=carry[22] S=SUM[21]
+ VDD=VDD VSS=VSS
XU1_20 ad01d0 $PINS A=copt_net_1652 B=B[20] CI=carry[20] CO=carry[21] S=SUM[20]
+ VDD=VDD VSS=VSS
XU1_19 ad01d0 $PINS A=copt_net_2234 B=B[19] CI=carry[19] CO=carry[20] S=SUM[19]
+ VDD=VDD VSS=VSS
XU1_18 ad01d0 $PINS A=copt_net_2693 B=B[18] CI=carry[18] CO=carry[19] S=SUM[18]
+ VDD=VDD VSS=VSS
XU1_17 ad01d0 $PINS A=A[17] B=B[17] CI=carry[17] CO=carry[18] S=SUM[17] VDD=VDD
+ VSS=VSS
XU1_16 ad01d0 $PINS A=A[16] B=B[16] CI=carry[16] CO=carry[17] S=SUM[16] VDD=VDD
+ VSS=VSS
XU1_15 ad01d0 $PINS A=A[15] B=B[15] CI=carry[15] CO=carry[16] S=SUM[15] VDD=VDD
+ VSS=VSS
XU1_14 ad01d0 $PINS A=A[14] B=B[14] CI=carry[14] CO=carry[15] S=SUM[14] VDD=VDD
+ VSS=VSS
XU1_13 ad01d0 $PINS A=copt_net_2834 B=B[13] CI=carry[13] CO=carry[14] S=SUM[13]
+ VDD=VDD VSS=VSS
XU1_12 ad01d0 $PINS A=copt_net_2841 B=B[12] CI=carry[12] CO=carry[13] S=SUM[12]
+ VDD=VDD VSS=VSS
XU1_11 ad01d0 $PINS A=copt_net_2840 B=B[11] CI=carry[11] CO=carry[12] S=SUM[11]
+ VDD=VDD VSS=VSS
XU1_10 ad01d0 $PINS A=A[10] B=B[10] CI=carry[10] CO=carry[11] S=SUM[10] VDD=VDD
+ VSS=VSS
XU1_9 ad01d0 $PINS A=A[9] B=B[9] CI=carry[9] CO=carry[10] S=SUM[9] VDD=VDD
+ VSS=VSS
XU1_8 ad01d0 $PINS A=A[8] B=B[8] CI=carry[8] CO=carry[9] S=SUM[8] VDD=VDD
+ VSS=VSS
XU1_7 ad01d0 $PINS A=A[7] B=B[7] CI=carry[7] CO=carry[8] S=SUM[7] VDD=VDD
+ VSS=VSS
XU1_6 ad01d0 $PINS A=A[6] B=B[6] CI=carry[6] CO=carry[7] S=SUM[6] VDD=VDD
+ VSS=VSS
XU1_5 ad01d0 $PINS A=A[5] B=B[5] CI=carry[5] CO=carry[6] S=SUM[5] VDD=VDD
+ VSS=VSS
XU1_4 ad01d0 $PINS A=A[4] B=B[4] CI=carry[4] CO=carry[5] S=SUM[4] VDD=VDD
+ VSS=VSS
XU1_3 ad01d0 $PINS A=A[3] B=B[3] CI=carry[3] CO=carry[4] S=SUM[3] VDD=VDD
+ VSS=VSS
XU1_2 ad01d0 $PINS A=A[2] B=B[2] CI=carry[2] CO=carry[3] S=SUM[2] VDD=VDD
+ VSS=VSS
XU1_1 ad01d0 $PINS A=A[1] B=B[1] CI=n1 CO=carry[2] S=SUM[1] VDD=VDD VSS=VSS
XU1 an02d1 $PINS A1=B[0] A2=A[0] Z=n1 VDD=VDD VSS=VSS
XU2 xr02d1 $PINS A1=A[0] A2=B[0] Z=SUM[0] VDD=VDD VSS=VSS
Xcopt_h_inst_4059 dl01d1 $PINS I=A[26] Z=copt_net_1227 VDD=VDD VSS=VSS
Xcopt_h_inst_4085 dl02d1 $PINS I=A[30] Z=copt_net_1253 VDD=VDD VSS=VSS
Xcopt_h_inst_4195 dl01d1 $PINS I=A[25] Z=copt_net_1363 VDD=VDD VSS=VSS
Xcopt_h_inst_4228 dl01d1 $PINS I=A[23] Z=copt_net_1396 VDD=VDD VSS=VSS
Xcopt_h_inst_4326 dl01d1 $PINS I=A[22] Z=copt_net_1494 VDD=VDD VSS=VSS
Xcopt_h_inst_4370 dl02d1 $PINS I=A[27] Z=copt_net_1538 VDD=VDD VSS=VSS
Xcopt_h_inst_4398 dl01d1 $PINS I=A[29] Z=copt_net_1566 VDD=VDD VSS=VSS
Xcopt_h_inst_4478 dl01d1 $PINS I=A[21] Z=copt_net_1646 VDD=VDD VSS=VSS
Xcopt_h_inst_4484 dl01d1 $PINS I=A[20] Z=copt_net_1652 VDD=VDD VSS=VSS
Xcopt_h_inst_4488 dl01d1 $PINS I=A[31] Z=copt_net_1656 VDD=VDD VSS=VSS
Xcopt_h_inst_4759 dl01d1 $PINS I=A[24] Z=copt_net_1927 VDD=VDD VSS=VSS
Xcopt_h_inst_4956 dl01d1 $PINS I=A[28] Z=copt_net_2123 VDD=VDD VSS=VSS
Xcopt_h_inst_5067 dl01d1 $PINS I=A[19] Z=copt_net_2234 VDD=VDD VSS=VSS
Xcopt_h_inst_5526 dl01d1 $PINS I=A[18] Z=copt_net_2693 VDD=VDD VSS=VSS
Xcopt_h_inst_5668 dl01d1 $PINS I=A[13] Z=copt_net_2834 VDD=VDD VSS=VSS
Xcopt_h_inst_5674 dl01d1 $PINS I=A[11] Z=copt_net_2840 VDD=VDD VSS=VSS
Xcopt_h_inst_5675 dl01d1 $PINS I=A[12] Z=copt_net_2841 VDD=VDD VSS=VSS
.ENDS

.SUBCKT unpu_pe_1 ZCTSNET_13 rst_n array_en weight_load mode_unsigned
+ weight_in[7] weight_in[6] weight_in[5] weight_in[4] weight_in[3] weight_in[2]
+ weight_in[1] weight_in[0] act_in[7] act_in[6] act_in[5] act_in[4] act_in[3]
+ act_in[2] act_in[1] act_in[0] psum_in[31] psum_in[30] psum_in[29] psum_in[28]
+ psum_in[27] psum_in[26] psum_in[25] psum_in[24] psum_in[23] psum_in[22]
+ psum_in[21] psum_in[20] psum_in[19] psum_in[18] psum_in[17] psum_in[16]
+ psum_in[15] psum_in[14] psum_in[13] psum_in[12] psum_in[11] psum_in[10]
+ psum_in[9] psum_in[8] psum_in[7] psum_in[6] psum_in[5] psum_in[4] psum_in[3]
+ psum_in[2] psum_in[1] psum_in[0] act_out[7] act_out[6] act_out[5] act_out[4]
+ act_out[3] act_out[2] act_out[1] act_out[0] psum_out[31] psum_out[30]
+ psum_out[29] psum_out[28] psum_out[27] psum_out[26] psum_out[25] psum_out[24]
+ psum_out[23] psum_out[22] psum_out[21] psum_out[20] psum_out[19] psum_out[18]
+ psum_out[17] psum_out[16] psum_out[15] psum_out[14] psum_out[13] psum_out[12]
+ psum_out[11] psum_out[10] psum_out[9] psum_out[8] psum_out[7] psum_out[6]
+ psum_out[5] psum_out[4] psum_out[3] psum_out[2] psum_out[1] psum_out[0] VDD
+ VSS ZCTSNET_15 ZCTSNET_2 HFSNET_3 HFSNET_4 HFSNET_7 HFSNET_8 HFSNET_9
+ HFSNET_10 HFSNET_11 HFSNET_12 ZCTSNET_0
XU2 aor22d1 $PINS A1=N_uc_30 A2=mode_unsigned B1=HFSNET_3 B2=N_uc_14
+ Z=product[9] VDD=VDD VSS=VSS
XU3 aor22d1 $PINS A1=N_uc_29 A2=mode_unsigned B1=N_uc_13 B2=HFSNET_3
+ Z=product[8] VDD=VDD VSS=VSS
XU5 aor22d1 $PINS A1=N_uc_28 A2=mode_unsigned B1=N_uc_12 B2=HFSNET_3
+ Z=product[7] VDD=VDD VSS=VSS
XU6 aor22d1 $PINS A1=N_uc_27 A2=mode_unsigned B1=N_uc_11 B2=HFSNET_3
+ Z=product[6] VDD=VDD VSS=VSS
XU7 aor22d1 $PINS A1=N_uc_26 A2=mode_unsigned B1=N_uc_10 B2=HFSNET_3
+ Z=product[5] VDD=VDD VSS=VSS
XU8 aor22d1 $PINS A1=N_uc_9 A2=HFSNET_3 B1=N_uc_25 B2=mode_unsigned
+ Z=product[4] VDD=VDD VSS=VSS
XU9 aor22d1 $PINS A1=N_uc_8 A2=HFSNET_3 B1=N_uc_24 B2=mode_unsigned
+ Z=product[3] VDD=VDD VSS=VSS
XU10 aor22d1 $PINS A1=N_uc_7 A2=HFSNET_3 B1=N_uc_23 B2=mode_unsigned
+ Z=product[2] VDD=VDD VSS=VSS
XU11 aor22d1 $PINS A1=N_uc_6 A2=HFSNET_3 B1=N_uc_22 B2=mode_unsigned
+ Z=product[1] VDD=VDD VSS=VSS
XU12 oaim21d1 $PINS B1=N_uc_20 B2=HFSNET_3 A=n14 ZN=product[15] VDD=VDD VSS=VSS
XU13 aor22d1 $PINS A1=N_uc_35 A2=mode_unsigned B1=N_uc_19 B2=HFSNET_3
+ Z=product[14] VDD=VDD VSS=VSS
XU14 aor22d1 $PINS A1=N_uc_34 A2=mode_unsigned B1=N_uc_18 B2=HFSNET_3
+ Z=product[13] VDD=VDD VSS=VSS
XU15 aor22d1 $PINS A1=N_uc_33 A2=mode_unsigned B1=N_uc_17 B2=HFSNET_3
+ Z=product[12] VDD=VDD VSS=VSS
XU16 aor22d1 $PINS A1=N_uc_32 A2=mode_unsigned B1=N_uc_16 B2=HFSNET_3
+ Z=product[11] VDD=VDD VSS=VSS
XU17 aor22d1 $PINS A1=N_uc_31 A2=mode_unsigned B1=N_uc_15 B2=HFSNET_3
+ Z=product[10] VDD=VDD VSS=VSS
XU18 aor22d1 $PINS A1=N_uc_5 A2=HFSNET_3 B1=N_uc_21 B2=mode_unsigned
+ Z=product[0] VDD=VDD VSS=VSS
Xadd_42 unpu_pe_1_DW01_add_0_DW01_add_2 $PINS A[31]=psum_in[31]
+ A[30]=psum_in[30] A[29]=psum_in[29] A[28]=psum_in[28] A[27]=psum_in[27]
+ A[26]=psum_in[26] A[25]=psum_in[25] A[24]=psum_in[24] A[23]=psum_in[23]
+ A[22]=psum_in[22] A[21]=psum_in[21] A[20]=psum_in[20] A[19]=psum_in[19]
+ A[18]=psum_in[18] A[17]=psum_in[17] A[16]=psum_in[16] A[15]=psum_in[15]
+ A[14]=psum_in[14] A[13]=psum_in[13] A[12]=psum_in[12] A[11]=psum_in[11]
+ A[10]=psum_in[10] A[9]=psum_in[9] A[8]=psum_in[8] A[7]=psum_in[7]
+ A[6]=psum_in[6] A[5]=psum_in[5] A[4]=psum_in[4] A[3]=psum_in[3] A[2]=psum_in[2]
+ A[1]=psum_in[1] A[0]=psum_in[0] B[31]=n2 B[30]=n2 B[29]=n2 B[28]=n2 B[27]=n2
+ B[26]=n2 B[25]=n2 B[24]=n2 B[23]=n2 B[22]=n2 B[21]=n2 B[20]=n2 B[19]=n2
+ B[18]=n2 B[17]=n2 B[16]=n2 B[15]=product[15] B[14]=product[14]
+ B[13]=product[13] B[12]=product[12] B[11]=product[11] B[10]=product[10]
+ B[9]=product[9] B[8]=product[8] B[7]=product[7] B[6]=product[6] B[5]=product[5]
+ B[4]=product[4] B[3]=product[3] B[2]=product[2] B[1]=product[1] B[0]=product[0]
+ CI=VSS SUM[31]=N_uc_71 SUM[30]=N_uc_70 SUM[29]=N_uc_69 SUM[28]=N_uc_68
+ SUM[27]=N_uc_67 SUM[26]=N_uc_66 SUM[25]=N_uc_65 SUM[24]=N_uc_64 SUM[23]=N_uc_63
+ SUM[22]=N_uc_62 SUM[21]=N_uc_61 SUM[20]=N_uc_60 SUM[19]=N_uc_59 SUM[18]=N_uc_58
+ SUM[17]=N_uc_57 SUM[16]=N_uc_56 SUM[15]=N_uc_55 SUM[14]=N_uc_54 SUM[13]=N_uc_53
+ SUM[12]=N_uc_52 SUM[11]=N_uc_51 SUM[10]=N_uc_50 SUM[9]=N_uc_49 SUM[8]=N_uc_48
+ SUM[7]=N_uc_47 SUM[6]=N_uc_46 SUM[5]=N_uc_45 SUM[4]=N_uc_44 SUM[3]=N_uc_43
+ SUM[2]=N_uc_42 SUM[1]=N_uc_41 SUM[0]=N_uc_40 VDD=VDD VSS=VSS
Xmult_28 unpu_pe_1_DW_mult_uns_0_DW_mult_uns_2 $PINS a[7]=weight_reg[7]
+ a[6]=weight_reg[6] a[5]=weight_reg[5] a[4]=weight_reg[4] a[3]=weight_reg[3]
+ a[2]=weight_reg[2] a[1]=weight_reg[1] a[0]=gre_a_INV_1520_3 b[7]=act_in[7]
+ b[6]=act_in[6] b[5]=act_in[5] b[4]=act_in[4] b[3]=act_in[3] b[2]=act_in[2]
+ b[1]=act_in[1] b[0]=act_in[0] product[15]=N_uc_20 product[14]=N_uc_19
+ product[13]=N_uc_18 product[12]=N_uc_17 product[11]=N_uc_16 product[10]=N_uc_15
+ product[9]=N_uc_14 product[8]=N_uc_13 product[7]=N_uc_12 product[6]=N_uc_11
+ product[5]=N_uc_10 product[4]=N_uc_9 product[3]=N_uc_8 product[2]=N_uc_7
+ product[1]=N_uc_6 product[0]=N_uc_5 VDD=VDD VSS=VSS
Xmult_30 unpu_pe_1_DW_mult_tc_0_DW_mult_tc_1 $PINS a[7]=weight_reg[7]
+ a[6]=weight_reg[6] a[5]=weight_reg[5] a[4]=weight_reg[4] a[3]=weight_reg[3]
+ a[2]=weight_reg[2] a[1]=weight_reg[1] a[0]=gre_a_INV_1520_3 b[7]=act_in[7]
+ b[6]=act_in[6] b[5]=act_in[5] b[4]=act_in[4] b[3]=act_in[3] b[2]=act_in[2]
+ b[1]=act_in[1] b[0]=act_in[0] product[15]=N_uc_36 product[14]=N_uc_35
+ product[13]=N_uc_34 product[12]=N_uc_33 product[11]=N_uc_32 product[10]=N_uc_31
+ product[9]=N_uc_30 product[8]=N_uc_29 product[7]=N_uc_28 product[6]=N_uc_27
+ product[5]=N_uc_26 product[4]=N_uc_25 product[3]=N_uc_24 product[2]=N_uc_23
+ product[1]=N_uc_22 product[0]=N_uc_21 VDD=VDD VSS=VSS
Xact_out_reg_3_ decrq1 $PINS D=copt_net_2858 ENN=array_en CP=ZCTSNET_13
+ CDN=HFSNET_9 Q=act_out[3] VDD=VDD VSS=VSS
Xact_out_reg_2_ decrq1 $PINS D=copt_net_2859 ENN=HFSNET_4 CP=ZCTSNET_2
+ CDN=rst_n Q=act_out[2] VDD=VDD VSS=VSS
Xact_out_reg_1_ decrq1 $PINS D=copt_net_2861 ENN=HFSNET_4 CP=ZCTSNET_2
+ CDN=rst_n Q=act_out[1] VDD=VDD VSS=VSS
Xact_out_reg_7_ decrq1 $PINS D=copt_net_2862 ENN=array_en CP=ZCTSNET_13
+ CDN=HFSNET_12 Q=act_out[7] VDD=VDD VSS=VSS
Xact_out_reg_6_ decrq1 $PINS D=copt_net_2866 ENN=array_en CP=ZCTSNET_0
+ CDN=HFSNET_12 Q=act_out[6] VDD=VDD VSS=VSS
Xact_out_reg_5_ decrq1 $PINS D=copt_net_2867 ENN=array_en CP=ZCTSNET_0
+ CDN=HFSNET_12 Q=act_out[5] VDD=VDD VSS=VSS
Xact_out_reg_4_ decrq1 $PINS D=copt_net_2860 ENN=array_en CP=ZCTSNET_13
+ CDN=HFSNET_12 Q=act_out[4] VDD=VDD VSS=VSS
Xact_out_reg_0_ decrq1 $PINS D=copt_net_2864 ENN=HFSNET_4 CP=ZCTSNET_2
+ CDN=rst_n Q=act_out[0] VDD=VDD VSS=VSS
Xpsum_out_reg_4_ decrq1 $PINS D=copt_net_1258 ENN=HFSNET_6 CP=ZCTSNET_15
+ CDN=HFSNET_11 Q=psum_out[4] VDD=VDD VSS=VSS
Xpsum_out_reg_3_ decrq1 $PINS D=copt_net_2545 ENN=HFSNET_6 CP=ZCTSNET_15
+ CDN=HFSNET_11 Q=psum_out[3] VDD=VDD VSS=VSS
Xpsum_out_reg_2_ decrq1 $PINS D=copt_net_2567 ENN=HFSNET_6 CP=ZCTSNET_15
+ CDN=HFSNET_11 Q=psum_out[2] VDD=VDD VSS=VSS
Xpsum_out_reg_1_ decrq1 $PINS D=copt_net_2585 ENN=HFSNET_6 CP=ZCTSNET_15
+ CDN=HFSNET_11 Q=psum_out[1] VDD=VDD VSS=VSS
Xpsum_out_reg_0_ decrq1 $PINS D=copt_net_1373 ENN=HFSNET_6 CP=ZCTSNET_15
+ CDN=HFSNET_11 Q=psum_out[0] VDD=VDD VSS=VSS
Xpsum_out_reg_5_ decrq1 $PINS D=copt_net_2516 ENN=HFSNET_6 CP=ZCTSNET_15
+ CDN=HFSNET_11 Q=psum_out[5] VDD=VDD VSS=VSS
Xpsum_out_reg_6_ decrq1 $PINS D=copt_net_2769 ENN=HFSNET_6 CP=ZCTSNET_15
+ CDN=HFSNET_10 Q=psum_out[6] VDD=VDD VSS=VSS
Xpsum_out_reg_7_ decrq1 $PINS D=copt_net_1018 ENN=HFSNET_6 CP=ZCTSNET_15
+ CDN=HFSNET_11 Q=psum_out[7] VDD=VDD VSS=VSS
Xpsum_out_reg_8_ decrq1 $PINS D=copt_net_2830 ENN=HFSNET_4 CP=ZCTSNET_15
+ CDN=rst_n Q=psum_out[8] VDD=VDD VSS=VSS
Xweight_reg_reg_7_ decrq1 $PINS D=weight_in[7] ENN=n13 CP=ZCTSNET_15
+ CDN=HFSNET_11 Q=weight_reg[7] VDD=VDD VSS=VSS
Xweight_reg_reg_6_ decrq1 $PINS D=weight_in[6] ENN=n13 CP=ZCTSNET_15
+ CDN=HFSNET_11 Q=weight_reg[6] VDD=VDD VSS=VSS
Xweight_reg_reg_5_ decrq1 $PINS D=weight_in[5] ENN=n13 CP=ZCTSNET_15
+ CDN=HFSNET_11 Q=weight_reg[5] VDD=VDD VSS=VSS
Xweight_reg_reg_4_ decrq1 $PINS D=weight_in[4] ENN=n13 CP=ZCTSNET_15
+ CDN=HFSNET_11 Q=weight_reg[4] VDD=VDD VSS=VSS
Xweight_reg_reg_3_ decrq1 $PINS D=weight_in[3] ENN=n13 CP=ZCTSNET_15
+ CDN=HFSNET_11 Q=weight_reg[3] VDD=VDD VSS=VSS
Xweight_reg_reg_2_ decrq1 $PINS D=weight_in[2] ENN=n13 CP=ZCTSNET_15
+ CDN=HFSNET_11 Q=weight_reg[2] VDD=VDD VSS=VSS
Xweight_reg_reg_1_ decrq1 $PINS D=weight_in[1] ENN=n13 CP=ZCTSNET_15
+ CDN=HFSNET_11 Q=weight_reg[1] VDD=VDD VSS=VSS
Xweight_reg_reg_0_ decrq1 $PINS D=weight_in[0] ENN=n13 CP=ZCTSNET_15
+ CDN=HFSNET_11 Q=weight_reg[0] VDD=VDD VSS=VSS
Xpsum_out_reg_9_ decrq1 $PINS D=copt_net_2505 ENN=HFSNET_4 CP=ZCTSNET_15
+ CDN=HFSNET_11 Q=psum_out[9] VDD=VDD VSS=VSS
Xpsum_out_reg_10_ decrq1 $PINS D=copt_net_2765 ENN=HFSNET_6 CP=ZCTSNET_15
+ CDN=HFSNET_11 Q=psum_out[10] VDD=VDD VSS=VSS
Xpsum_out_reg_11_ decrq1 $PINS D=N_uc_51 ENN=HFSNET_6 CP=ZCTSNET_15
+ CDN=HFSNET_11 Q=psum_out[11] VDD=VDD VSS=VSS
Xpsum_out_reg_12_ decrq1 $PINS D=N_uc_52 ENN=HFSNET_8 CP=ZCTSNET_15
+ CDN=HFSNET_10 Q=psum_out[12] VDD=VDD VSS=VSS
Xpsum_out_reg_13_ decrq1 $PINS D=N_uc_53 ENN=HFSNET_4 CP=ZCTSNET_2 CDN=rst_n
+ Q=psum_out[13] VDD=VDD VSS=VSS
Xpsum_out_reg_14_ decrq1 $PINS D=copt_net_2442 ENN=HFSNET_6 CP=ZCTSNET_15
+ CDN=HFSNET_11 Q=psum_out[14] VDD=VDD VSS=VSS
Xpsum_out_reg_15_ decrq1 $PINS D=copt_net_2426 ENN=HFSNET_6 CP=ZCTSNET_15
+ CDN=HFSNET_11 Q=psum_out[15] VDD=VDD VSS=VSS
Xpsum_out_reg_16_ decrq1 $PINS D=copt_net_2760 ENN=HFSNET_6 CP=ZCTSNET_15
+ CDN=HFSNET_11 Q=psum_out[16] VDD=VDD VSS=VSS
Xpsum_out_reg_17_ decrq1 $PINS D=copt_net_2415 ENN=HFSNET_6 CP=ZCTSNET_15
+ CDN=HFSNET_11 Q=psum_out[17] VDD=VDD VSS=VSS
Xpsum_out_reg_18_ decrq1 $PINS D=copt_net_969 ENN=HFSNET_6 CP=ZCTSNET_15
+ CDN=HFSNET_11 Q=psum_out[18] VDD=VDD VSS=VSS
Xpsum_out_reg_19_ decrq1 $PINS D=N_uc_59 ENN=HFSNET_6 CP=ZCTSNET_15
+ CDN=HFSNET_11 Q=psum_out[19] VDD=VDD VSS=VSS
Xpsum_out_reg_20_ decrq1 $PINS D=N_uc_60 ENN=HFSNET_6 CP=ZCTSNET_15
+ CDN=HFSNET_11 Q=psum_out[20] VDD=VDD VSS=VSS
Xpsum_out_reg_21_ decrq1 $PINS D=N_uc_61 ENN=HFSNET_6 CP=ZCTSNET_15
+ CDN=HFSNET_11 Q=psum_out[21] VDD=VDD VSS=VSS
Xpsum_out_reg_22_ decrq1 $PINS D=N_uc_62 ENN=HFSNET_6 CP=ZCTSNET_15
+ CDN=HFSNET_11 Q=psum_out[22] VDD=VDD VSS=VSS
Xpsum_out_reg_23_ decrq1 $PINS D=N_uc_63 ENN=HFSNET_6 CP=ZCTSNET_15
+ CDN=HFSNET_11 Q=psum_out[23] VDD=VDD VSS=VSS
Xpsum_out_reg_24_ decrq1 $PINS D=N_uc_64 ENN=HFSNET_4 CP=ZCTSNET_15
+ CDN=HFSNET_11 Q=psum_out[24] VDD=VDD VSS=VSS
Xpsum_out_reg_25_ decrq1 $PINS D=N_uc_65 ENN=HFSNET_4 CP=ZCTSNET_15 CDN=rst_n
+ Q=psum_out[25] VDD=VDD VSS=VSS
Xpsum_out_reg_26_ decrq1 $PINS D=N_uc_66 ENN=HFSNET_4 CP=ZCTSNET_15 CDN=rst_n
+ Q=psum_out[26] VDD=VDD VSS=VSS
Xpsum_out_reg_27_ decrq1 $PINS D=N_uc_67 ENN=HFSNET_4 CP=ZCTSNET_15 CDN=rst_n
+ Q=psum_out[27] VDD=VDD VSS=VSS
Xpsum_out_reg_28_ decrq1 $PINS D=N_uc_68 ENN=HFSNET_4 CP=ZCTSNET_15 CDN=rst_n
+ Q=psum_out[28] VDD=VDD VSS=VSS
Xpsum_out_reg_29_ decrq1 $PINS D=N_uc_69 ENN=HFSNET_4 CP=ZCTSNET_2 CDN=rst_n
+ Q=psum_out[29] VDD=VDD VSS=VSS
Xpsum_out_reg_30_ decrq1 $PINS D=N_uc_70 ENN=HFSNET_6 CP=ZCTSNET_15
+ CDN=HFSNET_11 Q=psum_out[30] VDD=VDD VSS=VSS
Xpsum_out_reg_31_ decrq1 $PINS D=N_uc_71 ENN=HFSNET_4 CP=ZCTSNET_15 CDN=rst_n
+ Q=psum_out[31] VDD=VDD VSS=VSS
XU19 inv0d2 $PINS I=n14 ZN=n2 VDD=VDD VSS=VSS
Xcopt_h_inst_3801 dl02d1 $PINS I=N_uc_58 Z=copt_net_969 VDD=VDD VSS=VSS
XHFSINV_60494_582 inv0d1 $PINS I=HFSNET_7 ZN=HFSNET_6 VDD=VDD VSS=VSS
XU22 nd02d1 $PINS A1=weight_load A2=HFSNET_7 ZN=n13 VDD=VDD VSS=VSS
Xcopt_h_inst_3850 dl02d1 $PINS I=N_uc_47 Z=copt_net_1018 VDD=VDD VSS=VSS
Xcopt_h_inst_4090 dl01d1 $PINS I=N_uc_44 Z=copt_net_1258 VDD=VDD VSS=VSS
Xcopt_h_inst_4205 dl01d1 $PINS I=N_uc_40 Z=copt_net_1373 VDD=VDD VSS=VSS
Xcopt_h_inst_5248 dl02d1 $PINS I=N_uc_57 Z=copt_net_2415 VDD=VDD VSS=VSS
XU27 nd02d1 $PINS A1=N_uc_36 A2=mode_unsigned ZN=n14 VDD=VDD VSS=VSS
Xcopt_h_inst_5259 dl01d1 $PINS I=N_uc_55 Z=copt_net_2426 VDD=VDD VSS=VSS
Xcopt_h_inst_5275 dl01d1 $PINS I=N_uc_54 Z=copt_net_2442 VDD=VDD VSS=VSS
Xcopt_h_inst_5338 dl01d1 $PINS I=N_uc_49 Z=copt_net_2505 VDD=VDD VSS=VSS
Xcopt_h_inst_5349 dl01d1 $PINS I=N_uc_45 Z=copt_net_2516 VDD=VDD VSS=VSS
Xcopt_h_inst_5378 dl01d1 $PINS I=N_uc_43 Z=copt_net_2545 VDD=VDD VSS=VSS
Xcopt_h_inst_5400 dl01d1 $PINS I=N_uc_42 Z=copt_net_2567 VDD=VDD VSS=VSS
Xcopt_h_inst_5418 dl01d1 $PINS I=N_uc_41 Z=copt_net_2585 VDD=VDD VSS=VSS
Xcopt_h_inst_5593 dl01d1 $PINS I=N_uc_56 Z=copt_net_2760 VDD=VDD VSS=VSS
Xcopt_h_inst_5598 dl01d1 $PINS I=N_uc_50 Z=copt_net_2765 VDD=VDD VSS=VSS
Xcopt_h_inst_5602 dl01d1 $PINS I=N_uc_46 Z=copt_net_2769 VDD=VDD VSS=VSS
Xcopt_h_inst_5664 dl01d1 $PINS I=N_uc_48 Z=copt_net_2830 VDD=VDD VSS=VSS
Xcopt_h_inst_5692 dl01d1 $PINS I=act_in[3] Z=copt_net_2858 VDD=VDD VSS=VSS
Xcopt_h_inst_5693 dl01d1 $PINS I=act_in[2] Z=copt_net_2859 VDD=VDD VSS=VSS
Xcopt_h_inst_5694 dl01d1 $PINS I=act_in[4] Z=copt_net_2860 VDD=VDD VSS=VSS
Xcopt_h_inst_5695 dl01d1 $PINS I=act_in[1] Z=copt_net_2861 VDD=VDD VSS=VSS
Xcopt_h_inst_5696 dl01d1 $PINS I=act_in[7] Z=copt_net_2862 VDD=VDD VSS=VSS
Xcopt_h_inst_5698 dl01d1 $PINS I=act_in[0] Z=copt_net_2864 VDD=VDD VSS=VSS
Xcopt_h_inst_5700 dl01d1 $PINS I=act_in[6] Z=copt_net_2866 VDD=VDD VSS=VSS
Xcopt_h_inst_5701 dl01d1 $PINS I=act_in[5] Z=copt_net_2867 VDD=VDD VSS=VSS
Xgre_a_INV_1520_inst_5843 inv0d1 $PINS I=weight_reg[0] ZN=gre_a_INV_1520_3
+ VDD=VDD VSS=VSS
.ENDS

.SUBCKT unpu_pe_2_DW_mult_tc_0_DW_mult_tc_2 a[7] a[6] a[5] a[4] a[3] a[2] a[1]
+ a[0] b[7] b[6] b[5] b[4] b[3] b[2] b[1] b[0] product[15] product[14]
+ product[13] product[12] product[11] product[10] product[9] product[8]
+ product[7] product[6] product[5] product[4] product[3] product[2] product[1]
+ product[0] VDD VSS gre_a_INV_2484_2
XU2 ad01d0 $PINS A=n196 B=n61 CI=n2 CO=n1 S=product[14] VDD=VDD VSS=VSS
XU3 ad01d0 $PINS A=n17 B=n16 CI=n3 CO=n2 S=product[13] VDD=VDD VSS=VSS
XU4 ad01d0 $PINS A=n18 B=n19 CI=n4 CO=n3 S=product[12] VDD=VDD VSS=VSS
XU5 ad01d0 $PINS A=n20 B=n23 CI=n5 CO=n4 S=product[11] VDD=VDD VSS=VSS
XU6 ad01d0 $PINS A=n27 B=n24 CI=n6 CO=n5 S=product[10] VDD=VDD VSS=VSS
XU7 ad01d0 $PINS A=n33 B=n28 CI=n7 CO=n6 S=product[9] VDD=VDD VSS=VSS
XU8 ad01d0 $PINS A=n39 B=n34 CI=n8 CO=n7 S=product[8] VDD=VDD VSS=VSS
XU9 ad01d0 $PINS A=n45 B=n40 CI=n9 CO=n8 S=product[7] VDD=VDD VSS=VSS
XU10 ad01d0 $PINS A=n49 B=n46 CI=n10 CO=n9 S=product[6] VDD=VDD VSS=VSS
XU11 ad01d0 $PINS A=n53 B=n50 CI=n11 CO=n10 S=product[5] VDD=VDD VSS=VSS
XU12 ad01d0 $PINS A=n55 B=n54 CI=n12 CO=n11 S=product[4] VDD=VDD VSS=VSS
XU13 ad01d0 $PINS A=n59 B=n56 CI=n13 CO=n12 S=product[3] VDD=VDD VSS=VSS
XU14 ad01d0 $PINS A=n84 B=n91 CI=n14 CO=n13 S=product[2] VDD=VDD VSS=VSS
XctmTdsLR_1_3006 an02d1 $PINS A1=n90 A2=n83 Z=n55 VDD=VDD VSS=VSS
XU17 ad01d0 $PINS A=n195 B=n62 CI=n69 CO=n17 S=n18 VDD=VDD VSS=VSS
XU18 ad01d0 $PINS A=n63 B=n25 CI=n22 CO=n19 S=n20 VDD=VDD VSS=VSS
XU20 ad01d0 $PINS A=n64 B=n26 CI=n29 CO=n23 S=n24 VDD=VDD VSS=VSS
XU21 ad01d0 $PINS A=n194 B=n70 CI=n77 CO=n25 S=n26 VDD=VDD VSS=VSS
XU22 ad01d0 $PINS A=n32 B=n35 CI=n30 CO=n27 S=n28 VDD=VDD VSS=VSS
XU23 ad01d0 $PINS A=n71 B=n65 CI=n37 CO=n29 S=n30 VDD=VDD VSS=VSS
XU25 ad01d0 $PINS A=n38 B=n41 CI=n36 CO=n33 S=n34 VDD=VDD VSS=VSS
XU26 ad01d0 $PINS A=n72 B=n85 CI=n43 CO=n35 S=n36 VDD=VDD VSS=VSS
XU29 ad01d0 $PINS A=n44 B=n47 CI=n42 CO=n39 S=n40 VDD=VDD VSS=VSS
XU30 ad01d0 $PINS A=n86 B=n73 CI=n79 CO=n41 S=n42 VDD=VDD VSS=VSS
XU32 ad01d0 $PINS A=n74 B=n51 CI=n48 CO=n45 S=n46 VDD=VDD VSS=VSS
XU33 ad01d0 $PINS A=n68 B=n87 CI=n80 CO=n47 S=n48 VDD=VDD VSS=VSS
XU34 ad01d0 $PINS A=n88 B=n81 CI=n52 CO=n49 S=n50 VDD=VDD VSS=VSS
XU36 ad01d0 $PINS A=n76 B=n89 CI=n82 CO=n53 S=n54 VDD=VDD VSS=VSS
XU145 oai21d1 $PINS B1=n203 B2=n249 A=n222 ZN=n77 VDD=VDD VSS=VSS
XU146 oai21d1 $PINS B1=n201 B2=n250 A=n232 ZN=n69 VDD=VDD VSS=VSS
XU147 oai21d1 $PINS B1=n199 B2=n251 A=n242 ZN=n61 VDD=VDD VSS=VSS
XU148 inv0d0 $PINS I=n16 ZN=n196 VDD=VDD VSS=VSS
XU149 inv0d0 $PINS I=n223 ZN=n201 VDD=VDD VSS=VSS
XU150 inv0d0 $PINS I=n214 ZN=n203 VDD=VDD VSS=VSS
XU151 inv0d0 $PINS I=n233 ZN=n199 VDD=VDD VSS=VSS
XU152 inv0d0 $PINS I=n32 ZN=n194 VDD=VDD VSS=VSS
XU153 inv0d0 $PINS I=n22 ZN=n195 VDD=VDD VSS=VSS
XU154 nd02d1 $PINS A1=n214 A2=n249 ZN=n216 VDD=VDD VSS=VSS
XU155 xr02d1 $PINS A1=a[2] A2=n204 Z=n214 VDD=VDD VSS=VSS
XU156 inv0d1 $PINS I=a[1] ZN=n204 VDD=VDD VSS=VSS
XU157 nd02d1 $PINS A1=n223 A2=n250 ZN=n225 VDD=VDD VSS=VSS
XU158 xr02d1 $PINS A1=a[4] A2=n202 Z=n223 VDD=VDD VSS=VSS
XU159 inv0d1 $PINS I=a[3] ZN=n202 VDD=VDD VSS=VSS
XU160 nd02d1 $PINS A1=a[1] A2=a[0] ZN=n206 VDD=VDD VSS=VSS
XU162 inv0d0 $PINS I=b[0] ZN=n197 VDD=VDD VSS=VSS
XU163 xr02d1 $PINS A1=a[6] A2=gre_a_INV_2484_2 Z=n233 VDD=VDD VSS=VSS
XU165 nd02d1 $PINS A1=n233 A2=n251 ZN=n235 VDD=VDD VSS=VSS
XU166 inv0d1 $PINS I=a[7] ZN=n198 VDD=VDD VSS=VSS
XU167 inv0d0 $PINS I=n1 ZN=product[15] VDD=VDD VSS=VSS
XU168 nr02d0 $PINS A1=a[0] A2=n197 ZN=product[0] VDD=VDD VSS=VSS
XU169 oai22d1 $PINS A1=b[0] A2=n206 B1=n207 B2=a[0] ZN=n92 VDD=VDD VSS=VSS
XU170 oai22d1 $PINS A1=n207 A2=n206 B1=n208 B2=a[0] ZN=n91 VDD=VDD VSS=VSS
XU171 xr02d1 $PINS A1=b[1] A2=n204 Z=n207 VDD=VDD VSS=VSS
XU172 oai22d1 $PINS A1=n208 A2=n206 B1=n209 B2=a[0] ZN=n90 VDD=VDD VSS=VSS
XU173 xr02d1 $PINS A1=b[2] A2=n204 Z=n208 VDD=VDD VSS=VSS
XU174 oai22d1 $PINS A1=n209 A2=n206 B1=n210 B2=a[0] ZN=n89 VDD=VDD VSS=VSS
XU175 xr02d1 $PINS A1=b[3] A2=n204 Z=n209 VDD=VDD VSS=VSS
XU176 oai22d1 $PINS A1=n210 A2=n206 B1=n211 B2=a[0] ZN=n88 VDD=VDD VSS=VSS
XU177 xr02d1 $PINS A1=b[4] A2=n204 Z=n210 VDD=VDD VSS=VSS
XU178 oai22d1 $PINS A1=n211 A2=n206 B1=n212 B2=a[0] ZN=n87 VDD=VDD VSS=VSS
XU179 xr02d1 $PINS A1=b[5] A2=n204 Z=n211 VDD=VDD VSS=VSS
XU180 oai22d1 $PINS A1=n212 A2=n206 B1=n213 B2=a[0] ZN=n86 VDD=VDD VSS=VSS
XU181 xr02d1 $PINS A1=b[6] A2=n204 Z=n212 VDD=VDD VSS=VSS
XU182 aor21d1 $PINS B1=a[0] B2=n206 A=n213 Z=n85 VDD=VDD VSS=VSS
XU183 xr02d1 $PINS A1=b[7] A2=n204 Z=n213 VDD=VDD VSS=VSS
XU184 nr02d0 $PINS A1=n214 A2=n197 ZN=n84 VDD=VDD VSS=VSS
XU185 oai22d1 $PINS A1=n216 A2=n215 B1=n214 B2=n217 ZN=n83 VDD=VDD VSS=VSS
XctmTdsLR_1_2995 an02d1 $PINS A1=n60 A2=n92 Z=n14 VDD=VDD VSS=VSS
XU187 oai22d1 $PINS A1=n217 A2=n216 B1=n214 B2=n218 ZN=n82 VDD=VDD VSS=VSS
XU188 xr02d1 $PINS A1=b[1] A2=n202 Z=n217 VDD=VDD VSS=VSS
XU189 oai22d1 $PINS A1=n218 A2=n216 B1=n214 B2=n219 ZN=n81 VDD=VDD VSS=VSS
XU190 xr02d1 $PINS A1=b[2] A2=n202 Z=n218 VDD=VDD VSS=VSS
XU191 oai22d1 $PINS A1=n219 A2=n216 B1=n214 B2=n220 ZN=n80 VDD=VDD VSS=VSS
XU192 xr02d1 $PINS A1=b[3] A2=n202 Z=n219 VDD=VDD VSS=VSS
XU193 oai22d1 $PINS A1=n220 A2=n216 B1=n214 B2=n221 ZN=n79 VDD=VDD VSS=VSS
XU194 xr02d1 $PINS A1=b[4] A2=n202 Z=n220 VDD=VDD VSS=VSS
XU195 nr02d0 $PINS A1=n223 A2=n197 ZN=n76 VDD=VDD VSS=VSS
XU196 oai22d1 $PINS A1=n225 A2=n224 B1=n223 B2=n226 ZN=n75 VDD=VDD VSS=VSS
XctmTdsLR_2_2996 aoim21d1 $PINS B1=n92 B2=n60 A=n14 ZN=product[1] VDD=VDD
+ VSS=VSS
XU198 oai22d1 $PINS A1=n226 A2=n225 B1=n223 B2=n227 ZN=n74 VDD=VDD VSS=VSS
XU199 xr02d1 $PINS A1=b[1] A2=gre_a_INV_2484_2 Z=n226 VDD=VDD VSS=VSS
XU200 oai22d1 $PINS A1=n227 A2=n225 B1=n223 B2=n228 ZN=n73 VDD=VDD VSS=VSS
XU201 xr02d1 $PINS A1=b[2] A2=gre_a_INV_2484_2 Z=n227 VDD=VDD VSS=VSS
XU202 oai22d1 $PINS A1=n228 A2=n225 B1=n223 B2=n229 ZN=n72 VDD=VDD VSS=VSS
XU203 xr02d1 $PINS A1=b[3] A2=gre_a_INV_2484_2 Z=n228 VDD=VDD VSS=VSS
XU204 oai22d1 $PINS A1=n229 A2=n225 B1=n223 B2=n230 ZN=n71 VDD=VDD VSS=VSS
XU205 xr02d1 $PINS A1=b[4] A2=gre_a_INV_2484_2 Z=n229 VDD=VDD VSS=VSS
XU206 oai22d1 $PINS A1=n230 A2=n225 B1=n223 B2=n231 ZN=n70 VDD=VDD VSS=VSS
XU207 xr02d1 $PINS A1=b[5] A2=gre_a_INV_2484_2 Z=n230 VDD=VDD VSS=VSS
XU208 nr02d0 $PINS A1=n233 A2=n197 ZN=n68 VDD=VDD VSS=VSS
XU209 oai22d1 $PINS A1=n235 A2=n234 B1=n233 B2=n236 ZN=n67 VDD=VDD VSS=VSS
XctmTdsLR_2_3007 aoim21d1 $PINS B1=n90 B2=n83 A=n55 ZN=n56 VDD=VDD VSS=VSS
XU211 oai22d1 $PINS A1=n237 A2=n235 B1=n233 B2=n238 ZN=n65 VDD=VDD VSS=VSS
XU212 oai22d1 $PINS A1=n238 A2=n235 B1=n233 B2=n239 ZN=n64 VDD=VDD VSS=VSS
XU213 xr02d1 $PINS A1=b[3] A2=n198 Z=n238 VDD=VDD VSS=VSS
XU214 oai22d1 $PINS A1=n239 A2=n235 B1=n233 B2=n240 ZN=n63 VDD=VDD VSS=VSS
XU215 xr02d1 $PINS A1=b[4] A2=n198 Z=n239 VDD=VDD VSS=VSS
XU216 oai22d1 $PINS A1=n240 A2=n235 B1=n233 B2=n241 ZN=n62 VDD=VDD VSS=VSS
XU217 xr02d1 $PINS A1=b[5] A2=n198 Z=n240 VDD=VDD VSS=VSS
XU218 oai21d1 $PINS B1=b[0] B2=n204 A=n206 ZN=n60 VDD=VDD VSS=VSS
XU219 oai21d1 $PINS B1=n202 B2=n216 A=n243 ZN=n59 VDD=VDD VSS=VSS
XU220 nd03d0 $PINS A1=n203 A2=n197 A3=a[3] ZN=n243 VDD=VDD VSS=VSS
XU221 oai21d1 $PINS B1=gre_a_INV_2484_2 B2=n225 A=n244 ZN=n58 VDD=VDD VSS=VSS
XU222 nd03d0 $PINS A1=n201 A2=n197 A3=a[5] ZN=n244 VDD=VDD VSS=VSS
XU223 oai21d1 $PINS B1=n198 B2=n235 A=n245 ZN=n57 VDD=VDD VSS=VSS
XU224 nd03d0 $PINS A1=n199 A2=n197 A3=a[7] ZN=n245 VDD=VDD VSS=VSS
XU225 xn02d1 $PINS A1=n246 A2=n247 ZN=n38 VDD=VDD VSS=VSS
XU226 or02d0 $PINS A1=n247 A2=n246 Z=n37 VDD=VDD VSS=VSS
XU227 oai22d1 $PINS A1=n236 A2=n235 B1=n233 B2=n237 ZN=n246 VDD=VDD VSS=VSS
XU228 xr02d1 $PINS A1=b[2] A2=n198 Z=n237 VDD=VDD VSS=VSS
XU229 xr02d1 $PINS A1=b[1] A2=n198 Z=n236 VDD=VDD VSS=VSS
XU230 oai22d1 $PINS A1=n221 A2=n216 B1=n214 B2=n248 ZN=n247 VDD=VDD VSS=VSS
XU231 xr02d1 $PINS A1=b[5] A2=n202 Z=n221 VDD=VDD VSS=VSS
XU232 aoim22d1 $PINS A1=n203 A2=n222 B1=n248 B2=n216 Z=n32 VDD=VDD VSS=VSS
XU233 xr02d1 $PINS A1=a[3] A2=a[2] Z=n249 VDD=VDD VSS=VSS
XU234 xr02d1 $PINS A1=b[6] A2=n202 Z=n248 VDD=VDD VSS=VSS
XU235 xr02d1 $PINS A1=b[7] A2=a[3] Z=n222 VDD=VDD VSS=VSS
XU236 aoim22d1 $PINS A1=n201 A2=n232 B1=n231 B2=n225 Z=n22 VDD=VDD VSS=VSS
XU237 xr02d1 $PINS A1=a[5] A2=a[4] Z=n250 VDD=VDD VSS=VSS
XU238 xr02d1 $PINS A1=b[6] A2=gre_a_INV_2484_2 Z=n231 VDD=VDD VSS=VSS
XU239 xr02d1 $PINS A1=b[7] A2=a[5] Z=n232 VDD=VDD VSS=VSS
XU240 aoim22d1 $PINS A1=n199 A2=n242 B1=n241 B2=n235 Z=n16 VDD=VDD VSS=VSS
XU241 xr02d1 $PINS A1=a[7] A2=a[6] Z=n251 VDD=VDD VSS=VSS
XU242 xr02d1 $PINS A1=b[6] A2=n198 Z=n241 VDD=VDD VSS=VSS
XU243 xr02d1 $PINS A1=b[7] A2=a[7] Z=n242 VDD=VDD VSS=VSS
XctmTdsLR_1_1367 aoim22d1 $PINS A1=n202 A2=b[0] B1=n202 B2=b[0] Z=n215 VDD=VDD
+ VSS=VSS
XctmTdsLR_1_1368 aoim22d1 $PINS A1=gre_a_INV_2484_2 A2=b[0] B1=gre_a_INV_2484_2
+ B2=b[0] Z=n224 VDD=VDD VSS=VSS
XctmTdsLR_1_1369 aoim22d1 $PINS A1=n198 A2=b[0] B1=n198 B2=b[0] Z=n234 VDD=VDD
+ VSS=VSS
XctmTdsLR_1_3008 an02d1 $PINS A1=n58 A2=n75 Z=n51 VDD=VDD VSS=VSS
XctmTdsLR_2_3009 aoim21d1 $PINS B1=n58 B2=n75 A=n51 ZN=n52 VDD=VDD VSS=VSS
XctmTdsLR_1_3010 an02d1 $PINS A1=n57 A2=n67 Z=n43 VDD=VDD VSS=VSS
XctmTdsLR_2_3011 aoim21d1 $PINS B1=n57 B2=n67 A=n43 ZN=n44 VDD=VDD VSS=VSS
.ENDS

.SUBCKT unpu_pe_2_DW_mult_uns_0_DW_mult_uns_3 a[7] a[6] a[5] a[4] a[3] a[2]
+ a[1] a[0] b[7] b[6] b[5] b[4] b[3] b[2] b[1] b[0] product[15] product[14]
+ product[13] product[12] product[11] product[10] product[9] product[8]
+ product[7] product[6] product[5] product[4] product[3] product[2] product[1]
+ product[0] VDD VSS
XU2 ad01d0 $PINS A=n99 B=n15 CI=n2 CO=product[15] S=product[14] VDD=VDD VSS=VSS
XU3 ad01d0 $PINS A=n16 B=n17 CI=n3 CO=n2 S=product[13] VDD=VDD VSS=VSS
XU4 ad01d0 $PINS A=n18 B=n21 CI=n4 CO=n3 S=product[12] VDD=VDD VSS=VSS
XU5 ad01d0 $PINS A=n27 B=n22 CI=n5 CO=n4 S=product[11] VDD=VDD VSS=VSS
XU6 ad01d1 $PINS A=n35 B=n28 CI=n6 CO=n5 S=product[10] VDD=VDD VSS=VSS
XU7 ad01d0 $PINS A=n45 B=n36 CI=n7 CO=n6 S=product[9] VDD=VDD VSS=VSS
XU8 ad01d0 $PINS A=n57 B=n46 CI=n8 CO=n7 S=product[8] VDD=VDD VSS=VSS
XU9 ad01d0 $PINS A=n69 B=n58 CI=n9 CO=n8 S=product[7] VDD=VDD VSS=VSS
XU10 ad01d1 $PINS A=n79 B=n70 CI=n10 CO=n9 S=product[6] VDD=VDD VSS=VSS
XU11 ad01d0 $PINS A=n87 B=n80 CI=n11 CO=n10 S=product[5] VDD=VDD VSS=VSS
XU12 ad01d0 $PINS A=n93 B=n88 CI=n12 CO=n11 S=product[4] VDD=VDD VSS=VSS
XU13 ad01d0 $PINS A=n96 B=n13 CI=n94 CO=n12 S=product[3] VDD=VDD VSS=VSS
XU14 ad01d0 $PINS A=n146 B=n14 CI=n98 CO=n13 S=product[2] VDD=VDD VSS=VSS
XU15 ah01d1 $PINS A=n161 B=n154 CO=n14 S=product[1] VDD=VDD VSS=VSS
XU16 ad01d0 $PINS A=n107 B=n100 CI=n19 CO=n15 S=n16 VDD=VDD VSS=VSS
XU17 ad01d0 $PINS A=n25 B=n20 CI=n23 CO=n17 S=n18 VDD=VDD VSS=VSS
XU18 ad01d0 $PINS A=n115 B=n101 CI=n108 CO=n19 S=n20 VDD=VDD VSS=VSS
XU19 ad01d0 $PINS A=n31 B=n24 CI=n29 CO=n21 S=n22 VDD=VDD VSS=VSS
XU20 ad01d0 $PINS A=n116 B=n33 CI=n26 CO=n23 S=n24 VDD=VDD VSS=VSS
XU21 ad01d0 $PINS A=n123 B=n102 CI=n109 CO=n25 S=n26 VDD=VDD VSS=VSS
XU22 ad01d0 $PINS A=n32 B=n37 CI=n30 CO=n27 S=n28 VDD=VDD VSS=VSS
XU23 ad01d0 $PINS A=n41 B=n34 CI=n39 CO=n29 S=n30 VDD=VDD VSS=VSS
XU24 ad01d0 $PINS A=n124 B=n117 CI=n43 CO=n31 S=n32 VDD=VDD VSS=VSS
XU25 ad01d0 $PINS A=n131 B=n103 CI=n110 CO=n33 S=n34 VDD=VDD VSS=VSS
XU26 ad01d0 $PINS A=n40 B=n47 CI=n38 CO=n35 S=n36 VDD=VDD VSS=VSS
XU27 ad01d0 $PINS A=n44 B=n51 CI=n49 CO=n37 S=n38 VDD=VDD VSS=VSS
XU28 ad01d0 $PINS A=n55 B=n53 CI=n42 CO=n39 S=n40 VDD=VDD VSS=VSS
XU29 ad01d0 $PINS A=n118 B=n125 CI=n132 CO=n41 S=n42 VDD=VDD VSS=VSS
XU30 ad01d0 $PINS A=n139 B=n104 CI=n111 CO=n43 S=n44 VDD=VDD VSS=VSS
XU31 ad01d0 $PINS A=n50 B=n59 CI=n48 CO=n45 S=n46 VDD=VDD VSS=VSS
XU32 ad01d0 $PINS A=n54 B=n52 CI=n61 CO=n47 S=n48 VDD=VDD VSS=VSS
XU33 ad01d0 $PINS A=n56 B=n65 CI=n63 CO=n49 S=n50 VDD=VDD VSS=VSS
XU34 ad01d0 $PINS A=n140 B=n133 CI=n67 CO=n51 S=n52 VDD=VDD VSS=VSS
XU35 ad01d0 $PINS A=n126 B=n119 CI=n147 CO=n53 S=n54 VDD=VDD VSS=VSS
XU36 ah01d1 $PINS A=n105 B=n112 CO=n55 S=n56 VDD=VDD VSS=VSS
XU37 ad01d0 $PINS A=n71 B=n62 CI=n60 CO=n57 S=n58 VDD=VDD VSS=VSS
XU38 ad01d0 $PINS A=n64 B=n66 CI=n73 CO=n59 S=n60 VDD=VDD VSS=VSS
XU39 ad01d0 $PINS A=n77 B=n68 CI=n75 CO=n61 S=n62 VDD=VDD VSS=VSS
XU40 ad01d0 $PINS A=n141 B=n127 CI=n134 CO=n63 S=n64 VDD=VDD VSS=VSS
XU41 ad01d0 $PINS A=n155 B=n120 CI=n148 CO=n65 S=n66 VDD=VDD VSS=VSS
XU42 ah01d1 $PINS A=n106 B=n113 CO=n67 S=n68 VDD=VDD VSS=VSS
XU43 ad01d0 $PINS A=n81 B=n74 CI=n72 CO=n69 S=n70 VDD=VDD VSS=VSS
XU44 ad01d0 $PINS A=n78 B=n83 CI=n76 CO=n71 S=n72 VDD=VDD VSS=VSS
XU45 ad01d0 $PINS A=n142 B=n135 CI=n85 CO=n73 S=n74 VDD=VDD VSS=VSS
XU46 ad01d0 $PINS A=n156 B=n128 CI=n149 CO=n75 S=n76 VDD=VDD VSS=VSS
XU47 ah01d1 $PINS A=n114 B=n121 CO=n77 S=n78 VDD=VDD VSS=VSS
XU48 ad01d0 $PINS A=n89 B=n84 CI=n82 CO=n79 S=n80 VDD=VDD VSS=VSS
XU49 ad01d0 $PINS A=n150 B=n91 CI=n86 CO=n81 S=n82 VDD=VDD VSS=VSS
XU50 ad01d0 $PINS A=n157 B=n136 CI=n143 CO=n83 S=n84 VDD=VDD VSS=VSS
XU51 ah01d1 $PINS A=n122 B=n129 CO=n85 S=n86 VDD=VDD VSS=VSS
XU52 ad01d0 $PINS A=n95 B=n92 CI=n90 CO=n87 S=n88 VDD=VDD VSS=VSS
XU53 ad01d1 $PINS A=n158 B=n144 CI=n151 CO=n89 S=n90 VDD=VDD VSS=VSS
XU54 ah01d1 $PINS A=n130 B=n137 CO=n91 S=n92 VDD=VDD VSS=VSS
XU55 ad01d0 $PINS A=n159 B=n152 CI=n97 CO=n93 S=n94 VDD=VDD VSS=VSS
XU56 ah01d1 $PINS A=n138 B=n145 CO=n95 S=n96 VDD=VDD VSS=VSS
XU57 ah01d1 $PINS A=n153 B=n160 CO=n97 S=n98 VDD=VDD VSS=VSS
XU140 inv0d0 $PINS I=b[4] ZN=n217 VDD=VDD VSS=VSS
XU141 inv0d0 $PINS I=a[1] ZN=n228 VDD=VDD VSS=VSS
XU142 inv0d0 $PINS I=b[2] ZN=n219 VDD=VDD VSS=VSS
XU144 inv0d0 $PINS I=a[2] ZN=n227 VDD=VDD VSS=VSS
XU145 inv0d0 $PINS I=b[3] ZN=n218 VDD=VDD VSS=VSS
XU147 inv0d0 $PINS I=b[1] ZN=n220 VDD=VDD VSS=VSS
XU148 inv0d0 $PINS I=b[0] ZN=n221 VDD=VDD VSS=VSS
XU149 inv0d0 $PINS I=a[4] ZN=n225 VDD=VDD VSS=VSS
XU150 inv0d0 $PINS I=b[6] ZN=n215 VDD=VDD VSS=VSS
XU151 inv0d0 $PINS I=a[3] ZN=n226 VDD=VDD VSS=VSS
XU152 inv0d0 $PINS I=b[5] ZN=n216 VDD=VDD VSS=VSS
XU153 inv0d0 $PINS I=b[7] ZN=n214 VDD=VDD VSS=VSS
XU154 inv0d0 $PINS I=a[6] ZN=n223 VDD=VDD VSS=VSS
XU155 inv0d0 $PINS I=a[7] ZN=n222 VDD=VDD VSS=VSS
XU156 nr02d0 $PINS A1=a[0] A2=n221 ZN=product[0] VDD=VDD VSS=VSS
XU157 nr02d0 $PINS A1=n222 A2=n214 ZN=n99 VDD=VDD VSS=VSS
XU158 nr02d0 $PINS A1=a[0] A2=n220 ZN=n161 VDD=VDD VSS=VSS
XU159 nr02d0 $PINS A1=a[0] A2=n219 ZN=n160 VDD=VDD VSS=VSS
XU160 nr02d0 $PINS A1=a[0] A2=n218 ZN=n159 VDD=VDD VSS=VSS
XU161 nr02d0 $PINS A1=a[0] A2=n217 ZN=n158 VDD=VDD VSS=VSS
XU162 nr02d0 $PINS A1=a[0] A2=n216 ZN=n157 VDD=VDD VSS=VSS
XU163 nr02d0 $PINS A1=a[0] A2=n215 ZN=n156 VDD=VDD VSS=VSS
XU164 nr02d0 $PINS A1=a[0] A2=n214 ZN=n155 VDD=VDD VSS=VSS
XU165 nr02d0 $PINS A1=n221 A2=n228 ZN=n154 VDD=VDD VSS=VSS
XU166 nr02d0 $PINS A1=n220 A2=n228 ZN=n153 VDD=VDD VSS=VSS
XU167 nr02d0 $PINS A1=n219 A2=n228 ZN=n152 VDD=VDD VSS=VSS
XU168 nr02d0 $PINS A1=n218 A2=n228 ZN=n151 VDD=VDD VSS=VSS
XU169 nr02d0 $PINS A1=n217 A2=n228 ZN=n150 VDD=VDD VSS=VSS
XU170 nr02d0 $PINS A1=n216 A2=n228 ZN=n149 VDD=VDD VSS=VSS
XU171 nr02d0 $PINS A1=n215 A2=n228 ZN=n148 VDD=VDD VSS=VSS
XU172 nr02d0 $PINS A1=n214 A2=n228 ZN=n147 VDD=VDD VSS=VSS
XU173 nr02d0 $PINS A1=n221 A2=n227 ZN=n146 VDD=VDD VSS=VSS
XU174 nr02d0 $PINS A1=n220 A2=n227 ZN=n145 VDD=VDD VSS=VSS
XU175 nr02d0 $PINS A1=n219 A2=n227 ZN=n144 VDD=VDD VSS=VSS
XU176 nr02d0 $PINS A1=n218 A2=n227 ZN=n143 VDD=VDD VSS=VSS
XU177 nr02d0 $PINS A1=n217 A2=n227 ZN=n142 VDD=VDD VSS=VSS
XU178 nr02d0 $PINS A1=n216 A2=n227 ZN=n141 VDD=VDD VSS=VSS
XU179 nr02d0 $PINS A1=n215 A2=n227 ZN=n140 VDD=VDD VSS=VSS
XU180 nr02d0 $PINS A1=n214 A2=n227 ZN=n139 VDD=VDD VSS=VSS
XU181 nr02d0 $PINS A1=n221 A2=n226 ZN=n138 VDD=VDD VSS=VSS
XU182 nr02d0 $PINS A1=n220 A2=n226 ZN=n137 VDD=VDD VSS=VSS
XU183 nr02d0 $PINS A1=n219 A2=n226 ZN=n136 VDD=VDD VSS=VSS
XU184 nr02d0 $PINS A1=n218 A2=n226 ZN=n135 VDD=VDD VSS=VSS
XU185 nr02d0 $PINS A1=n217 A2=n226 ZN=n134 VDD=VDD VSS=VSS
XU186 nr02d0 $PINS A1=n216 A2=n226 ZN=n133 VDD=VDD VSS=VSS
XU187 nr02d0 $PINS A1=n215 A2=n226 ZN=n132 VDD=VDD VSS=VSS
XU188 nr02d0 $PINS A1=n214 A2=n226 ZN=n131 VDD=VDD VSS=VSS
XU189 nr02d0 $PINS A1=n221 A2=n225 ZN=n130 VDD=VDD VSS=VSS
XU190 nr02d0 $PINS A1=n220 A2=n225 ZN=n129 VDD=VDD VSS=VSS
XU191 nr02d0 $PINS A1=n219 A2=n225 ZN=n128 VDD=VDD VSS=VSS
XU192 nr02d0 $PINS A1=n218 A2=n225 ZN=n127 VDD=VDD VSS=VSS
XU193 nr02d0 $PINS A1=n217 A2=n225 ZN=n126 VDD=VDD VSS=VSS
XU194 nr02d0 $PINS A1=n216 A2=n225 ZN=n125 VDD=VDD VSS=VSS
XU195 nr02d0 $PINS A1=n215 A2=n225 ZN=n124 VDD=VDD VSS=VSS
XU196 nr02d0 $PINS A1=n214 A2=n225 ZN=n123 VDD=VDD VSS=VSS
XU197 nr02d0 $PINS A1=n221 A2=a[5] ZN=n122 VDD=VDD VSS=VSS
XU198 nr02d0 $PINS A1=n220 A2=a[5] ZN=n121 VDD=VDD VSS=VSS
XU199 nr02d0 $PINS A1=n219 A2=a[5] ZN=n120 VDD=VDD VSS=VSS
XU200 nr02d0 $PINS A1=n218 A2=a[5] ZN=n119 VDD=VDD VSS=VSS
XU201 nr02d0 $PINS A1=n217 A2=a[5] ZN=n118 VDD=VDD VSS=VSS
XU202 nr02d0 $PINS A1=n216 A2=a[5] ZN=n117 VDD=VDD VSS=VSS
XU203 nr02d0 $PINS A1=n215 A2=a[5] ZN=n116 VDD=VDD VSS=VSS
XU204 nr02d0 $PINS A1=n214 A2=a[5] ZN=n115 VDD=VDD VSS=VSS
XU205 nr02d0 $PINS A1=n221 A2=n223 ZN=n114 VDD=VDD VSS=VSS
XU206 nr02d0 $PINS A1=n220 A2=n223 ZN=n113 VDD=VDD VSS=VSS
XU207 nr02d0 $PINS A1=n219 A2=n223 ZN=n112 VDD=VDD VSS=VSS
XU208 nr02d0 $PINS A1=n218 A2=n223 ZN=n111 VDD=VDD VSS=VSS
XU209 nr02d0 $PINS A1=n217 A2=n223 ZN=n110 VDD=VDD VSS=VSS
XU210 nr02d0 $PINS A1=n216 A2=n223 ZN=n109 VDD=VDD VSS=VSS
XU211 nr02d0 $PINS A1=n215 A2=n223 ZN=n108 VDD=VDD VSS=VSS
XU212 nr02d0 $PINS A1=n214 A2=n223 ZN=n107 VDD=VDD VSS=VSS
XU213 nr02d0 $PINS A1=n221 A2=n222 ZN=n106 VDD=VDD VSS=VSS
XU214 nr02d0 $PINS A1=n222 A2=n220 ZN=n105 VDD=VDD VSS=VSS
XU215 nr02d0 $PINS A1=n222 A2=n219 ZN=n104 VDD=VDD VSS=VSS
XU216 nr02d0 $PINS A1=n222 A2=n218 ZN=n103 VDD=VDD VSS=VSS
XU217 nr02d0 $PINS A1=n222 A2=n217 ZN=n102 VDD=VDD VSS=VSS
XU218 nr02d0 $PINS A1=n222 A2=n216 ZN=n101 VDD=VDD VSS=VSS
XU219 nr02d0 $PINS A1=n222 A2=n215 ZN=n100 VDD=VDD VSS=VSS
.ENDS

.SUBCKT unpu_pe_2_DW01_add_0_DW01_add_3 A[31] A[30] A[29] A[28] A[27] A[26]
+ A[25] A[24] A[23] A[22] A[21] A[20] A[19] A[18] A[17] A[16] A[15] A[14] A[13]
+ A[12] A[11] A[10] A[9] A[8] A[7] A[6] A[5] A[4] A[3] A[2] A[1] A[0] B[31]
+ B[30] B[29] B[28] B[27] B[26] B[25] B[24] B[23] B[22] B[21] B[20] B[19] B[18]
+ B[17] B[16] B[15] B[14] B[13] B[12] B[11] B[10] B[9] B[8] B[7] B[6] B[5] B[4]
+ B[3] B[2] B[1] B[0] CI SUM[31] SUM[30] SUM[29] SUM[28] SUM[27] SUM[26]
+ SUM[25] SUM[24] SUM[23] SUM[22] SUM[21] SUM[20] SUM[19] SUM[18] SUM[17]
+ SUM[16] SUM[15] SUM[14] SUM[13] SUM[12] SUM[11] SUM[10] SUM[9] SUM[8] SUM[7]
+ SUM[6] SUM[5] SUM[4] SUM[3] SUM[2] SUM[1] SUM[0] CO VDD VSS
XU1_31 ad01d0 $PINS A=A[31] B=B[31] CI=carry[31] S=SUM[31] VDD=VDD VSS=VSS
XU1_30 ad01d0 $PINS A=copt_net_1729 B=B[30] CI=carry[30] CO=carry[31] S=SUM[30]
+ VDD=VDD VSS=VSS
XU1_29 ad01d0 $PINS A=copt_net_2152 B=B[29] CI=carry[29] CO=carry[30] S=SUM[29]
+ VDD=VDD VSS=VSS
XU1_28 ad01d0 $PINS A=copt_net_1684 B=B[28] CI=carry[28] CO=carry[29] S=SUM[28]
+ VDD=VDD VSS=VSS
XU1_27 ad01d0 $PINS A=copt_net_2186 B=B[27] CI=carry[27] CO=carry[28] S=SUM[27]
+ VDD=VDD VSS=VSS
XU1_26 ad01d1 $PINS A=copt_net_1714 B=B[26] CI=carry[26] CO=carry[27] S=SUM[26]
+ VDD=VDD VSS=VSS
XU1_25 ad01d0 $PINS A=copt_net_1784 B=B[25] CI=carry[25] CO=carry[26] S=SUM[25]
+ VDD=VDD VSS=VSS
XU1_24 ad01d0 $PINS A=A[24] B=B[24] CI=carry[24] CO=carry[25] S=SUM[24] VDD=VDD
+ VSS=VSS
XU1_23 ad01d0 $PINS A=copt_net_1585 B=B[23] CI=carry[23] CO=carry[24] S=SUM[23]
+ VDD=VDD VSS=VSS
XU1_22 ad01d0 $PINS A=A[22] B=B[22] CI=carry[22] CO=carry[23] S=SUM[22] VDD=VDD
+ VSS=VSS
XU1_21 ad01d4 $PINS A=A[21] B=B[21] CI=carry[21] CO=carry[22] S=SUM[21] VDD=VDD
+ VSS=VSS
XU1_20 ad01d0 $PINS A=copt_net_1905 B=B[20] CI=carry[20] CO=carry[21] S=SUM[20]
+ VDD=VDD VSS=VSS
XU1_19 ad01d0 $PINS A=copt_net_1946 B=B[19] CI=carry[19] CO=carry[20] S=SUM[19]
+ VDD=VDD VSS=VSS
XU1_18 ad01d0 $PINS A=copt_net_2701 B=B[18] CI=carry[18] CO=carry[19] S=SUM[18]
+ VDD=VDD VSS=VSS
XU1_17 ad01d1 $PINS A=copt_net_1259 B=B[17] CI=carry[17] CO=carry[18] S=SUM[17]
+ VDD=VDD VSS=VSS
XU1_16 ad01d1 $PINS A=copt_net_1956 B=B[16] CI=carry[16] CO=carry[17] S=SUM[16]
+ VDD=VDD VSS=VSS
XU1_15 ad01d1 $PINS A=copt_net_2475 B=B[15] CI=carry[15] CO=carry[16] S=SUM[15]
+ VDD=VDD VSS=VSS
XU1_14 ad01d1 $PINS A=copt_net_1242 B=B[14] CI=carry[14] CO=carry[15] S=SUM[14]
+ VDD=VDD VSS=VSS
XU1_13 ad01d1 $PINS A=copt_net_2650 B=B[13] CI=carry[13] CO=carry[14] S=SUM[13]
+ VDD=VDD VSS=VSS
XU1_12 ad01d1 $PINS A=copt_net_1482 B=B[12] CI=carry[12] CO=carry[13] S=SUM[12]
+ VDD=VDD VSS=VSS
XU1_11 ad01d1 $PINS A=copt_net_1818 B=B[11] CI=carry[11] CO=carry[12] S=SUM[11]
+ VDD=VDD VSS=VSS
XU1_10 ad01d1 $PINS A=copt_net_1596 B=B[10] CI=carry[10] CO=carry[11] S=SUM[10]
+ VDD=VDD VSS=VSS
XU1_9 ad01d1 $PINS A=copt_net_1763 B=B[9] CI=carry[9] CO=carry[10] S=SUM[9]
+ VDD=VDD VSS=VSS
XU1_8 ad01d1 $PINS A=copt_net_2615 B=B[8] CI=carry[8] CO=carry[9] S=SUM[8]
+ VDD=VDD VSS=VSS
XU1_7 ad01d1 $PINS A=A[7] B=B[7] CI=carry[7] CO=carry[8] S=SUM[7] VDD=VDD
+ VSS=VSS
XU1_6 ad01d1 $PINS A=A[6] B=B[6] CI=carry[6] CO=carry[7] S=SUM[6] VDD=VDD
+ VSS=VSS
XU1_5 ad01d1 $PINS A=A[5] B=B[5] CI=carry[5] CO=carry[6] S=SUM[5] VDD=VDD
+ VSS=VSS
XU1_4 ad01d1 $PINS A=A[4] B=B[4] CI=carry[4] CO=carry[5] S=SUM[4] VDD=VDD
+ VSS=VSS
XU1_3 ad01d1 $PINS A=A[3] B=B[3] CI=carry[3] CO=carry[4] S=SUM[3] VDD=VDD
+ VSS=VSS
XU1_2 ad01d1 $PINS A=A[2] B=B[2] CI=carry[2] CO=carry[3] S=SUM[2] VDD=VDD
+ VSS=VSS
XU1_1 ad01d4 $PINS A=A[1] B=B[1] CI=n1 CO=carry[2] S=SUM[1] VDD=VDD VSS=VSS
XU1 an02d1 $PINS A1=B[0] A2=A[0] Z=n1 VDD=VDD VSS=VSS
XU2 xr02d1 $PINS A1=A[0] A2=B[0] Z=SUM[0] VDD=VDD VSS=VSS
Xcopt_h_inst_4074 dl01d1 $PINS I=A[14] Z=copt_net_1242 VDD=VDD VSS=VSS
Xcopt_h_inst_4091 dl01d1 $PINS I=A[17] Z=copt_net_1259 VDD=VDD VSS=VSS
Xcopt_h_inst_4314 dl01d1 $PINS I=A[12] Z=copt_net_1482 VDD=VDD VSS=VSS
Xcopt_h_inst_4417 dl01d1 $PINS I=A[23] Z=copt_net_1585 VDD=VDD VSS=VSS
Xcopt_h_inst_4428 dl01d1 $PINS I=A[10] Z=copt_net_1596 VDD=VDD VSS=VSS
Xcopt_h_inst_4516 dl01d1 $PINS I=A[28] Z=copt_net_1684 VDD=VDD VSS=VSS
Xcopt_h_inst_4546 dl01d1 $PINS I=A[26] Z=copt_net_1714 VDD=VDD VSS=VSS
Xcopt_h_inst_4561 dl01d1 $PINS I=A[30] Z=copt_net_1729 VDD=VDD VSS=VSS
Xcopt_h_inst_4595 dl01d1 $PINS I=A[9] Z=copt_net_1763 VDD=VDD VSS=VSS
Xcopt_h_inst_4616 dl01d1 $PINS I=A[25] Z=copt_net_1784 VDD=VDD VSS=VSS
Xcopt_h_inst_4650 dl01d1 $PINS I=A[11] Z=copt_net_1818 VDD=VDD VSS=VSS
Xcopt_h_inst_4737 dl01d1 $PINS I=A[20] Z=copt_net_1905 VDD=VDD VSS=VSS
Xcopt_h_inst_4778 dl01d1 $PINS I=A[19] Z=copt_net_1946 VDD=VDD VSS=VSS
Xcopt_h_inst_4789 dl01d1 $PINS I=A[16] Z=copt_net_1956 VDD=VDD VSS=VSS
Xcopt_h_inst_4985 buffd1 $PINS I=A[29] Z=copt_net_2152 VDD=VDD VSS=VSS
Xcopt_h_inst_5019 buffd1 $PINS I=A[27] Z=copt_net_2186 VDD=VDD VSS=VSS
Xcopt_h_inst_5308 dl01d1 $PINS I=A[15] Z=copt_net_2475 VDD=VDD VSS=VSS
Xcopt_h_inst_5448 dl01d1 $PINS I=A[8] Z=copt_net_2615 VDD=VDD VSS=VSS
Xcopt_h_inst_5483 dl01d1 $PINS I=A[13] Z=copt_net_2650 VDD=VDD VSS=VSS
Xcopt_h_inst_5534 buffd1 $PINS I=A[18] Z=copt_net_2701 VDD=VDD VSS=VSS
.ENDS

.SUBCKT unpu_pe_2 ZCTSNET_10 rst_n array_en weight_load mode_unsigned
+ weight_in[7] weight_in[6] weight_in[5] weight_in[4] weight_in[3] weight_in[2]
+ weight_in[1] weight_in[0] act_in[7] act_in[6] act_in[5] act_in[4] act_in[3]
+ act_in[2] act_in[1] act_in[0] psum_in[31] psum_in[30] psum_in[29] psum_in[28]
+ psum_in[27] psum_in[26] psum_in[25] psum_in[24] psum_in[23] psum_in[22]
+ psum_in[21] psum_in[20] psum_in[19] psum_in[18] psum_in[17] psum_in[16]
+ psum_in[15] psum_in[14] psum_in[13] psum_in[12] psum_in[11] psum_in[10]
+ psum_in[9] psum_in[8] psum_in[7] psum_in[6] psum_in[5] psum_in[4] psum_in[3]
+ psum_in[2] psum_in[1] psum_in[0] act_out[7] act_out[6] act_out[5] act_out[4]
+ act_out[3] act_out[2] act_out[1] act_out[0] psum_out[31] psum_out[30]
+ psum_out[29] psum_out[28] psum_out[27] psum_out[26] psum_out[25] psum_out[24]
+ psum_out[23] psum_out[22] psum_out[21] psum_out[20] psum_out[19] psum_out[18]
+ psum_out[17] psum_out[16] psum_out[15] psum_out[14] psum_out[13] psum_out[12]
+ psum_out[11] psum_out[10] psum_out[9] psum_out[8] psum_out[7] psum_out[6]
+ psum_out[5] psum_out[4] psum_out[3] psum_out[2] psum_out[1] psum_out[0] VDD
+ VSS ZCTSNET_0 ZCTSNET_11 HFSNET_4 HFSNET_6 HFSNET_7 HFSNET_8 HFSNET_9
+ ZCTSNET_1
XU2 aor22d1 $PINS A1=N_uc_30 A2=HFSNET_3 B1=HFSNET_2 B2=N_uc_14 Z=product[9]
+ VDD=VDD VSS=VSS
XU3 aor22d1 $PINS A1=N_uc_29 A2=HFSNET_3 B1=N_uc_13 B2=HFSNET_2 Z=product[8]
+ VDD=VDD VSS=VSS
XU5 aor22d1 $PINS A1=N_uc_28 A2=HFSNET_3 B1=N_uc_12 B2=HFSNET_2 Z=product[7]
+ VDD=VDD VSS=VSS
XU6 aor22d1 $PINS A1=N_uc_27 A2=HFSNET_3 B1=N_uc_11 B2=HFSNET_2 Z=product[6]
+ VDD=VDD VSS=VSS
XU7 aor22d1 $PINS A1=N_uc_26 A2=HFSNET_3 B1=N_uc_10 B2=HFSNET_2 Z=product[5]
+ VDD=VDD VSS=VSS
XU8 aor22d1 $PINS A1=N_uc_9 A2=HFSNET_2 B1=N_uc_25 B2=HFSNET_3 Z=product[4]
+ VDD=VDD VSS=VSS
XU9 aor22d1 $PINS A1=N_uc_8 A2=HFSNET_2 B1=N_uc_24 B2=HFSNET_3 Z=product[3]
+ VDD=VDD VSS=VSS
XU10 aor22d1 $PINS A1=N_uc_7 A2=HFSNET_2 B1=N_uc_23 B2=HFSNET_3 Z=product[2]
+ VDD=VDD VSS=VSS
XU11 aor22d1 $PINS A1=N_uc_6 A2=HFSNET_2 B1=N_uc_22 B2=HFSNET_3 Z=product[1]
+ VDD=VDD VSS=VSS
XU12 oaim21d1 $PINS B1=N_uc_20 B2=HFSNET_2 A=n14 ZN=product[15] VDD=VDD VSS=VSS
XU13 aor22d1 $PINS A1=N_uc_35 A2=HFSNET_3 B1=N_uc_19 B2=HFSNET_2 Z=product[14]
+ VDD=VDD VSS=VSS
XU14 aor22d1 $PINS A1=N_uc_34 A2=HFSNET_3 B1=N_uc_18 B2=HFSNET_2 Z=product[13]
+ VDD=VDD VSS=VSS
XU15 aor22d1 $PINS A1=N_uc_33 A2=HFSNET_3 B1=N_uc_17 B2=HFSNET_2 Z=product[12]
+ VDD=VDD VSS=VSS
XU16 aor22d1 $PINS A1=N_uc_32 A2=HFSNET_3 B1=N_uc_16 B2=HFSNET_2 Z=product[11]
+ VDD=VDD VSS=VSS
XU17 aor22d1 $PINS A1=N_uc_31 A2=HFSNET_3 B1=N_uc_15 B2=HFSNET_2 Z=product[10]
+ VDD=VDD VSS=VSS
XU18 aor22d1 $PINS A1=N_uc_5 A2=HFSNET_2 B1=N_uc_21 B2=HFSNET_3 Z=product[0]
+ VDD=VDD VSS=VSS
Xadd_42 unpu_pe_2_DW01_add_0_DW01_add_3 $PINS A[31]=psum_in[31]
+ A[30]=psum_in[30] A[29]=psum_in[29] A[28]=psum_in[28] A[27]=psum_in[27]
+ A[26]=psum_in[26] A[25]=psum_in[25] A[24]=psum_in[24] A[23]=psum_in[23]
+ A[22]=psum_in[22] A[21]=psum_in[21] A[20]=psum_in[20] A[19]=psum_in[19]
+ A[18]=psum_in[18] A[17]=psum_in[17] A[16]=psum_in[16] A[15]=psum_in[15]
+ A[14]=psum_in[14] A[13]=psum_in[13] A[12]=psum_in[12] A[11]=psum_in[11]
+ A[10]=psum_in[10] A[9]=psum_in[9] A[8]=psum_in[8] A[7]=psum_in[7]
+ A[6]=psum_in[6] A[5]=psum_in[5] A[4]=psum_in[4] A[3]=psum_in[3] A[2]=psum_in[2]
+ A[1]=psum_in[1] A[0]=psum_in[0] B[31]=n2 B[30]=n2 B[29]=n2 B[28]=n2 B[27]=n2
+ B[26]=n2 B[25]=n2 B[24]=n2 B[23]=n2 B[22]=n2 B[21]=n2 B[20]=n2 B[19]=n2
+ B[18]=n2 B[17]=n2 B[16]=n2 B[15]=product[15] B[14]=product[14]
+ B[13]=product[13] B[12]=product[12] B[11]=product[11] B[10]=product[10]
+ B[9]=product[9] B[8]=product[8] B[7]=product[7] B[6]=product[6] B[5]=product[5]
+ B[4]=product[4] B[3]=product[3] B[2]=product[2] B[1]=product[1] B[0]=product[0]
+ CI=VSS SUM[31]=N_uc_71 SUM[30]=N_uc_70 SUM[29]=N_uc_69 SUM[28]=N_uc_68
+ SUM[27]=N_uc_67 SUM[26]=N_uc_66 SUM[25]=N_uc_65 SUM[24]=N_uc_64 SUM[23]=N_uc_63
+ SUM[22]=N_uc_62 SUM[21]=N_uc_61 SUM[20]=N_uc_60 SUM[19]=N_uc_59 SUM[18]=N_uc_58
+ SUM[17]=N_uc_57 SUM[16]=N_uc_56 SUM[15]=N_uc_55 SUM[14]=N_uc_54 SUM[13]=N_uc_53
+ SUM[12]=N_uc_52 SUM[11]=N_uc_51 SUM[10]=N_uc_50 SUM[9]=N_uc_49 SUM[8]=N_uc_48
+ SUM[7]=N_uc_47 SUM[6]=N_uc_46 SUM[5]=N_uc_45 SUM[4]=N_uc_44 SUM[3]=N_uc_43
+ SUM[2]=N_uc_42 SUM[1]=N_uc_41 SUM[0]=N_uc_40 VDD=VDD VSS=VSS
Xmult_28 unpu_pe_2_DW_mult_uns_0_DW_mult_uns_3 $PINS a[7]=weight_reg[7]
+ a[6]=weight_reg[6] a[5]=gre_a_INV_2484_3 a[4]=weight_reg[4] a[3]=weight_reg[3]
+ a[2]=weight_reg[2] a[1]=weight_reg[1] a[0]=gre_a_INV_1495_3 b[7]=act_in[7]
+ b[6]=act_in[6] b[5]=act_in[5] b[4]=act_in[4] b[3]=act_in[3] b[2]=act_in[2]
+ b[1]=act_in[1] b[0]=act_in[0] product[15]=N_uc_20 product[14]=N_uc_19
+ product[13]=N_uc_18 product[12]=N_uc_17 product[11]=N_uc_16 product[10]=N_uc_15
+ product[9]=N_uc_14 product[8]=N_uc_13 product[7]=N_uc_12 product[6]=N_uc_11
+ product[5]=N_uc_10 product[4]=N_uc_9 product[3]=N_uc_8 product[2]=N_uc_7
+ product[1]=N_uc_6 product[0]=N_uc_5 VDD=VDD VSS=VSS
Xmult_30 unpu_pe_2_DW_mult_tc_0_DW_mult_tc_2 $PINS a[7]=weight_reg[7]
+ a[6]=weight_reg[6] a[5]=weight_reg[5] a[4]=weight_reg[4] a[3]=weight_reg[3]
+ a[2]=weight_reg[2] a[1]=weight_reg[1] a[0]=gre_a_INV_1495_3 b[7]=act_in[7]
+ b[6]=act_in[6] b[5]=act_in[5] b[4]=act_in[4] b[3]=act_in[3] b[2]=act_in[2]
+ b[1]=act_in[1] b[0]=act_in[0] product[15]=N_uc_36 product[14]=N_uc_35
+ product[13]=N_uc_34 product[12]=N_uc_33 product[11]=N_uc_32 product[10]=N_uc_31
+ product[9]=N_uc_30 product[8]=N_uc_29 product[7]=N_uc_28 product[6]=N_uc_27
+ product[5]=N_uc_26 product[4]=N_uc_25 product[3]=N_uc_24 product[2]=N_uc_23
+ product[1]=N_uc_22 product[0]=N_uc_21 VDD=VDD VSS=VSS
+ gre_a_INV_2484_2=gre_a_INV_2484_3
Xact_out_reg_3_ decrq1 $PINS D=copt_net_2768 ENN=HFSNET_5 CP=ZCTSNET_0
+ CDN=HFSNET_9 Q=act_out[3] VDD=VDD VSS=VSS
Xact_out_reg_2_ decrq1 $PINS D=copt_net_2774 ENN=HFSNET_5 CP=ZCTSNET_1
+ CDN=HFSNET_8 Q=act_out[2] VDD=VDD VSS=VSS
Xact_out_reg_1_ decrq1 $PINS D=copt_net_2776 ENN=HFSNET_5 CP=ZCTSNET_1
+ CDN=rst_n Q=act_out[1] VDD=VDD VSS=VSS
Xact_out_reg_7_ decrq1 $PINS D=copt_net_2789 ENN=HFSNET_5 CP=ZCTSNET_0
+ CDN=HFSNET_9 Q=act_out[7] VDD=VDD VSS=VSS
Xact_out_reg_6_ decrq1 $PINS D=copt_net_2785 ENN=HFSNET_5 CP=ZCTSNET_0
+ CDN=HFSNET_9 Q=act_out[6] VDD=VDD VSS=VSS
Xact_out_reg_5_ decrq1 $PINS D=copt_net_2792 ENN=HFSNET_5 CP=ZCTSNET_0
+ CDN=HFSNET_9 Q=act_out[5] VDD=VDD VSS=VSS
Xact_out_reg_4_ decrq1 $PINS D=copt_net_2787 ENN=HFSNET_5 CP=ZCTSNET_0
+ CDN=HFSNET_9 Q=act_out[4] VDD=VDD VSS=VSS
Xact_out_reg_0_ decrq1 $PINS D=copt_net_2780 ENN=HFSNET_5 CP=ZCTSNET_1
+ CDN=rst_n Q=act_out[0] VDD=VDD VSS=VSS
Xpsum_out_reg_4_ decrq1 $PINS D=copt_net_2491 ENN=HFSNET_5 CP=ZCTSNET_1
+ CDN=rst_n Q=psum_out[4] VDD=VDD VSS=VSS
Xpsum_out_reg_3_ decrq1 $PINS D=copt_net_1212 ENN=HFSNET_5 CP=ZCTSNET_1
+ CDN=HFSNET_8 Q=psum_out[3] VDD=VDD VSS=VSS
Xpsum_out_reg_2_ decrq1 $PINS D=copt_net_1436 ENN=HFSNET_5 CP=ZCTSNET_11
+ CDN=HFSNET_8 Q=psum_out[2] VDD=VDD VSS=VSS
Xpsum_out_reg_1_ decrq1 $PINS D=N_uc_41 ENN=HFSNET_5 CP=ZCTSNET_11 CDN=rst_n
+ Q=psum_out[1] VDD=VDD VSS=VSS
Xpsum_out_reg_0_ decrq1 $PINS D=copt_net_1891 ENN=HFSNET_5 CP=ZCTSNET_0
+ CDN=rst_n Q=psum_out[0] VDD=VDD VSS=VSS
Xpsum_out_reg_5_ decrq1 $PINS D=copt_net_2478 ENN=HFSNET_5 CP=ZCTSNET_1
+ CDN=rst_n Q=psum_out[5] VDD=VDD VSS=VSS
Xpsum_out_reg_6_ decrq1 $PINS D=copt_net_1181 ENN=HFSNET_5 CP=ZCTSNET_1
+ CDN=rst_n Q=psum_out[6] VDD=VDD VSS=VSS
Xpsum_out_reg_7_ decrq1 $PINS D=copt_net_2469 ENN=HFSNET_5 CP=ZCTSNET_1
+ CDN=rst_n Q=psum_out[7] VDD=VDD VSS=VSS
Xpsum_out_reg_8_ decrq1 $PINS D=copt_net_1125 ENN=array_en CP=ZCTSNET_1
+ CDN=rst_n Q=psum_out[8] VDD=VDD VSS=VSS
Xweight_reg_reg_7_ decrq1 $PINS D=weight_in[7] ENN=n13 CP=ZCTSNET_0
+ CDN=HFSNET_9 Q=weight_reg[7] VDD=VDD VSS=VSS
Xweight_reg_reg_6_ decrq1 $PINS D=weight_in[6] ENN=n13 CP=ZCTSNET_0
+ CDN=HFSNET_9 Q=weight_reg[6] VDD=VDD VSS=VSS
Xweight_reg_reg_5_ decrq1 $PINS D=weight_in[5] ENN=n13 CP=ZCTSNET_0
+ CDN=HFSNET_9 Q=weight_reg[5] VDD=VDD VSS=VSS
Xweight_reg_reg_4_ decrq1 $PINS D=weight_in[4] ENN=n13 CP=ZCTSNET_0
+ CDN=HFSNET_9 Q=weight_reg[4] VDD=VDD VSS=VSS
Xweight_reg_reg_3_ decrq1 $PINS D=weight_in[3] ENN=n13 CP=ZCTSNET_0
+ CDN=HFSNET_9 Q=weight_reg[3] VDD=VDD VSS=VSS
Xweight_reg_reg_2_ decrq1 $PINS D=weight_in[2] ENN=n13 CP=ZCTSNET_0
+ CDN=HFSNET_9 Q=weight_reg[2] VDD=VDD VSS=VSS
Xweight_reg_reg_1_ decrq1 $PINS D=weight_in[1] ENN=n13 CP=ZCTSNET_0
+ CDN=HFSNET_9 Q=weight_reg[1] VDD=VDD VSS=VSS
Xweight_reg_reg_0_ decrq1 $PINS D=weight_in[0] ENN=n13 CP=ZCTSNET_0
+ CDN=HFSNET_9 Q=weight_reg[0] VDD=VDD VSS=VSS
Xpsum_out_reg_9_ decrq1 $PINS D=N_uc_49 ENN=HFSNET_5 CP=ZCTSNET_0 CDN=rst_n
+ Q=psum_out[9] VDD=VDD VSS=VSS
Xpsum_out_reg_10_ decrq1 $PINS D=N_uc_50 ENN=array_en CP=ZCTSNET_1 CDN=rst_n
+ Q=psum_out[10] VDD=VDD VSS=VSS
Xpsum_out_reg_11_ decrq1 $PINS D=N_uc_51 ENN=array_en CP=ZCTSNET_1 CDN=rst_n
+ Q=psum_out[11] VDD=VDD VSS=VSS
Xpsum_out_reg_12_ decrq1 $PINS D=N_uc_52 ENN=array_en CP=ZCTSNET_1 CDN=rst_n
+ Q=psum_out[12] VDD=VDD VSS=VSS
Xpsum_out_reg_13_ decrq1 $PINS D=N_uc_53 ENN=HFSNET_5 CP=ZCTSNET_1 CDN=rst_n
+ Q=psum_out[13] VDD=VDD VSS=VSS
Xpsum_out_reg_14_ decrq1 $PINS D=N_uc_54 ENN=HFSNET_5 CP=ZCTSNET_11
+ CDN=HFSNET_8 Q=psum_out[14] VDD=VDD VSS=VSS
Xpsum_out_reg_15_ decrq1 $PINS D=N_uc_55 ENN=HFSNET_5 CP=ZCTSNET_10
+ CDN=HFSNET_8 Q=psum_out[15] VDD=VDD VSS=VSS
Xpsum_out_reg_16_ decrq1 $PINS D=N_uc_56 ENN=HFSNET_5 CP=ZCTSNET_10
+ CDN=HFSNET_8 Q=psum_out[16] VDD=VDD VSS=VSS
Xpsum_out_reg_17_ decrq1 $PINS D=N_uc_57 ENN=HFSNET_5 CP=ZCTSNET_11
+ CDN=HFSNET_8 Q=psum_out[17] VDD=VDD VSS=VSS
Xpsum_out_reg_18_ decrq1 $PINS D=N_uc_58 ENN=HFSNET_5 CP=ZCTSNET_0 CDN=rst_n
+ Q=psum_out[18] VDD=VDD VSS=VSS
Xpsum_out_reg_19_ decrq1 $PINS D=N_uc_59 ENN=HFSNET_5 CP=ZCTSNET_1 CDN=HFSNET_9
+ Q=psum_out[19] VDD=VDD VSS=VSS
Xpsum_out_reg_20_ decrq1 $PINS D=N_uc_60 ENN=HFSNET_7 CP=ZCTSNET_10
+ CDN=HFSNET_8 Q=psum_out[20] VDD=VDD VSS=VSS
Xpsum_out_reg_21_ decrq1 $PINS D=N_uc_61 ENN=HFSNET_5 CP=ZCTSNET_0 CDN=HFSNET_9
+ Q=psum_out[21] VDD=VDD VSS=VSS
Xpsum_out_reg_22_ decrq1 $PINS D=N_uc_62 ENN=HFSNET_5 CP=ZCTSNET_0 CDN=HFSNET_9
+ Q=psum_out[22] VDD=VDD VSS=VSS
Xpsum_out_reg_23_ decrq1 $PINS D=N_uc_63 ENN=HFSNET_5 CP=ZCTSNET_10
+ CDN=HFSNET_8 Q=psum_out[23] VDD=VDD VSS=VSS
Xpsum_out_reg_24_ decrq1 $PINS D=N_uc_64 ENN=HFSNET_5 CP=ZCTSNET_0 CDN=HFSNET_9
+ Q=psum_out[24] VDD=VDD VSS=VSS
Xpsum_out_reg_25_ decrq1 $PINS D=N_uc_65 ENN=HFSNET_7 CP=ZCTSNET_10
+ CDN=HFSNET_8 Q=psum_out[25] VDD=VDD VSS=VSS
Xpsum_out_reg_26_ decrq1 $PINS D=N_uc_66 ENN=HFSNET_7 CP=ZCTSNET_10
+ CDN=HFSNET_8 Q=psum_out[26] VDD=VDD VSS=VSS
Xpsum_out_reg_27_ decrq1 $PINS D=N_uc_67 ENN=HFSNET_5 CP=ZCTSNET_0 CDN=HFSNET_9
+ Q=psum_out[27] VDD=VDD VSS=VSS
Xpsum_out_reg_28_ decrq1 $PINS D=N_uc_68 ENN=HFSNET_5 CP=ZCTSNET_10
+ CDN=HFSNET_8 Q=psum_out[28] VDD=VDD VSS=VSS
Xpsum_out_reg_29_ decrq1 $PINS D=N_uc_69 ENN=HFSNET_5 CP=ZCTSNET_1 CDN=HFSNET_8
+ Q=psum_out[29] VDD=VDD VSS=VSS
Xpsum_out_reg_30_ decrq1 $PINS D=N_uc_70 ENN=HFSNET_5 CP=ZCTSNET_10
+ CDN=HFSNET_8 Q=psum_out[30] VDD=VDD VSS=VSS
Xpsum_out_reg_31_ decrq1 $PINS D=N_uc_71 ENN=HFSNET_5 CP=ZCTSNET_11
+ CDN=HFSNET_8 Q=psum_out[31] VDD=VDD VSS=VSS
XU19 inv0d2 $PINS I=n14 ZN=n2 VDD=VDD VSS=VSS
XHFSINV_23165_592 inv0d1 $PINS I=HFSNET_6 ZN=HFSNET_5 VDD=VDD VSS=VSS
Xcopt_h_inst_3957 dl01d1 $PINS I=N_uc_48 Z=copt_net_1125 VDD=VDD VSS=VSS
XU22 nd02d1 $PINS A1=weight_load A2=HFSNET_6 ZN=n13 VDD=VDD VSS=VSS
Xcopt_h_inst_4013 dl01d1 $PINS I=N_uc_46 Z=copt_net_1181 VDD=VDD VSS=VSS
Xcopt_h_inst_4044 dl01d1 $PINS I=N_uc_43 Z=copt_net_1212 VDD=VDD VSS=VSS
Xcopt_h_inst_4268 dl01d1 $PINS I=N_uc_42 Z=copt_net_1436 VDD=VDD VSS=VSS
XHFSINV_9425_544 inv0d1 $PINS I=HFSNET_4 ZN=HFSNET_2 VDD=VDD VSS=VSS
XU27 nd02d1 $PINS A1=N_uc_36 A2=HFSNET_3 ZN=n14 VDD=VDD VSS=VSS
Xcopt_h_inst_4723 dl01d1 $PINS I=N_uc_40 Z=copt_net_1891 VDD=VDD VSS=VSS
XHFSBUF_8986_549 buffd1 $PINS I=mode_unsigned Z=HFSNET_3 VDD=VDD VSS=VSS
Xcopt_h_inst_5302 dl01d1 $PINS I=N_uc_47 Z=copt_net_2469 VDD=VDD VSS=VSS
Xcopt_h_inst_5311 dl01d1 $PINS I=N_uc_45 Z=copt_net_2478 VDD=VDD VSS=VSS
Xcopt_h_inst_5324 dl01d1 $PINS I=N_uc_44 Z=copt_net_2491 VDD=VDD VSS=VSS
Xgre_a_INV_1495_inst_5811 inv0d1 $PINS I=weight_reg[0] ZN=gre_a_INV_1495_3
+ VDD=VDD VSS=VSS
Xcopt_h_inst_5601 dl01d1 $PINS I=act_in[3] Z=copt_net_2768 VDD=VDD VSS=VSS
Xcopt_h_inst_5607 dl01d1 $PINS I=act_in[2] Z=copt_net_2774 VDD=VDD VSS=VSS
Xcopt_h_inst_5609 dl01d1 $PINS I=act_in[1] Z=copt_net_2776 VDD=VDD VSS=VSS
Xcopt_h_inst_5613 dl01d1 $PINS I=act_in[0] Z=copt_net_2780 VDD=VDD VSS=VSS
Xcopt_h_inst_5618 dl01d1 $PINS I=act_in[6] Z=copt_net_2785 VDD=VDD VSS=VSS
Xcopt_h_inst_5620 dl01d1 $PINS I=act_in[4] Z=copt_net_2787 VDD=VDD VSS=VSS
Xcopt_h_inst_5622 dl01d1 $PINS I=act_in[7] Z=copt_net_2789 VDD=VDD VSS=VSS
Xcopt_h_inst_5625 dl01d1 $PINS I=act_in[5] Z=copt_net_2792 VDD=VDD VSS=VSS
Xgre_a_INV_2484_inst_5835 inv0d1 $PINS I=weight_reg[5] ZN=gre_a_INV_2484_3
+ VDD=VDD VSS=VSS
.ENDS

.SUBCKT unpu_pe_3_DW_mult_tc_0_DW_mult_tc_12 a[7] a[6] a[5] a[4] a[3] a[2] a[1]
+ a[0] b[7] b[6] b[5] b[4] b[3] b[2] b[1] b[0] product[15] product[14]
+ product[13] product[12] product[11] product[10] product[9] product[8]
+ product[7] product[6] product[5] product[4] product[3] product[2] product[1]
+ product[0] VDD VSS gre_a_INV_1961_2
XU2 ad01d0 $PINS A=n194 B=n61 CI=n2 CO=n1 S=product[14] VDD=VDD VSS=VSS
XU3 ad01d0 $PINS A=n17 B=n16 CI=n3 CO=n2 S=product[13] VDD=VDD VSS=VSS
XU4 ad01d0 $PINS A=n18 B=n19 CI=n4 CO=n3 S=product[12] VDD=VDD VSS=VSS
XU5 ad01d0 $PINS A=n20 B=n23 CI=n5 CO=n4 S=product[11] VDD=VDD VSS=VSS
XU6 ad01d0 $PINS A=n27 B=n24 CI=n6 CO=n5 S=product[10] VDD=VDD VSS=VSS
XU7 ad01d0 $PINS A=n33 B=n28 CI=n7 CO=n6 S=product[9] VDD=VDD VSS=VSS
XU8 ad01d0 $PINS A=n39 B=n34 CI=n8 CO=n7 S=product[8] VDD=VDD VSS=VSS
XU9 ad01d0 $PINS A=n45 B=n40 CI=n9 CO=n8 S=product[7] VDD=VDD VSS=VSS
XU10 ad01d0 $PINS A=n49 B=n46 CI=n10 CO=n9 S=product[6] VDD=VDD VSS=VSS
XU11 ad01d0 $PINS A=n53 B=n50 CI=n11 CO=n10 S=product[5] VDD=VDD VSS=VSS
XU12 ad01d0 $PINS A=n55 B=n54 CI=n12 CO=n11 S=product[4] VDD=VDD VSS=VSS
XU13 ad01d0 $PINS A=n59 B=n56 CI=n13 CO=n12 S=product[3] VDD=VDD VSS=VSS
XU14 ad01d0 $PINS A=n84 B=n91 CI=n14 CO=n13 S=product[2] VDD=VDD VSS=VSS
XU15 ah01d1 $PINS A=n92 B=n60 CO=n14 S=product[1] VDD=VDD VSS=VSS
XU17 ad01d0 $PINS A=n197 B=n62 CI=n69 CO=n17 S=n18 VDD=VDD VSS=VSS
XU18 ad01d0 $PINS A=n63 B=n25 CI=n22 CO=n19 S=n20 VDD=VDD VSS=VSS
XU20 ad01d0 $PINS A=n64 B=n26 CI=n29 CO=n23 S=n24 VDD=VDD VSS=VSS
XU21 ad01d0 $PINS A=n200 B=n70 CI=n77 CO=n25 S=n26 VDD=VDD VSS=VSS
XU22 ad01d0 $PINS A=n32 B=n35 CI=n30 CO=n27 S=n28 VDD=VDD VSS=VSS
XU23 ad01d0 $PINS A=n71 B=n65 CI=n37 CO=n29 S=n30 VDD=VDD VSS=VSS
XU25 ad01d0 $PINS A=n38 B=n41 CI=n36 CO=n33 S=n34 VDD=VDD VSS=VSS
XU26 ad01d0 $PINS A=n72 B=n85 CI=n43 CO=n35 S=n36 VDD=VDD VSS=VSS
XU29 ad01d0 $PINS A=n44 B=n47 CI=n42 CO=n39 S=n40 VDD=VDD VSS=VSS
XU30 ad01d0 $PINS A=n86 B=n73 CI=n79 CO=n41 S=n42 VDD=VDD VSS=VSS
XU32 ad01d0 $PINS A=n74 B=n51 CI=n48 CO=n45 S=n46 VDD=VDD VSS=VSS
XU33 ad01d0 $PINS A=n68 B=n87 CI=n80 CO=n47 S=n48 VDD=VDD VSS=VSS
XU34 ad01d0 $PINS A=n88 B=n81 CI=n52 CO=n49 S=n50 VDD=VDD VSS=VSS
XU36 ad01d0 $PINS A=n76 B=n89 CI=n82 CO=n53 S=n54 VDD=VDD VSS=VSS
XU37 ah01d1 $PINS A=n83 B=n90 CO=n55 S=n56 VDD=VDD VSS=VSS
XU145 oai21d1 $PINS B1=n202 B2=n249 A=n222 ZN=n77 VDD=VDD VSS=VSS
XU146 oai21d1 $PINS B1=n199 B2=n250 A=n232 ZN=n69 VDD=VDD VSS=VSS
XU147 oai21d1 $PINS B1=n196 B2=n251 A=n242 ZN=n61 VDD=VDD VSS=VSS
XU148 inv0d0 $PINS I=n16 ZN=n194 VDD=VDD VSS=VSS
XU149 inv0d0 $PINS I=n223 ZN=n199 VDD=VDD VSS=VSS
XU150 inv0d0 $PINS I=n214 ZN=n202 VDD=VDD VSS=VSS
XU151 inv0d0 $PINS I=n233 ZN=n196 VDD=VDD VSS=VSS
XU152 inv0d0 $PINS I=n32 ZN=n200 VDD=VDD VSS=VSS
XU153 inv0d0 $PINS I=n22 ZN=n197 VDD=VDD VSS=VSS
XU154 nd02d1 $PINS A1=n214 A2=n249 ZN=n216 VDD=VDD VSS=VSS
XU155 xr02d1 $PINS A1=a[2] A2=n203 Z=n214 VDD=VDD VSS=VSS
XU156 inv0d1 $PINS I=a[1] ZN=n203 VDD=VDD VSS=VSS
XU157 nd02d1 $PINS A1=n223 A2=n250 ZN=n225 VDD=VDD VSS=VSS
XU158 xr02d1 $PINS A1=a[4] A2=n201 Z=n223 VDD=VDD VSS=VSS
XU159 inv0d1 $PINS I=a[3] ZN=n201 VDD=VDD VSS=VSS
XU160 nd02d1 $PINS A1=a[1] A2=a[0] ZN=n206 VDD=VDD VSS=VSS
XU162 inv0d0 $PINS I=b[0] ZN=n205 VDD=VDD VSS=VSS
XU163 xr02d1 $PINS A1=a[6] A2=n198 Z=n233 VDD=VDD VSS=VSS
XU164 inv0d1 $PINS I=a[5] ZN=n198 VDD=VDD VSS=VSS
XU165 nd02d1 $PINS A1=n233 A2=n251 ZN=n235 VDD=VDD VSS=VSS
XU167 inv0d0 $PINS I=n1 ZN=product[15] VDD=VDD VSS=VSS
XU168 nr02d0 $PINS A1=a[0] A2=n205 ZN=product[0] VDD=VDD VSS=VSS
XU169 oai22d1 $PINS A1=b[0] A2=n206 B1=n207 B2=a[0] ZN=n92 VDD=VDD VSS=VSS
XU170 oai22d1 $PINS A1=n207 A2=n206 B1=n208 B2=a[0] ZN=n91 VDD=VDD VSS=VSS
XU171 xr02d1 $PINS A1=b[1] A2=n203 Z=n207 VDD=VDD VSS=VSS
XU172 oai22d1 $PINS A1=n208 A2=n206 B1=n209 B2=a[0] ZN=n90 VDD=VDD VSS=VSS
XU173 xr02d1 $PINS A1=b[2] A2=n203 Z=n208 VDD=VDD VSS=VSS
XU174 oai22d1 $PINS A1=n209 A2=n206 B1=n210 B2=a[0] ZN=n89 VDD=VDD VSS=VSS
XU175 xr02d1 $PINS A1=b[3] A2=n203 Z=n209 VDD=VDD VSS=VSS
XU176 oai22d1 $PINS A1=n210 A2=n206 B1=n211 B2=a[0] ZN=n88 VDD=VDD VSS=VSS
XU177 xr02d1 $PINS A1=b[4] A2=n203 Z=n210 VDD=VDD VSS=VSS
XU178 oai22d1 $PINS A1=n211 A2=n206 B1=n212 B2=a[0] ZN=n87 VDD=VDD VSS=VSS
XU179 xr02d1 $PINS A1=b[5] A2=n203 Z=n211 VDD=VDD VSS=VSS
XU180 oai22d1 $PINS A1=n212 A2=n206 B1=n213 B2=a[0] ZN=n86 VDD=VDD VSS=VSS
XU181 xr02d1 $PINS A1=b[6] A2=n203 Z=n212 VDD=VDD VSS=VSS
XU182 aor21d1 $PINS B1=a[0] B2=n206 A=n213 Z=n85 VDD=VDD VSS=VSS
XU183 xr02d1 $PINS A1=b[7] A2=n203 Z=n213 VDD=VDD VSS=VSS
XU184 nr02d0 $PINS A1=n214 A2=n205 ZN=n84 VDD=VDD VSS=VSS
XU185 oai22d1 $PINS A1=n216 A2=n215 B1=n214 B2=n217 ZN=n83 VDD=VDD VSS=VSS
XctmTdsLR_1_2991 an02d1 $PINS A1=n58 A2=n75 Z=n51 VDD=VDD VSS=VSS
XU187 oai22d1 $PINS A1=n217 A2=n216 B1=n214 B2=n218 ZN=n82 VDD=VDD VSS=VSS
XU188 xr02d1 $PINS A1=b[1] A2=n201 Z=n217 VDD=VDD VSS=VSS
XU189 oai22d1 $PINS A1=n218 A2=n216 B1=n214 B2=n219 ZN=n81 VDD=VDD VSS=VSS
XU190 xr02d1 $PINS A1=b[2] A2=n201 Z=n218 VDD=VDD VSS=VSS
XU191 oai22d1 $PINS A1=n219 A2=n216 B1=n214 B2=n220 ZN=n80 VDD=VDD VSS=VSS
XU192 xr02d1 $PINS A1=b[3] A2=n201 Z=n219 VDD=VDD VSS=VSS
XU193 oai22d1 $PINS A1=n220 A2=n216 B1=n214 B2=n221 ZN=n79 VDD=VDD VSS=VSS
XU194 xr02d1 $PINS A1=b[4] A2=n201 Z=n220 VDD=VDD VSS=VSS
XU195 nr02d0 $PINS A1=n223 A2=n205 ZN=n76 VDD=VDD VSS=VSS
XU196 oai22d1 $PINS A1=n225 A2=n224 B1=n223 B2=n226 ZN=n75 VDD=VDD VSS=VSS
XctmTdsLR_2_2992 aoim21d1 $PINS B1=n58 B2=n75 A=n51 ZN=n52 VDD=VDD VSS=VSS
XU198 oai22d1 $PINS A1=n226 A2=n225 B1=n223 B2=n227 ZN=n74 VDD=VDD VSS=VSS
XU199 xr02d1 $PINS A1=b[1] A2=n198 Z=n226 VDD=VDD VSS=VSS
XU200 oai22d1 $PINS A1=n227 A2=n225 B1=n223 B2=n228 ZN=n73 VDD=VDD VSS=VSS
XU201 xr02d1 $PINS A1=b[2] A2=n198 Z=n227 VDD=VDD VSS=VSS
XU202 oai22d1 $PINS A1=n228 A2=n225 B1=n223 B2=n229 ZN=n72 VDD=VDD VSS=VSS
XU203 xr02d1 $PINS A1=b[3] A2=n198 Z=n228 VDD=VDD VSS=VSS
XU204 oai22d1 $PINS A1=n229 A2=n225 B1=n223 B2=n230 ZN=n71 VDD=VDD VSS=VSS
XU205 xr02d1 $PINS A1=b[4] A2=n198 Z=n229 VDD=VDD VSS=VSS
XU206 oai22d1 $PINS A1=n230 A2=n225 B1=n223 B2=n231 ZN=n70 VDD=VDD VSS=VSS
XU207 xr02d1 $PINS A1=b[5] A2=n198 Z=n230 VDD=VDD VSS=VSS
XU208 nr02d0 $PINS A1=n233 A2=n205 ZN=n68 VDD=VDD VSS=VSS
XU209 oai22d1 $PINS A1=n235 A2=n234 B1=n236 B2=n233 ZN=n67 VDD=VDD VSS=VSS
XctmTdsLR_1_2993 an02d1 $PINS A1=n57 A2=n67 Z=n43 VDD=VDD VSS=VSS
XU211 oai22d1 $PINS A1=n237 A2=n235 B1=n233 B2=n238 ZN=n65 VDD=VDD VSS=VSS
XU212 oai22d1 $PINS A1=n238 A2=n235 B1=n233 B2=n239 ZN=n64 VDD=VDD VSS=VSS
XU213 xr02d1 $PINS A1=b[3] A2=gre_a_INV_1961_2 Z=n238 VDD=VDD VSS=VSS
XU214 oai22d1 $PINS A1=n239 A2=n235 B1=n233 B2=n240 ZN=n63 VDD=VDD VSS=VSS
XU215 xr02d1 $PINS A1=b[4] A2=gre_a_INV_1961_2 Z=n239 VDD=VDD VSS=VSS
XU216 oai22d1 $PINS A1=n240 A2=n235 B1=n233 B2=n241 ZN=n62 VDD=VDD VSS=VSS
XU217 xr02d1 $PINS A1=b[5] A2=gre_a_INV_1961_2 Z=n240 VDD=VDD VSS=VSS
XU218 oai21d1 $PINS B1=b[0] B2=n203 A=n206 ZN=n60 VDD=VDD VSS=VSS
XU219 oai21d1 $PINS B1=n201 B2=n216 A=n243 ZN=n59 VDD=VDD VSS=VSS
XU220 nd03d0 $PINS A1=n202 A2=n205 A3=a[3] ZN=n243 VDD=VDD VSS=VSS
XU221 oai21d1 $PINS B1=n198 B2=n225 A=n244 ZN=n58 VDD=VDD VSS=VSS
XU222 nd03d0 $PINS A1=n199 A2=n205 A3=a[5] ZN=n244 VDD=VDD VSS=VSS
XU223 oai21d1 $PINS B1=gre_a_INV_1961_2 B2=n235 A=n245 ZN=n57 VDD=VDD VSS=VSS
XU224 nd03d0 $PINS A1=n196 A2=n205 A3=a[7] ZN=n245 VDD=VDD VSS=VSS
XU225 xn02d1 $PINS A1=n246 A2=n247 ZN=n38 VDD=VDD VSS=VSS
XU226 or02d0 $PINS A1=n247 A2=n246 Z=n37 VDD=VDD VSS=VSS
XU227 oai22d1 $PINS A1=n236 A2=n235 B1=n233 B2=n237 ZN=n246 VDD=VDD VSS=VSS
XU228 xr02d1 $PINS A1=b[2] A2=gre_a_INV_1961_2 Z=n237 VDD=VDD VSS=VSS
XU229 xr02d1 $PINS A1=b[1] A2=gre_a_INV_1961_2 Z=n236 VDD=VDD VSS=VSS
XU230 oai22d1 $PINS A1=n221 A2=n216 B1=n214 B2=n248 ZN=n247 VDD=VDD VSS=VSS
XU231 xr02d1 $PINS A1=b[5] A2=n201 Z=n221 VDD=VDD VSS=VSS
XU232 aoim22d1 $PINS A1=n202 A2=n222 B1=n248 B2=n216 Z=n32 VDD=VDD VSS=VSS
XU233 xr02d1 $PINS A1=a[3] A2=a[2] Z=n249 VDD=VDD VSS=VSS
XU234 xr02d1 $PINS A1=b[6] A2=n201 Z=n248 VDD=VDD VSS=VSS
XU235 xr02d1 $PINS A1=b[7] A2=a[3] Z=n222 VDD=VDD VSS=VSS
XU236 aoim22d1 $PINS A1=n199 A2=n232 B1=n231 B2=n225 Z=n22 VDD=VDD VSS=VSS
XU237 xr02d1 $PINS A1=a[5] A2=a[4] Z=n250 VDD=VDD VSS=VSS
XU238 xr02d1 $PINS A1=b[6] A2=n198 Z=n231 VDD=VDD VSS=VSS
XU239 xr02d1 $PINS A1=b[7] A2=a[5] Z=n232 VDD=VDD VSS=VSS
XU240 aoim22d1 $PINS A1=n196 A2=n242 B1=n241 B2=n235 Z=n16 VDD=VDD VSS=VSS
XU241 xr02d1 $PINS A1=a[7] A2=a[6] Z=n251 VDD=VDD VSS=VSS
XU242 xr02d1 $PINS A1=b[6] A2=gre_a_INV_1961_2 Z=n241 VDD=VDD VSS=VSS
XU243 xr02d1 $PINS A1=b[7] A2=a[7] Z=n242 VDD=VDD VSS=VSS
XctmTdsLR_1_1352 aoim22d1 $PINS A1=n201 A2=b[0] B1=n201 B2=b[0] Z=n215 VDD=VDD
+ VSS=VSS
XctmTdsLR_1_1353 aoim22d1 $PINS A1=n198 A2=b[0] B1=n198 B2=b[0] Z=n224 VDD=VDD
+ VSS=VSS
XctmTdsLR_1_1354 aoim22d1 $PINS A1=gre_a_INV_1961_2 A2=b[0] B1=gre_a_INV_1961_2
+ B2=b[0] Z=n234 VDD=VDD VSS=VSS
XctmTdsLR_2_2994 aoim21d1 $PINS B1=n57 B2=n67 A=n43 ZN=n44 VDD=VDD VSS=VSS
.ENDS

.SUBCKT unpu_pe_3_DW_mult_uns_0_DW_mult_uns_13 a[7] a[6] a[5] a[4] a[3] a[2]
+ a[1] a[0] b[7] b[6] b[5] b[4] b[3] b[2] b[1] b[0] product[15] product[14]
+ product[13] product[12] product[11] product[10] product[9] product[8]
+ product[7] product[6] product[5] product[4] product[3] product[2] product[1]
+ product[0] VDD VSS
XU2 ad01d0 $PINS A=n99 B=n15 CI=n2 CO=product[15] S=product[14] VDD=VDD VSS=VSS
XU3 ad01d0 $PINS A=n16 B=n17 CI=n3 CO=n2 S=product[13] VDD=VDD VSS=VSS
XU4 ad01d0 $PINS A=n18 B=n21 CI=n4 CO=n3 S=product[12] VDD=VDD VSS=VSS
XU5 ad01d0 $PINS A=n27 B=n22 CI=n5 CO=n4 S=product[11] VDD=VDD VSS=VSS
XU6 ad01d0 $PINS A=n35 B=n28 CI=n6 CO=n5 S=product[10] VDD=VDD VSS=VSS
XU7 ad01d0 $PINS A=n45 B=n36 CI=n7 CO=n6 S=product[9] VDD=VDD VSS=VSS
XU8 ad01d0 $PINS A=n57 B=n46 CI=n8 CO=n7 S=product[8] VDD=VDD VSS=VSS
XU9 ad01d0 $PINS A=n69 B=n58 CI=n9 CO=n8 S=product[7] VDD=VDD VSS=VSS
XU10 ad01d0 $PINS A=n79 B=n70 CI=n10 CO=n9 S=product[6] VDD=VDD VSS=VSS
XU11 ad01d0 $PINS A=n87 B=n80 CI=n11 CO=n10 S=product[5] VDD=VDD VSS=VSS
XU12 ad01d0 $PINS A=n93 B=n88 CI=n12 CO=n11 S=product[4] VDD=VDD VSS=VSS
XU13 ad01d0 $PINS A=n96 B=n13 CI=n94 CO=n12 S=product[3] VDD=VDD VSS=VSS
XU14 ad01d0 $PINS A=n146 B=n14 CI=n98 CO=n13 S=product[2] VDD=VDD VSS=VSS
XU15 ah01d1 $PINS A=n161 B=n154 CO=n14 S=product[1] VDD=VDD VSS=VSS
XU16 ad01d0 $PINS A=n107 B=n100 CI=n19 CO=n15 S=n16 VDD=VDD VSS=VSS
XU17 ad01d0 $PINS A=n25 B=n20 CI=n23 CO=n17 S=n18 VDD=VDD VSS=VSS
XU18 ad01d0 $PINS A=n115 B=n101 CI=n108 CO=n19 S=n20 VDD=VDD VSS=VSS
XU19 ad01d0 $PINS A=n31 B=n24 CI=n29 CO=n21 S=n22 VDD=VDD VSS=VSS
XU20 ad01d0 $PINS A=n116 B=n33 CI=n26 CO=n23 S=n24 VDD=VDD VSS=VSS
XU21 ad01d0 $PINS A=n123 B=n102 CI=n109 CO=n25 S=n26 VDD=VDD VSS=VSS
XU22 ad01d0 $PINS A=n32 B=n37 CI=n30 CO=n27 S=n28 VDD=VDD VSS=VSS
XU23 ad01d0 $PINS A=n41 B=n34 CI=n39 CO=n29 S=n30 VDD=VDD VSS=VSS
XU24 ad01d0 $PINS A=n124 B=n117 CI=n43 CO=n31 S=n32 VDD=VDD VSS=VSS
XU25 ad01d0 $PINS A=n131 B=n103 CI=n110 CO=n33 S=n34 VDD=VDD VSS=VSS
XU26 ad01d0 $PINS A=n40 B=n47 CI=n38 CO=n35 S=n36 VDD=VDD VSS=VSS
XU27 ad01d0 $PINS A=n44 B=n51 CI=n49 CO=n37 S=n38 VDD=VDD VSS=VSS
XU28 ad01d0 $PINS A=n55 B=n53 CI=n42 CO=n39 S=n40 VDD=VDD VSS=VSS
XU29 ad01d0 $PINS A=n118 B=n125 CI=n132 CO=n41 S=n42 VDD=VDD VSS=VSS
XU30 ad01d0 $PINS A=n139 B=n104 CI=n111 CO=n43 S=n44 VDD=VDD VSS=VSS
XU31 ad01d0 $PINS A=n50 B=n59 CI=n48 CO=n45 S=n46 VDD=VDD VSS=VSS
XU32 ad01d0 $PINS A=n54 B=n52 CI=n61 CO=n47 S=n48 VDD=VDD VSS=VSS
XU33 ad01d0 $PINS A=n56 B=n65 CI=n63 CO=n49 S=n50 VDD=VDD VSS=VSS
XU34 ad01d0 $PINS A=n140 B=n133 CI=n67 CO=n51 S=n52 VDD=VDD VSS=VSS
XU35 ad01d0 $PINS A=n126 B=n119 CI=n147 CO=n53 S=n54 VDD=VDD VSS=VSS
XU36 ah01d1 $PINS A=n105 B=n112 CO=n55 S=n56 VDD=VDD VSS=VSS
XU37 ad01d0 $PINS A=n71 B=n62 CI=n60 CO=n57 S=n58 VDD=VDD VSS=VSS
XU38 ad01d0 $PINS A=n64 B=n66 CI=n73 CO=n59 S=n60 VDD=VDD VSS=VSS
XU39 ad01d0 $PINS A=n77 B=n68 CI=n75 CO=n61 S=n62 VDD=VDD VSS=VSS
XU40 ad01d0 $PINS A=n141 B=n127 CI=n134 CO=n63 S=n64 VDD=VDD VSS=VSS
XU41 ad01d0 $PINS A=n155 B=n120 CI=n148 CO=n65 S=n66 VDD=VDD VSS=VSS
XU42 ah01d1 $PINS A=n106 B=n113 CO=n67 S=n68 VDD=VDD VSS=VSS
XU43 ad01d0 $PINS A=n81 B=n74 CI=n72 CO=n69 S=n70 VDD=VDD VSS=VSS
XU44 ad01d0 $PINS A=n78 B=n83 CI=n76 CO=n71 S=n72 VDD=VDD VSS=VSS
XU45 ad01d0 $PINS A=n142 B=n135 CI=n85 CO=n73 S=n74 VDD=VDD VSS=VSS
XU46 ad01d0 $PINS A=n156 B=n128 CI=n149 CO=n75 S=n76 VDD=VDD VSS=VSS
XU47 ah01d1 $PINS A=n114 B=n121 CO=n77 S=n78 VDD=VDD VSS=VSS
XU48 ad01d0 $PINS A=n89 B=n84 CI=n82 CO=n79 S=n80 VDD=VDD VSS=VSS
XU49 ad01d0 $PINS A=n150 B=n91 CI=n86 CO=n81 S=n82 VDD=VDD VSS=VSS
XU50 ad01d0 $PINS A=n157 B=n136 CI=n143 CO=n83 S=n84 VDD=VDD VSS=VSS
XU51 ah01d1 $PINS A=n122 B=n129 CO=n85 S=n86 VDD=VDD VSS=VSS
XU52 ad01d1 $PINS A=n95 B=n92 CI=n90 CO=n87 S=n88 VDD=VDD VSS=VSS
XU53 ad01d1 $PINS A=n158 B=n144 CI=n151 CO=n89 S=n90 VDD=VDD VSS=VSS
XU54 ah01d1 $PINS A=n130 B=n137 CO=n91 S=n92 VDD=VDD VSS=VSS
XU55 ad01d0 $PINS A=n159 B=n152 CI=n97 CO=n93 S=n94 VDD=VDD VSS=VSS
XU56 ah01d1 $PINS A=n138 B=n145 CO=n95 S=n96 VDD=VDD VSS=VSS
XU57 ah01d1 $PINS A=n153 B=n160 CO=n97 S=n98 VDD=VDD VSS=VSS
XU140 inv0d0 $PINS I=b[4] ZN=n225 VDD=VDD VSS=VSS
XU141 inv0d0 $PINS I=a[1] ZN=n220 VDD=VDD VSS=VSS
XU142 inv0d0 $PINS I=b[2] ZN=n227 VDD=VDD VSS=VSS
XU144 inv0d1 $PINS I=a[2] ZN=n219 VDD=VDD VSS=VSS
XU145 inv0d0 $PINS I=b[3] ZN=n226 VDD=VDD VSS=VSS
XU146 inv0d0 $PINS I=a[5] ZN=n216 VDD=VDD VSS=VSS
XU147 inv0d1 $PINS I=b[1] ZN=n228 VDD=VDD VSS=VSS
XU148 inv0d0 $PINS I=b[0] ZN=n229 VDD=VDD VSS=VSS
XU149 inv0d0 $PINS I=a[4] ZN=n217 VDD=VDD VSS=VSS
XU150 inv0d0 $PINS I=b[6] ZN=n223 VDD=VDD VSS=VSS
XU151 inv0d0 $PINS I=a[3] ZN=n218 VDD=VDD VSS=VSS
XU152 inv0d0 $PINS I=b[5] ZN=n224 VDD=VDD VSS=VSS
XU153 inv0d0 $PINS I=b[7] ZN=n222 VDD=VDD VSS=VSS
XU154 inv0d0 $PINS I=a[6] ZN=n215 VDD=VDD VSS=VSS
XU156 nr02d0 $PINS A1=a[0] A2=n229 ZN=product[0] VDD=VDD VSS=VSS
XU157 nr02d0 $PINS A1=a[7] A2=n222 ZN=n99 VDD=VDD VSS=VSS
XU158 nr02d0 $PINS A1=a[0] A2=n228 ZN=n161 VDD=VDD VSS=VSS
XU159 nr02d0 $PINS A1=a[0] A2=n227 ZN=n160 VDD=VDD VSS=VSS
XU160 nr02d0 $PINS A1=a[0] A2=n226 ZN=n159 VDD=VDD VSS=VSS
XU161 nr02d0 $PINS A1=a[0] A2=n225 ZN=n158 VDD=VDD VSS=VSS
XU162 nr02d0 $PINS A1=a[0] A2=n224 ZN=n157 VDD=VDD VSS=VSS
XU163 nr02d1 $PINS A1=a[0] A2=n223 ZN=n156 VDD=VDD VSS=VSS
XU164 nr02d0 $PINS A1=a[0] A2=n222 ZN=n155 VDD=VDD VSS=VSS
XU165 nr02d0 $PINS A1=n229 A2=n220 ZN=n154 VDD=VDD VSS=VSS
XU166 nr02d0 $PINS A1=n228 A2=n220 ZN=n153 VDD=VDD VSS=VSS
XU167 nr02d0 $PINS A1=n227 A2=n220 ZN=n152 VDD=VDD VSS=VSS
XU168 nr02d0 $PINS A1=n226 A2=n220 ZN=n151 VDD=VDD VSS=VSS
XU169 nr02d0 $PINS A1=n225 A2=n220 ZN=n150 VDD=VDD VSS=VSS
XU170 nr02d0 $PINS A1=n224 A2=n220 ZN=n149 VDD=VDD VSS=VSS
XU171 nr02d0 $PINS A1=n223 A2=n220 ZN=n148 VDD=VDD VSS=VSS
XU172 nr02d0 $PINS A1=n222 A2=n220 ZN=n147 VDD=VDD VSS=VSS
XU173 nr02d0 $PINS A1=n229 A2=n219 ZN=n146 VDD=VDD VSS=VSS
XU174 nr02d0 $PINS A1=n228 A2=n219 ZN=n145 VDD=VDD VSS=VSS
XU175 nr02d0 $PINS A1=n227 A2=n219 ZN=n144 VDD=VDD VSS=VSS
XU176 nr02d0 $PINS A1=n226 A2=n219 ZN=n143 VDD=VDD VSS=VSS
XU177 nr02d0 $PINS A1=n225 A2=n219 ZN=n142 VDD=VDD VSS=VSS
XU178 nr02d0 $PINS A1=n224 A2=n219 ZN=n141 VDD=VDD VSS=VSS
XU179 nr02d0 $PINS A1=n223 A2=n219 ZN=n140 VDD=VDD VSS=VSS
XU180 nr02d0 $PINS A1=n222 A2=n219 ZN=n139 VDD=VDD VSS=VSS
XU181 nr02d0 $PINS A1=n229 A2=n218 ZN=n138 VDD=VDD VSS=VSS
XU182 nr02d0 $PINS A1=n228 A2=n218 ZN=n137 VDD=VDD VSS=VSS
XU183 nr02d0 $PINS A1=n227 A2=n218 ZN=n136 VDD=VDD VSS=VSS
XU184 nr02d0 $PINS A1=n226 A2=n218 ZN=n135 VDD=VDD VSS=VSS
XU185 nr02d0 $PINS A1=n225 A2=n218 ZN=n134 VDD=VDD VSS=VSS
XU186 nr02d0 $PINS A1=n224 A2=n218 ZN=n133 VDD=VDD VSS=VSS
XU187 nr02d0 $PINS A1=n223 A2=n218 ZN=n132 VDD=VDD VSS=VSS
XU188 nr02d0 $PINS A1=n222 A2=n218 ZN=n131 VDD=VDD VSS=VSS
XU189 nr02d0 $PINS A1=n229 A2=n217 ZN=n130 VDD=VDD VSS=VSS
XU190 nr02d0 $PINS A1=n228 A2=n217 ZN=n129 VDD=VDD VSS=VSS
XU191 nr02d0 $PINS A1=n227 A2=n217 ZN=n128 VDD=VDD VSS=VSS
XU192 nr02d0 $PINS A1=n226 A2=n217 ZN=n127 VDD=VDD VSS=VSS
XU193 nr02d0 $PINS A1=n225 A2=n217 ZN=n126 VDD=VDD VSS=VSS
XU194 nr02d0 $PINS A1=n224 A2=n217 ZN=n125 VDD=VDD VSS=VSS
XU195 nr02d0 $PINS A1=n223 A2=n217 ZN=n124 VDD=VDD VSS=VSS
XU196 nr02d0 $PINS A1=n222 A2=n217 ZN=n123 VDD=VDD VSS=VSS
XU197 nr02d0 $PINS A1=n229 A2=n216 ZN=n122 VDD=VDD VSS=VSS
XU198 nr02d0 $PINS A1=n228 A2=n216 ZN=n121 VDD=VDD VSS=VSS
XU199 nr02d0 $PINS A1=n227 A2=n216 ZN=n120 VDD=VDD VSS=VSS
XU200 nr02d0 $PINS A1=n226 A2=n216 ZN=n119 VDD=VDD VSS=VSS
XU201 nr02d0 $PINS A1=n225 A2=n216 ZN=n118 VDD=VDD VSS=VSS
XU202 nr02d0 $PINS A1=n224 A2=n216 ZN=n117 VDD=VDD VSS=VSS
XU203 nr02d0 $PINS A1=n223 A2=n216 ZN=n116 VDD=VDD VSS=VSS
XU204 nr02d0 $PINS A1=n222 A2=n216 ZN=n115 VDD=VDD VSS=VSS
XU205 nr02d0 $PINS A1=n229 A2=n215 ZN=n114 VDD=VDD VSS=VSS
XU206 nr02d0 $PINS A1=n228 A2=n215 ZN=n113 VDD=VDD VSS=VSS
XU207 nr02d0 $PINS A1=n227 A2=n215 ZN=n112 VDD=VDD VSS=VSS
XU208 nr02d0 $PINS A1=n226 A2=n215 ZN=n111 VDD=VDD VSS=VSS
XU209 nr02d0 $PINS A1=n225 A2=n215 ZN=n110 VDD=VDD VSS=VSS
XU210 nr02d0 $PINS A1=n224 A2=n215 ZN=n109 VDD=VDD VSS=VSS
XU211 nr02d0 $PINS A1=n223 A2=n215 ZN=n108 VDD=VDD VSS=VSS
XU212 nr02d0 $PINS A1=n222 A2=n215 ZN=n107 VDD=VDD VSS=VSS
XU213 nr02d0 $PINS A1=n229 A2=a[7] ZN=n106 VDD=VDD VSS=VSS
XU214 nr02d0 $PINS A1=a[7] A2=n228 ZN=n105 VDD=VDD VSS=VSS
XU215 nr02d0 $PINS A1=a[7] A2=n227 ZN=n104 VDD=VDD VSS=VSS
XU216 nr02d0 $PINS A1=a[7] A2=n226 ZN=n103 VDD=VDD VSS=VSS
XU217 nr02d0 $PINS A1=a[7] A2=n225 ZN=n102 VDD=VDD VSS=VSS
XU218 nr02d0 $PINS A1=a[7] A2=n224 ZN=n101 VDD=VDD VSS=VSS
XU219 nr02d0 $PINS A1=a[7] A2=n223 ZN=n100 VDD=VDD VSS=VSS
.ENDS

.SUBCKT unpu_pe_3_DW01_add_0_DW01_add_4 A[31] A[30] A[29] A[28] A[27] A[26]
+ A[25] A[24] A[23] A[22] A[21] A[20] A[19] A[18] A[17] A[16] A[15] A[14] A[13]
+ A[12] A[11] A[10] A[9] A[8] A[7] A[6] A[5] A[4] A[3] A[2] A[1] A[0] B[31]
+ B[30] B[29] B[28] B[27] B[26] B[25] B[24] B[23] B[22] B[21] B[20] B[19] B[18]
+ B[17] B[16] B[15] B[14] B[13] B[12] B[11] B[10] B[9] B[8] B[7] B[6] B[5] B[4]
+ B[3] B[2] B[1] B[0] CI SUM[31] SUM[30] SUM[29] SUM[28] SUM[27] SUM[26]
+ SUM[25] SUM[24] SUM[23] SUM[22] SUM[21] SUM[20] SUM[19] SUM[18] SUM[17]
+ SUM[16] SUM[15] SUM[14] SUM[13] SUM[12] SUM[11] SUM[10] SUM[9] SUM[8] SUM[7]
+ SUM[6] SUM[5] SUM[4] SUM[3] SUM[2] SUM[1] SUM[0] CO VDD VSS
XU1_31 ad01d0 $PINS A=copt_net_1594 B=B[31] CI=carry[31] S=SUM[31] VDD=VDD
+ VSS=VSS
XU1_30 ad01d0 $PINS A=copt_net_1593 B=B[30] CI=carry[30] CO=carry[31] S=SUM[30]
+ VDD=VDD VSS=VSS
XU1_29 ad01d0 $PINS A=copt_net_1725 B=B[29] CI=carry[29] CO=carry[30] S=SUM[29]
+ VDD=VDD VSS=VSS
XU1_28 ad01d0 $PINS A=copt_net_2458 B=B[28] CI=carry[28] CO=carry[29] S=SUM[28]
+ VDD=VDD VSS=VSS
XU1_27 ad01d0 $PINS A=copt_net_905 B=B[27] CI=carry[27] CO=carry[28] S=SUM[27]
+ VDD=VDD VSS=VSS
XU1_26 ad01d1 $PINS A=copt_net_1584 B=B[26] CI=carry[26] CO=carry[27] S=SUM[26]
+ VDD=VDD VSS=VSS
XU1_25 ad01d0 $PINS A=copt_net_1509 B=B[25] CI=carry[25] CO=carry[26] S=SUM[25]
+ VDD=VDD VSS=VSS
XU1_24 ad01d0 $PINS A=copt_net_2144 B=B[24] CI=carry[24] CO=carry[25] S=SUM[24]
+ VDD=VDD VSS=VSS
XU1_23 ad01d0 $PINS A=copt_net_1315 B=B[23] CI=carry[23] CO=carry[24] S=SUM[23]
+ VDD=VDD VSS=VSS
XU1_22 ad01d0 $PINS A=copt_net_2140 B=B[22] CI=carry[22] CO=carry[23] S=SUM[22]
+ VDD=VDD VSS=VSS
XU1_21 ad01d0 $PINS A=copt_net_1260 B=B[21] CI=carry[21] CO=carry[22] S=SUM[21]
+ VDD=VDD VSS=VSS
XU1_20 ad01d0 $PINS A=copt_net_1422 B=B[20] CI=carry[20] CO=carry[21] S=SUM[20]
+ VDD=VDD VSS=VSS
XU1_19 ad01d0 $PINS A=copt_net_1739 B=B[19] CI=carry[19] CO=carry[20] S=SUM[19]
+ VDD=VDD VSS=VSS
XU1_18 ad01d0 $PINS A=copt_net_1823 B=B[18] CI=carry[18] CO=carry[19] S=SUM[18]
+ VDD=VDD VSS=VSS
XU1_17 ad01d0 $PINS A=copt_net_1726 B=B[17] CI=carry[17] CO=carry[18] S=SUM[17]
+ VDD=VDD VSS=VSS
XU1_16 ad01d0 $PINS A=copt_net_1452 B=B[16] CI=carry[16] CO=carry[17] S=SUM[16]
+ VDD=VDD VSS=VSS
XU1_15 ad01d0 $PINS A=copt_net_1903 B=B[15] CI=carry[15] CO=carry[16] S=SUM[15]
+ VDD=VDD VSS=VSS
XU1_14 ad01d0 $PINS A=copt_net_1699 B=B[14] CI=carry[14] CO=carry[15] S=SUM[14]
+ VDD=VDD VSS=VSS
XU1_13 ad01d0 $PINS A=copt_net_1787 B=B[13] CI=carry[13] CO=carry[14] S=SUM[13]
+ VDD=VDD VSS=VSS
XU1_12 ad01d0 $PINS A=copt_net_1686 B=B[12] CI=carry[12] CO=carry[13] S=SUM[12]
+ VDD=VDD VSS=VSS
XU1_11 ad01d0 $PINS A=copt_net_1707 B=B[11] CI=carry[11] CO=carry[12] S=SUM[11]
+ VDD=VDD VSS=VSS
XU1_10 ad01d0 $PINS A=copt_net_2161 B=B[10] CI=carry[10] CO=carry[11] S=SUM[10]
+ VDD=VDD VSS=VSS
XU1_9 ad01d0 $PINS A=copt_net_2000 B=B[9] CI=carry[9] CO=carry[10] S=SUM[9]
+ VDD=VDD VSS=VSS
XU1_8 ad01d0 $PINS A=copt_net_2107 B=B[8] CI=carry[8] CO=carry[9] S=SUM[8]
+ VDD=VDD VSS=VSS
XU1_7 ad01d0 $PINS A=copt_net_1989 B=B[7] CI=carry[7] CO=carry[8] S=SUM[7]
+ VDD=VDD VSS=VSS
XU1_6 ad01d0 $PINS A=copt_net_1999 B=B[6] CI=carry[6] CO=carry[7] S=SUM[6]
+ VDD=VDD VSS=VSS
XU1_5 ad01d0 $PINS A=copt_net_1588 B=B[5] CI=carry[5] CO=carry[6] S=SUM[5]
+ VDD=VDD VSS=VSS
XU1_4 ad01d0 $PINS A=copt_net_1529 B=B[4] CI=carry[4] CO=carry[5] S=SUM[4]
+ VDD=VDD VSS=VSS
XU1_3 ad01d0 $PINS A=copt_net_1846 B=B[3] CI=carry[3] CO=carry[4] S=SUM[3]
+ VDD=VDD VSS=VSS
XU1_2 ad01d0 $PINS A=copt_net_1640 B=B[2] CI=carry[2] CO=carry[3] S=SUM[2]
+ VDD=VDD VSS=VSS
XU1_1 ad01d0 $PINS A=copt_net_1940 B=B[1] CI=n1 CO=carry[2] S=SUM[1] VDD=VDD
+ VSS=VSS
XU1 an02d1 $PINS A1=B[0] A2=copt_net_1647 Z=n1 VDD=VDD VSS=VSS
XU2 xr02d1 $PINS A1=copt_net_1647 A2=B[0] Z=SUM[0] VDD=VDD VSS=VSS
Xcopt_h_inst_3737 dl02d1 $PINS I=A[27] Z=copt_net_905 VDD=VDD VSS=VSS
Xcopt_h_inst_4092 dl02d1 $PINS I=A[21] Z=copt_net_1260 VDD=VDD VSS=VSS
Xcopt_h_inst_4147 dl01d1 $PINS I=A[23] Z=copt_net_1315 VDD=VDD VSS=VSS
Xcopt_h_inst_4254 dl01d1 $PINS I=A[20] Z=copt_net_1422 VDD=VDD VSS=VSS
Xcopt_h_inst_4284 dl01d1 $PINS I=A[16] Z=copt_net_1452 VDD=VDD VSS=VSS
Xcopt_h_inst_4341 dl01d1 $PINS I=A[25] Z=copt_net_1509 VDD=VDD VSS=VSS
Xcopt_h_inst_4361 dl01d1 $PINS I=A[4] Z=copt_net_1529 VDD=VDD VSS=VSS
Xcopt_h_inst_4416 dl01d1 $PINS I=A[26] Z=copt_net_1584 VDD=VDD VSS=VSS
Xcopt_h_inst_4420 dl01d1 $PINS I=A[5] Z=copt_net_1588 VDD=VDD VSS=VSS
Xcopt_h_inst_4425 dl01d1 $PINS I=A[30] Z=copt_net_1593 VDD=VDD VSS=VSS
Xcopt_h_inst_4426 dl01d1 $PINS I=A[31] Z=copt_net_1594 VDD=VDD VSS=VSS
Xcopt_h_inst_4472 dl01d1 $PINS I=A[2] Z=copt_net_1640 VDD=VDD VSS=VSS
Xcopt_h_inst_4479 dl01d1 $PINS I=A[0] Z=copt_net_1647 VDD=VDD VSS=VSS
Xcopt_h_inst_4518 dl01d1 $PINS I=A[12] Z=copt_net_1686 VDD=VDD VSS=VSS
Xcopt_h_inst_4531 dl01d1 $PINS I=A[14] Z=copt_net_1699 VDD=VDD VSS=VSS
Xcopt_h_inst_4539 dl01d1 $PINS I=A[11] Z=copt_net_1707 VDD=VDD VSS=VSS
Xcopt_h_inst_4557 dl01d1 $PINS I=A[29] Z=copt_net_1725 VDD=VDD VSS=VSS
Xcopt_h_inst_4558 dl01d1 $PINS I=A[17] Z=copt_net_1726 VDD=VDD VSS=VSS
Xcopt_h_inst_4571 dl01d1 $PINS I=A[19] Z=copt_net_1739 VDD=VDD VSS=VSS
Xcopt_h_inst_4619 dl01d1 $PINS I=A[13] Z=copt_net_1787 VDD=VDD VSS=VSS
Xcopt_h_inst_4655 dl01d1 $PINS I=A[18] Z=copt_net_1823 VDD=VDD VSS=VSS
Xcopt_h_inst_4678 dl01d1 $PINS I=A[3] Z=copt_net_1846 VDD=VDD VSS=VSS
Xcopt_h_inst_4735 dl01d1 $PINS I=A[15] Z=copt_net_1903 VDD=VDD VSS=VSS
Xcopt_h_inst_4772 dl01d1 $PINS I=A[1] Z=copt_net_1940 VDD=VDD VSS=VSS
Xcopt_h_inst_4822 dl01d1 $PINS I=A[7] Z=copt_net_1989 VDD=VDD VSS=VSS
Xcopt_h_inst_4832 dl01d1 $PINS I=A[6] Z=copt_net_1999 VDD=VDD VSS=VSS
Xcopt_h_inst_4833 dl01d1 $PINS I=A[9] Z=copt_net_2000 VDD=VDD VSS=VSS
Xcopt_h_inst_4940 dl01d1 $PINS I=A[8] Z=copt_net_2107 VDD=VDD VSS=VSS
Xcopt_h_inst_4973 dl01d1 $PINS I=A[22] Z=copt_net_2140 VDD=VDD VSS=VSS
Xcopt_h_inst_4977 dl01d1 $PINS I=A[24] Z=copt_net_2144 VDD=VDD VSS=VSS
Xcopt_h_inst_4994 dl01d1 $PINS I=A[10] Z=copt_net_2161 VDD=VDD VSS=VSS
Xcopt_h_inst_5291 dl01d1 $PINS I=A[28] Z=copt_net_2458 VDD=VDD VSS=VSS
.ENDS

.SUBCKT unpu_pe_3 rst_n array_en weight_load mode_unsigned weight_in[7]
+ weight_in[6] weight_in[5] weight_in[4] weight_in[3] weight_in[2] weight_in[1]
+ weight_in[0] act_in[7] act_in[6] act_in[5] act_in[4] act_in[3] act_in[2]
+ act_in[1] act_in[0] psum_in[31] psum_in[30] psum_in[29] psum_in[28]
+ psum_in[27] psum_in[26] psum_in[25] psum_in[24] psum_in[23] psum_in[22]
+ psum_in[21] psum_in[20] psum_in[19] psum_in[18] psum_in[17] psum_in[16]
+ psum_in[15] psum_in[14] psum_in[13] psum_in[12] psum_in[11] psum_in[10]
+ psum_in[9] psum_in[8] psum_in[7] psum_in[6] psum_in[5] psum_in[4] psum_in[3]
+ psum_in[2] psum_in[1] psum_in[0] act_out[7] act_out[6] act_out[5] act_out[4]
+ act_out[3] act_out[2] act_out[1] act_out[0] psum_out[31] psum_out[30]
+ psum_out[29] psum_out[28] psum_out[27] psum_out[26] psum_out[25] psum_out[24]
+ psum_out[23] psum_out[22] psum_out[21] psum_out[20] psum_out[19] psum_out[18]
+ psum_out[17] psum_out[16] psum_out[15] psum_out[14] psum_out[13] psum_out[12]
+ psum_out[11] psum_out[10] psum_out[9] psum_out[8] psum_out[7] psum_out[6]
+ psum_out[5] psum_out[4] psum_out[3] psum_out[2] psum_out[1] psum_out[0] VDD
+ VSS ZCTSNET_12 HFSNET_2 HFSNET_3 HFSNET_4 HFSNET_5 HFSNET_6 HFSNET_7 HFSNET_8
+ HFSNET_9 HFSNET_10 ZCTSNET_0 ZCTSNET_2
XU2 aor22d1 $PINS A1=N_uc_30 A2=mode_unsigned B1=HFSNET_2 B2=N_uc_14
+ Z=product[9] VDD=VDD VSS=VSS
XU3 aor22d1 $PINS A1=N_uc_29 A2=mode_unsigned B1=N_uc_13 B2=HFSNET_2
+ Z=product[8] VDD=VDD VSS=VSS
XU5 aor22d1 $PINS A1=N_uc_28 A2=mode_unsigned B1=N_uc_12 B2=HFSNET_2
+ Z=product[7] VDD=VDD VSS=VSS
XU6 aor22d1 $PINS A1=N_uc_27 A2=mode_unsigned B1=N_uc_11 B2=HFSNET_2
+ Z=product[6] VDD=VDD VSS=VSS
XU7 aor22d1 $PINS A1=N_uc_26 A2=mode_unsigned B1=N_uc_10 B2=HFSNET_2
+ Z=product[5] VDD=VDD VSS=VSS
XU8 aor22d1 $PINS A1=N_uc_9 A2=HFSNET_2 B1=N_uc_25 B2=mode_unsigned
+ Z=product[4] VDD=VDD VSS=VSS
XU9 aor22d1 $PINS A1=N_uc_8 A2=HFSNET_2 B1=N_uc_24 B2=mode_unsigned
+ Z=product[3] VDD=VDD VSS=VSS
XU10 aor22d1 $PINS A1=N_uc_7 A2=HFSNET_2 B1=N_uc_23 B2=mode_unsigned
+ Z=product[2] VDD=VDD VSS=VSS
XU11 aor22d1 $PINS A1=N_uc_6 A2=HFSNET_2 B1=N_uc_22 B2=mode_unsigned
+ Z=product[1] VDD=VDD VSS=VSS
XU12 oaim21d1 $PINS B1=N_uc_20 B2=HFSNET_2 A=n16 ZN=product[15] VDD=VDD VSS=VSS
XU13 aor22d1 $PINS A1=N_uc_35 A2=mode_unsigned B1=N_uc_19 B2=HFSNET_2
+ Z=product[14] VDD=VDD VSS=VSS
XU14 aor22d1 $PINS A1=N_uc_34 A2=mode_unsigned B1=N_uc_18 B2=HFSNET_2
+ Z=product[13] VDD=VDD VSS=VSS
XU15 aor22d1 $PINS A1=N_uc_33 A2=mode_unsigned B1=N_uc_17 B2=HFSNET_2
+ Z=product[12] VDD=VDD VSS=VSS
XU16 aor22d1 $PINS A1=N_uc_32 A2=mode_unsigned B1=N_uc_16 B2=HFSNET_2
+ Z=product[11] VDD=VDD VSS=VSS
XU17 aor22d1 $PINS A1=N_uc_31 A2=mode_unsigned B1=N_uc_15 B2=HFSNET_2
+ Z=product[10] VDD=VDD VSS=VSS
XU18 aor22d1 $PINS A1=N_uc_5 A2=HFSNET_2 B1=N_uc_21 B2=mode_unsigned
+ Z=product[0] VDD=VDD VSS=VSS
Xadd_42 unpu_pe_3_DW01_add_0_DW01_add_4 $PINS A[31]=psum_in[31]
+ A[30]=psum_in[30] A[29]=psum_in[29] A[28]=psum_in[28] A[27]=psum_in[27]
+ A[26]=psum_in[26] A[25]=psum_in[25] A[24]=psum_in[24] A[23]=psum_in[23]
+ A[22]=psum_in[22] A[21]=psum_in[21] A[20]=psum_in[20] A[19]=psum_in[19]
+ A[18]=psum_in[18] A[17]=psum_in[17] A[16]=psum_in[16] A[15]=psum_in[15]
+ A[14]=psum_in[14] A[13]=psum_in[13] A[12]=psum_in[12] A[11]=psum_in[11]
+ A[10]=psum_in[10] A[9]=psum_in[9] A[8]=psum_in[8] A[7]=psum_in[7]
+ A[6]=psum_in[6] A[5]=psum_in[5] A[4]=psum_in[4] A[3]=psum_in[3] A[2]=psum_in[2]
+ A[1]=psum_in[1] A[0]=psum_in[0] B[31]=n2 B[30]=n2 B[29]=n2 B[28]=n2 B[27]=n2
+ B[26]=n2 B[25]=n2 B[24]=n2 B[23]=n2 B[22]=n2 B[21]=n2 B[20]=n2 B[19]=n2
+ B[18]=n2 B[17]=n2 B[16]=n2 B[15]=product[15] B[14]=product[14]
+ B[13]=product[13] B[12]=product[12] B[11]=product[11] B[10]=product[10]
+ B[9]=product[9] B[8]=product[8] B[7]=product[7] B[6]=product[6] B[5]=product[5]
+ B[4]=product[4] B[3]=product[3] B[2]=product[2] B[1]=product[1] B[0]=product[0]
+ CI=VSS SUM[31]=N_uc_71 SUM[30]=N_uc_70 SUM[29]=N_uc_69 SUM[28]=N_uc_68
+ SUM[27]=N_uc_67 SUM[26]=N_uc_66 SUM[25]=N_uc_65 SUM[24]=N_uc_64 SUM[23]=N_uc_63
+ SUM[22]=N_uc_62 SUM[21]=N_uc_61 SUM[20]=N_uc_60 SUM[19]=N_uc_59 SUM[18]=N_uc_58
+ SUM[17]=N_uc_57 SUM[16]=N_uc_56 SUM[15]=N_uc_55 SUM[14]=N_uc_54 SUM[13]=N_uc_53
+ SUM[12]=N_uc_52 SUM[11]=N_uc_51 SUM[10]=N_uc_50 SUM[9]=N_uc_49 SUM[8]=N_uc_48
+ SUM[7]=N_uc_47 SUM[6]=N_uc_46 SUM[5]=N_uc_45 SUM[4]=N_uc_44 SUM[3]=N_uc_43
+ SUM[2]=N_uc_42 SUM[1]=N_uc_41 SUM[0]=N_uc_40 VDD=VDD VSS=VSS
Xmult_28 unpu_pe_3_DW_mult_uns_0_DW_mult_uns_13 $PINS a[7]=gre_a_INV_1961_3
+ a[6]=weight_reg[6] a[5]=weight_reg[5] a[4]=weight_reg[4] a[3]=weight_reg[3]
+ a[2]=weight_reg[2] a[1]=weight_reg[1] a[0]=gre_a_INV_1497_3 b[7]=act_in[7]
+ b[6]=act_in[6] b[5]=act_in[5] b[4]=act_in[4] b[3]=act_in[3] b[2]=act_in[2]
+ b[1]=act_in[1] b[0]=act_in[0] product[15]=N_uc_20 product[14]=N_uc_19
+ product[13]=N_uc_18 product[12]=N_uc_17 product[11]=N_uc_16 product[10]=N_uc_15
+ product[9]=N_uc_14 product[8]=N_uc_13 product[7]=N_uc_12 product[6]=N_uc_11
+ product[5]=N_uc_10 product[4]=N_uc_9 product[3]=N_uc_8 product[2]=N_uc_7
+ product[1]=N_uc_6 product[0]=N_uc_5 VDD=VDD VSS=VSS
Xmult_30 unpu_pe_3_DW_mult_tc_0_DW_mult_tc_12 $PINS a[7]=weight_reg[7]
+ a[6]=weight_reg[6] a[5]=weight_reg[5] a[4]=weight_reg[4] a[3]=weight_reg[3]
+ a[2]=weight_reg[2] a[1]=weight_reg[1] a[0]=gre_a_INV_1497_3 b[7]=act_in[7]
+ b[6]=act_in[6] b[5]=act_in[5] b[4]=act_in[4] b[3]=act_in[3] b[2]=act_in[2]
+ b[1]=act_in[1] b[0]=act_in[0] product[15]=N_uc_36 product[14]=N_uc_35
+ product[13]=N_uc_34 product[12]=N_uc_33 product[11]=N_uc_32 product[10]=N_uc_31
+ product[9]=N_uc_30 product[8]=N_uc_29 product[7]=N_uc_28 product[6]=N_uc_27
+ product[5]=N_uc_26 product[4]=N_uc_25 product[3]=N_uc_24 product[2]=N_uc_23
+ product[1]=N_uc_22 product[0]=N_uc_21 VDD=VDD VSS=VSS
+ gre_a_INV_1961_2=gre_a_INV_1961_3
Xact_out_reg_3_ decrq1 $PINS D=act_in[3] ENN=HFSNET_7 CP=ZCTSNET_2 CDN=HFSNET_8
+ Q=act_out[3] VDD=VDD VSS=VSS
Xact_out_reg_2_ decrq1 $PINS D=copt_net_259 ENN=array_en CP=ZCTSNET_12
+ CDN=rst_n Q=act_out[2] VDD=VDD VSS=VSS
Xact_out_reg_1_ decrq1 $PINS D=act_in[1] ENN=array_en CP=ZCTSNET_12 CDN=rst_n
+ Q=act_out[1] VDD=VDD VSS=VSS
Xact_out_reg_7_ decrq1 $PINS D=act_in[7] ENN=array_en CP=ZCTSNET_12 CDN=rst_n
+ Q=act_out[7] VDD=VDD VSS=VSS
Xact_out_reg_6_ decrq1 $PINS D=act_in[6] ENN=array_en CP=ZCTSNET_0 CDN=rst_n
+ Q=act_out[6] VDD=VDD VSS=VSS
Xact_out_reg_5_ decrq1 $PINS D=copt_net_297 ENN=array_en CP=ZCTSNET_12
+ CDN=rst_n Q=act_out[5] VDD=VDD VSS=VSS
Xact_out_reg_4_ decrq1 $PINS D=copt_net_2413 ENN=array_en CP=ZCTSNET_12
+ CDN=rst_n Q=act_out[4] VDD=VDD VSS=VSS
Xact_out_reg_0_ decrq1 $PINS D=copt_net_304 ENN=HFSNET_3 CP=ZCTSNET_0 CDN=rst_n
+ Q=act_out[0] VDD=VDD VSS=VSS
Xpsum_out_reg_7_ decrq1 $PINS D=N_uc_47 ENN=HFSNET_5 CP=ZCTSNET_2 CDN=HFSNET_8
+ Q=psum_out[7] VDD=VDD VSS=VSS
Xpsum_out_reg_6_ decrq1 $PINS D=N_uc_46 ENN=HFSNET_7 CP=ZCTSNET_2 CDN=HFSNET_9
+ Q=psum_out[6] VDD=VDD VSS=VSS
Xpsum_out_reg_5_ decrq1 $PINS D=N_uc_45 ENN=HFSNET_7 CP=ZCTSNET_0 CDN=HFSNET_9
+ Q=psum_out[5] VDD=VDD VSS=VSS
Xpsum_out_reg_4_ decrq1 $PINS D=N_uc_44 ENN=HFSNET_7 CP=ZCTSNET_12 CDN=rst_n
+ Q=psum_out[4] VDD=VDD VSS=VSS
Xpsum_out_reg_3_ decrq1 $PINS D=N_uc_43 ENN=HFSNET_7 CP=ZCTSNET_2 CDN=rst_n
+ Q=psum_out[3] VDD=VDD VSS=VSS
Xpsum_out_reg_2_ decrq1 $PINS D=N_uc_42 ENN=HFSNET_3 CP=ZCTSNET_0 CDN=rst_n
+ Q=psum_out[2] VDD=VDD VSS=VSS
Xpsum_out_reg_1_ decrq1 $PINS D=N_uc_41 ENN=array_en CP=ZCTSNET_12 CDN=rst_n
+ Q=psum_out[1] VDD=VDD VSS=VSS
Xpsum_out_reg_0_ decrq1 $PINS D=N_uc_40 ENN=HFSNET_7 CP=ZCTSNET_2 CDN=rst_n
+ Q=psum_out[0] VDD=VDD VSS=VSS
Xpsum_out_reg_8_ decrq1 $PINS D=N_uc_48 ENN=HFSNET_7 CP=ZCTSNET_2 CDN=HFSNET_9
+ Q=psum_out[8] VDD=VDD VSS=VSS
Xpsum_out_reg_9_ decrq1 $PINS D=N_uc_49 ENN=HFSNET_7 CP=ZCTSNET_2 CDN=HFSNET_9
+ Q=psum_out[9] VDD=VDD VSS=VSS
Xpsum_out_reg_10_ decrq1 $PINS D=N_uc_50 ENN=HFSNET_7 CP=ZCTSNET_2 CDN=HFSNET_9
+ Q=psum_out[10] VDD=VDD VSS=VSS
Xweight_reg_reg_7_ decrq1 $PINS D=weight_in[7] ENN=n15 CP=ZCTSNET_0
+ CDN=HFSNET_9 Q=weight_reg[7] VDD=VDD VSS=VSS
Xweight_reg_reg_6_ decrq1 $PINS D=weight_in[6] ENN=n15 CP=ZCTSNET_2
+ CDN=HFSNET_9 Q=weight_reg[6] VDD=VDD VSS=VSS
Xweight_reg_reg_5_ decrq1 $PINS D=weight_in[5] ENN=n15 CP=ZCTSNET_2
+ CDN=HFSNET_9 Q=weight_reg[5] VDD=VDD VSS=VSS
Xweight_reg_reg_4_ decrq1 $PINS D=weight_in[4] ENN=n15 CP=ZCTSNET_2
+ CDN=HFSNET_9 Q=weight_reg[4] VDD=VDD VSS=VSS
Xweight_reg_reg_3_ decrq1 $PINS D=weight_in[3] ENN=n15 CP=ZCTSNET_2 CDN=rst_n
+ Q=weight_reg[3] VDD=VDD VSS=VSS
Xweight_reg_reg_2_ decrq1 $PINS D=weight_in[2] ENN=n15 CP=ZCTSNET_0
+ CDN=HFSNET_9 Q=weight_reg[2] VDD=VDD VSS=VSS
Xweight_reg_reg_1_ decrq1 $PINS D=weight_in[1] ENN=n15 CP=ZCTSNET_0
+ CDN=HFSNET_10 Q=weight_reg[1] VDD=VDD VSS=VSS
Xweight_reg_reg_0_ decrq1 $PINS D=weight_in[0] ENN=n15 CP=ZCTSNET_2
+ CDN=HFSNET_9 Q=weight_reg[0] VDD=VDD VSS=VSS
Xpsum_out_reg_11_ decrq1 $PINS D=N_uc_51 ENN=HFSNET_5 CP=ZCTSNET_12
+ CDN=HFSNET_8 Q=psum_out[11] VDD=VDD VSS=VSS
Xpsum_out_reg_12_ decrq1 $PINS D=N_uc_52 ENN=HFSNET_5 CP=ZCTSNET_12
+ CDN=HFSNET_8 Q=psum_out[12] VDD=VDD VSS=VSS
Xpsum_out_reg_13_ decrq1 $PINS D=N_uc_53 ENN=HFSNET_5 CP=ZCTSNET_2 CDN=HFSNET_8
+ Q=psum_out[13] VDD=VDD VSS=VSS
Xpsum_out_reg_14_ decrq1 $PINS D=N_uc_54 ENN=HFSNET_5 CP=ZCTSNET_12
+ CDN=HFSNET_8 Q=psum_out[14] VDD=VDD VSS=VSS
Xpsum_out_reg_15_ decrq1 $PINS D=N_uc_55 ENN=HFSNET_7 CP=ZCTSNET_2 CDN=HFSNET_8
+ Q=psum_out[15] VDD=VDD VSS=VSS
Xpsum_out_reg_16_ decrq1 $PINS D=N_uc_56 ENN=HFSNET_7 CP=ZCTSNET_12
+ CDN=HFSNET_9 Q=psum_out[16] VDD=VDD VSS=VSS
Xpsum_out_reg_17_ decrq1 $PINS D=N_uc_57 ENN=HFSNET_7 CP=ZCTSNET_2 CDN=HFSNET_9
+ Q=psum_out[17] VDD=VDD VSS=VSS
Xpsum_out_reg_18_ decrq1 $PINS D=N_uc_58 ENN=HFSNET_7 CP=ZCTSNET_2 CDN=HFSNET_8
+ Q=psum_out[18] VDD=VDD VSS=VSS
Xpsum_out_reg_19_ decrq1 $PINS D=N_uc_59 ENN=HFSNET_7 CP=ZCTSNET_2 CDN=HFSNET_9
+ Q=psum_out[19] VDD=VDD VSS=VSS
Xpsum_out_reg_20_ decrq1 $PINS D=N_uc_60 ENN=HFSNET_7 CP=ZCTSNET_0 CDN=HFSNET_9
+ Q=psum_out[20] VDD=VDD VSS=VSS
Xpsum_out_reg_21_ decrq1 $PINS D=N_uc_61 ENN=HFSNET_7 CP=ZCTSNET_0 CDN=HFSNET_9
+ Q=psum_out[21] VDD=VDD VSS=VSS
Xpsum_out_reg_22_ decrq1 $PINS D=N_uc_62 ENN=HFSNET_7 CP=ZCTSNET_0 CDN=HFSNET_9
+ Q=psum_out[22] VDD=VDD VSS=VSS
Xpsum_out_reg_23_ decrq1 $PINS D=N_uc_63 ENN=HFSNET_7 CP=ZCTSNET_2 CDN=HFSNET_9
+ Q=psum_out[23] VDD=VDD VSS=VSS
Xpsum_out_reg_24_ decrq1 $PINS D=N_uc_64 ENN=HFSNET_7 CP=ZCTSNET_2 CDN=HFSNET_9
+ Q=psum_out[24] VDD=VDD VSS=VSS
Xpsum_out_reg_25_ decrq1 $PINS D=N_uc_65 ENN=HFSNET_7 CP=ZCTSNET_0 CDN=HFSNET_9
+ Q=psum_out[25] VDD=VDD VSS=VSS
Xpsum_out_reg_26_ decrq1 $PINS D=N_uc_66 ENN=HFSNET_4 CP=ZCTSNET_0 CDN=HFSNET_9
+ Q=psum_out[26] VDD=VDD VSS=VSS
Xpsum_out_reg_27_ decrq1 $PINS D=N_uc_67 ENN=HFSNET_4 CP=ZCTSNET_0
+ CDN=HFSNET_10 Q=psum_out[27] VDD=VDD VSS=VSS
Xpsum_out_reg_28_ decrq1 $PINS D=N_uc_68 ENN=HFSNET_7 CP=ZCTSNET_0 CDN=HFSNET_9
+ Q=psum_out[28] VDD=VDD VSS=VSS
Xpsum_out_reg_29_ decrq1 $PINS D=N_uc_69 ENN=HFSNET_7 CP=ZCTSNET_2 CDN=rst_n
+ Q=psum_out[29] VDD=VDD VSS=VSS
Xpsum_out_reg_30_ decrq1 $PINS D=N_uc_70 ENN=HFSNET_7 CP=ZCTSNET_2 CDN=rst_n
+ Q=psum_out[30] VDD=VDD VSS=VSS
Xpsum_out_reg_31_ decrq1 $PINS D=N_uc_71 ENN=HFSNET_7 CP=ZCTSNET_2 CDN=rst_n
+ Q=psum_out[31] VDD=VDD VSS=VSS
XU19 inv0d2 $PINS I=n16 ZN=n2 VDD=VDD VSS=VSS
Xcopt_h_inst_3089 dl02d1 $PINS I=act_in[2] Z=copt_net_259 VDD=VDD VSS=VSS
Xcopt_h_inst_3127 dl01d1 $PINS I=act_in[5] Z=copt_net_297 VDD=VDD VSS=VSS
Xcopt_h_inst_3134 dl01d1 $PINS I=act_in[0] Z=copt_net_304 VDD=VDD VSS=VSS
Xcopt_h_inst_5246 dl02d1 $PINS I=act_in[4] Z=copt_net_2413 VDD=VDD VSS=VSS
XU24 nd02d1 $PINS A1=weight_load A2=HFSNET_6 ZN=n15 VDD=VDD VSS=VSS
Xgre_a_INV_1497_inst_5799 inv0d1 $PINS I=weight_reg[0] ZN=gre_a_INV_1497_3
+ VDD=VDD VSS=VSS
Xgre_a_INV_1961_inst_5816 inv0d1 $PINS I=weight_reg[7] ZN=gre_a_INV_1961_3
+ VDD=VDD VSS=VSS
XU29 nd02d1 $PINS A1=N_uc_36 A2=mode_unsigned ZN=n16 VDD=VDD VSS=VSS
.ENDS

.SUBCKT unpu_pe_4_DW_mult_tc_0_DW_mult_tc_3 a[7] a[6] a[5] a[4] a[3] a[2] a[1]
+ a[0] b[7] b[6] b[5] b[4] b[3] b[2] b[1] b[0] product[15] product[14]
+ product[13] product[12] product[11] product[10] product[9] product[8]
+ product[7] product[6] product[5] product[4] product[3] product[2] product[1]
+ product[0] VDD VSS gre_a_INV_1872_2
XU2 ad01d0 $PINS A=n196 B=n61 CI=n2 CO=n1 S=product[14] VDD=VDD VSS=VSS
XU3 ad01d0 $PINS A=n17 B=n16 CI=n3 CO=n2 S=product[13] VDD=VDD VSS=VSS
XU4 ad01d0 $PINS A=n18 B=n19 CI=n4 CO=n3 S=product[12] VDD=VDD VSS=VSS
XU5 ad01d0 $PINS A=n20 B=n23 CI=n5 CO=n4 S=product[11] VDD=VDD VSS=VSS
XU6 ad01d0 $PINS A=n27 B=n24 CI=n6 CO=n5 S=product[10] VDD=VDD VSS=VSS
XU7 ad01d0 $PINS A=n33 B=n28 CI=n7 CO=n6 S=product[9] VDD=VDD VSS=VSS
XU8 ad01d0 $PINS A=n39 B=n34 CI=n8 CO=n7 S=product[8] VDD=VDD VSS=VSS
XU9 ad01d0 $PINS A=n45 B=n40 CI=n9 CO=n8 S=product[7] VDD=VDD VSS=VSS
XU10 ad01d0 $PINS A=n49 B=n46 CI=n10 CO=n9 S=product[6] VDD=VDD VSS=VSS
XU11 ad01d0 $PINS A=n53 B=n50 CI=n11 CO=n10 S=product[5] VDD=VDD VSS=VSS
XU12 ad01d0 $PINS A=n55 B=n54 CI=n12 CO=n11 S=product[4] VDD=VDD VSS=VSS
XU13 ad01d0 $PINS A=n59 B=n56 CI=n13 CO=n12 S=product[3] VDD=VDD VSS=VSS
XU14 ad01d0 $PINS A=n84 B=n91 CI=n14 CO=n13 S=product[2] VDD=VDD VSS=VSS
XctmTdsLR_1_3002 an02d1 $PINS A1=n58 A2=n75 Z=n51 VDD=VDD VSS=VSS
XU17 ad01d0 $PINS A=n195 B=n62 CI=n69 CO=n17 S=n18 VDD=VDD VSS=VSS
XU18 ad01d0 $PINS A=n63 B=n25 CI=n22 CO=n19 S=n20 VDD=VDD VSS=VSS
XU20 ad01d0 $PINS A=n64 B=n26 CI=n29 CO=n23 S=n24 VDD=VDD VSS=VSS
XU21 ad01d0 $PINS A=n194 B=n70 CI=n77 CO=n25 S=n26 VDD=VDD VSS=VSS
XU22 ad01d0 $PINS A=n32 B=n35 CI=n30 CO=n27 S=n28 VDD=VDD VSS=VSS
XU23 ad01d0 $PINS A=n71 B=n65 CI=n37 CO=n29 S=n30 VDD=VDD VSS=VSS
XU25 ad01d0 $PINS A=n38 B=n41 CI=n36 CO=n33 S=n34 VDD=VDD VSS=VSS
XU26 ad01d0 $PINS A=n72 B=n85 CI=n43 CO=n35 S=n36 VDD=VDD VSS=VSS
XU29 ad01d0 $PINS A=n44 B=n47 CI=n42 CO=n39 S=n40 VDD=VDD VSS=VSS
XU30 ad01d0 $PINS A=n86 B=n73 CI=n79 CO=n41 S=n42 VDD=VDD VSS=VSS
XU32 ad01d0 $PINS A=n74 B=n51 CI=n48 CO=n45 S=n46 VDD=VDD VSS=VSS
XU33 ad01d0 $PINS A=n68 B=n87 CI=n80 CO=n47 S=n48 VDD=VDD VSS=VSS
XU34 ad01d0 $PINS A=n88 B=n81 CI=n52 CO=n49 S=n50 VDD=VDD VSS=VSS
XU36 ad01d0 $PINS A=n76 B=n89 CI=n82 CO=n53 S=n54 VDD=VDD VSS=VSS
XU37 ah01d1 $PINS A=n83 B=n90 CO=n55 S=n56 VDD=VDD VSS=VSS
XU145 oai21d1 $PINS B1=n203 B2=n249 A=n222 ZN=n77 VDD=VDD VSS=VSS
XU146 oai21d1 $PINS B1=n201 B2=n250 A=n232 ZN=n69 VDD=VDD VSS=VSS
XU147 oai21d1 $PINS B1=n199 B2=n251 A=n242 ZN=n61 VDD=VDD VSS=VSS
XU148 inv0d0 $PINS I=n16 ZN=n196 VDD=VDD VSS=VSS
XU149 inv0d0 $PINS I=n223 ZN=n201 VDD=VDD VSS=VSS
XU150 inv0d0 $PINS I=n214 ZN=n203 VDD=VDD VSS=VSS
XU151 inv0d0 $PINS I=n233 ZN=n199 VDD=VDD VSS=VSS
XU152 inv0d0 $PINS I=n32 ZN=n194 VDD=VDD VSS=VSS
XU153 inv0d0 $PINS I=n22 ZN=n195 VDD=VDD VSS=VSS
XU154 nd02d1 $PINS A1=n214 A2=n249 ZN=n216 VDD=VDD VSS=VSS
XU155 xr02d1 $PINS A1=a[2] A2=gre_a_INV_1872_2 Z=n214 VDD=VDD VSS=VSS
XU157 nd02d1 $PINS A1=n223 A2=n250 ZN=n225 VDD=VDD VSS=VSS
XU158 xr02d1 $PINS A1=a[4] A2=n202 Z=n223 VDD=VDD VSS=VSS
XU159 inv0d1 $PINS I=a[3] ZN=n202 VDD=VDD VSS=VSS
XU160 nd02d1 $PINS A1=a[1] A2=a[0] ZN=n206 VDD=VDD VSS=VSS
XU162 inv0d0 $PINS I=b[0] ZN=n197 VDD=VDD VSS=VSS
XU163 xr02d1 $PINS A1=a[6] A2=n200 Z=n233 VDD=VDD VSS=VSS
XU164 inv0d1 $PINS I=a[5] ZN=n200 VDD=VDD VSS=VSS
XU165 nd02d1 $PINS A1=n233 A2=n251 ZN=n235 VDD=VDD VSS=VSS
XU166 inv0d0 $PINS I=a[7] ZN=n198 VDD=VDD VSS=VSS
XU167 inv0d0 $PINS I=n1 ZN=product[15] VDD=VDD VSS=VSS
XU168 nr02d0 $PINS A1=a[0] A2=n197 ZN=product[0] VDD=VDD VSS=VSS
XU169 oai22d1 $PINS A1=b[0] A2=n206 B1=n207 B2=a[0] ZN=n92 VDD=VDD VSS=VSS
XU170 oai22d1 $PINS A1=n207 A2=n206 B1=n208 B2=a[0] ZN=n91 VDD=VDD VSS=VSS
XU171 xr02d1 $PINS A1=b[1] A2=gre_a_INV_1872_2 Z=n207 VDD=VDD VSS=VSS
XU172 oai22d1 $PINS A1=n208 A2=n206 B1=n209 B2=a[0] ZN=n90 VDD=VDD VSS=VSS
XU173 xr02d1 $PINS A1=b[2] A2=gre_a_INV_1872_2 Z=n208 VDD=VDD VSS=VSS
XU174 oai22d1 $PINS A1=n209 A2=n206 B1=n210 B2=a[0] ZN=n89 VDD=VDD VSS=VSS
XU175 xr02d1 $PINS A1=b[3] A2=gre_a_INV_1872_2 Z=n209 VDD=VDD VSS=VSS
XU176 oai22d1 $PINS A1=n210 A2=n206 B1=n211 B2=a[0] ZN=n88 VDD=VDD VSS=VSS
XU177 xr02d1 $PINS A1=b[4] A2=gre_a_INV_1872_2 Z=n210 VDD=VDD VSS=VSS
XU178 oai22d1 $PINS A1=n211 A2=n206 B1=n212 B2=a[0] ZN=n87 VDD=VDD VSS=VSS
XU179 xr02d1 $PINS A1=b[5] A2=gre_a_INV_1872_2 Z=n211 VDD=VDD VSS=VSS
XU180 oai22d1 $PINS A1=n212 A2=n206 B1=n213 B2=a[0] ZN=n86 VDD=VDD VSS=VSS
XU181 xr02d1 $PINS A1=b[6] A2=gre_a_INV_1872_2 Z=n212 VDD=VDD VSS=VSS
XU182 aor21d1 $PINS B1=a[0] B2=n206 A=n213 Z=n85 VDD=VDD VSS=VSS
XU183 xr02d1 $PINS A1=b[7] A2=gre_a_INV_1872_2 Z=n213 VDD=VDD VSS=VSS
XU184 nr02d0 $PINS A1=n214 A2=n197 ZN=n84 VDD=VDD VSS=VSS
XU185 oai22d1 $PINS A1=n216 A2=n215 B1=n214 B2=n217 ZN=n83 VDD=VDD VSS=VSS
XctmTdsLR_1_2989 an02d1 $PINS A1=n60 A2=n92 Z=n14 VDD=VDD VSS=VSS
XU187 oai22d1 $PINS A1=n217 A2=n216 B1=n214 B2=n218 ZN=n82 VDD=VDD VSS=VSS
XU188 xr02d1 $PINS A1=b[1] A2=n202 Z=n217 VDD=VDD VSS=VSS
XU189 oai22d1 $PINS A1=n218 A2=n216 B1=n214 B2=n219 ZN=n81 VDD=VDD VSS=VSS
XU190 xr02d1 $PINS A1=b[2] A2=n202 Z=n218 VDD=VDD VSS=VSS
XU191 oai22d1 $PINS A1=n219 A2=n216 B1=n214 B2=n220 ZN=n80 VDD=VDD VSS=VSS
XU192 xr02d1 $PINS A1=b[3] A2=n202 Z=n219 VDD=VDD VSS=VSS
XU193 oai22d1 $PINS A1=n220 A2=n216 B1=n214 B2=n221 ZN=n79 VDD=VDD VSS=VSS
XU194 xr02d1 $PINS A1=b[4] A2=n202 Z=n220 VDD=VDD VSS=VSS
XU195 nr02d0 $PINS A1=n223 A2=n197 ZN=n76 VDD=VDD VSS=VSS
XU196 oai22d1 $PINS A1=n225 A2=n224 B1=n223 B2=n226 ZN=n75 VDD=VDD VSS=VSS
XctmTdsLR_2_2990 aoim21d1 $PINS B1=n92 B2=n60 A=n14 ZN=product[1] VDD=VDD
+ VSS=VSS
XU198 oai22d1 $PINS A1=n226 A2=n225 B1=n223 B2=n227 ZN=n74 VDD=VDD VSS=VSS
XU199 xr02d1 $PINS A1=b[1] A2=n200 Z=n226 VDD=VDD VSS=VSS
XU200 oai22d1 $PINS A1=n227 A2=n225 B1=n223 B2=n228 ZN=n73 VDD=VDD VSS=VSS
XU201 xr02d1 $PINS A1=b[2] A2=n200 Z=n227 VDD=VDD VSS=VSS
XU202 oai22d1 $PINS A1=n228 A2=n225 B1=n223 B2=n229 ZN=n72 VDD=VDD VSS=VSS
XU203 xr02d1 $PINS A1=b[3] A2=n200 Z=n228 VDD=VDD VSS=VSS
XU204 oai22d1 $PINS A1=n229 A2=n225 B1=n223 B2=n230 ZN=n71 VDD=VDD VSS=VSS
XU205 xr02d1 $PINS A1=b[4] A2=n200 Z=n229 VDD=VDD VSS=VSS
XU206 oai22d1 $PINS A1=n230 A2=n225 B1=n223 B2=n231 ZN=n70 VDD=VDD VSS=VSS
XU207 xr02d1 $PINS A1=b[5] A2=n200 Z=n230 VDD=VDD VSS=VSS
XU208 nr02d0 $PINS A1=n233 A2=n197 ZN=n68 VDD=VDD VSS=VSS
XU209 oai22d1 $PINS A1=n234 A2=n235 B1=n236 B2=n233 ZN=n67 VDD=VDD VSS=VSS
XctmTdsLR_2_3003 aoim21d1 $PINS B1=n58 B2=n75 A=n51 ZN=n52 VDD=VDD VSS=VSS
XU211 oai22d1 $PINS A1=n237 A2=n235 B1=n233 B2=n238 ZN=n65 VDD=VDD VSS=VSS
XU212 oai22d1 $PINS A1=n238 A2=n235 B1=n233 B2=n239 ZN=n64 VDD=VDD VSS=VSS
XU213 xr02d1 $PINS A1=b[3] A2=n198 Z=n238 VDD=VDD VSS=VSS
XU214 oai22d1 $PINS A1=n239 A2=n235 B1=n233 B2=n240 ZN=n63 VDD=VDD VSS=VSS
XU215 xr02d1 $PINS A1=b[4] A2=n198 Z=n239 VDD=VDD VSS=VSS
XU216 oai22d1 $PINS A1=n240 A2=n235 B1=n233 B2=n241 ZN=n62 VDD=VDD VSS=VSS
XU217 xr02d1 $PINS A1=b[5] A2=n198 Z=n240 VDD=VDD VSS=VSS
XU218 oai21d1 $PINS B1=b[0] B2=gre_a_INV_1872_2 A=n206 ZN=n60 VDD=VDD VSS=VSS
XU219 oai21d1 $PINS B1=n202 B2=n216 A=n243 ZN=n59 VDD=VDD VSS=VSS
XU220 nd03d0 $PINS A1=n203 A2=n197 A3=a[3] ZN=n243 VDD=VDD VSS=VSS
XU221 oai21d1 $PINS B1=n200 B2=n225 A=n244 ZN=n58 VDD=VDD VSS=VSS
XU222 nd03d0 $PINS A1=n201 A2=n197 A3=a[5] ZN=n244 VDD=VDD VSS=VSS
XU223 oai21d1 $PINS B1=n198 B2=n235 A=n245 ZN=n57 VDD=VDD VSS=VSS
XU224 nd03d0 $PINS A1=n199 A2=n197 A3=a[7] ZN=n245 VDD=VDD VSS=VSS
XU225 xn02d1 $PINS A1=n246 A2=n247 ZN=n38 VDD=VDD VSS=VSS
XU226 or02d0 $PINS A1=n247 A2=n246 Z=n37 VDD=VDD VSS=VSS
XU227 oai22d1 $PINS A1=n236 A2=n235 B1=n233 B2=n237 ZN=n246 VDD=VDD VSS=VSS
XU228 xr02d1 $PINS A1=b[2] A2=n198 Z=n237 VDD=VDD VSS=VSS
XU229 xr02d1 $PINS A1=b[1] A2=n198 Z=n236 VDD=VDD VSS=VSS
XU230 oai22d1 $PINS A1=n221 A2=n216 B1=n214 B2=n248 ZN=n247 VDD=VDD VSS=VSS
XU231 xr02d1 $PINS A1=b[5] A2=n202 Z=n221 VDD=VDD VSS=VSS
XU232 aoim22d1 $PINS A1=n203 A2=n222 B1=n248 B2=n216 Z=n32 VDD=VDD VSS=VSS
XU233 xr02d1 $PINS A1=a[3] A2=a[2] Z=n249 VDD=VDD VSS=VSS
XU234 xr02d1 $PINS A1=b[6] A2=n202 Z=n248 VDD=VDD VSS=VSS
XU235 xr02d1 $PINS A1=b[7] A2=a[3] Z=n222 VDD=VDD VSS=VSS
XU236 aoim22d1 $PINS A1=n201 A2=n232 B1=n231 B2=n225 Z=n22 VDD=VDD VSS=VSS
XU237 xr02d1 $PINS A1=a[5] A2=a[4] Z=n250 VDD=VDD VSS=VSS
XU238 xr02d1 $PINS A1=b[6] A2=n200 Z=n231 VDD=VDD VSS=VSS
XU239 xr02d1 $PINS A1=b[7] A2=a[5] Z=n232 VDD=VDD VSS=VSS
XU240 aoim22d1 $PINS A1=n199 A2=n242 B1=n241 B2=n235 Z=n16 VDD=VDD VSS=VSS
XU241 xr02d1 $PINS A1=a[7] A2=a[6] Z=n251 VDD=VDD VSS=VSS
XU242 xr02d1 $PINS A1=b[6] A2=n198 Z=n241 VDD=VDD VSS=VSS
XU243 xr02d1 $PINS A1=b[7] A2=a[7] Z=n242 VDD=VDD VSS=VSS
XctmTdsLR_1_1364 aoim22d1 $PINS A1=n202 A2=b[0] B1=n202 B2=b[0] Z=n215 VDD=VDD
+ VSS=VSS
XctmTdsLR_1_1365 aoim22d1 $PINS A1=n200 A2=b[0] B1=n200 B2=b[0] Z=n224 VDD=VDD
+ VSS=VSS
XctmTdsLR_1_1366 aoim22d1 $PINS A1=n198 A2=b[0] B1=n198 B2=b[0] Z=n234 VDD=VDD
+ VSS=VSS
XctmTdsLR_1_3004 an02d1 $PINS A1=n67 A2=n57 Z=n43 VDD=VDD VSS=VSS
XctmTdsLR_2_3005 aoim21d1 $PINS B1=n67 B2=n57 A=n43 ZN=n44 VDD=VDD VSS=VSS
.ENDS

.SUBCKT unpu_pe_4_DW_mult_uns_0_DW_mult_uns_4 a[7] a[6] a[5] a[4] a[3] a[2]
+ a[1] a[0] b[7] b[6] b[5] b[4] b[3] b[2] b[1] b[0] product[15] product[14]
+ product[13] product[12] product[11] product[10] product[9] product[8]
+ product[7] product[6] product[5] product[4] product[3] product[2] product[1]
+ product[0] VDD VSS
XU2 ad01d0 $PINS A=n99 B=n15 CI=n2 CO=product[15] S=product[14] VDD=VDD VSS=VSS
XU3 ad01d0 $PINS A=n16 B=n17 CI=n3 CO=n2 S=product[13] VDD=VDD VSS=VSS
XU4 ad01d0 $PINS A=n18 B=n21 CI=n4 CO=n3 S=product[12] VDD=VDD VSS=VSS
XU5 ad01d0 $PINS A=n27 B=n22 CI=n5 CO=n4 S=product[11] VDD=VDD VSS=VSS
XU6 ad01d0 $PINS A=n35 B=n28 CI=n6 CO=n5 S=product[10] VDD=VDD VSS=VSS
XU7 ad01d0 $PINS A=n45 B=n36 CI=n7 CO=n6 S=product[9] VDD=VDD VSS=VSS
XU8 ad01d0 $PINS A=n57 B=n46 CI=n8 CO=n7 S=product[8] VDD=VDD VSS=VSS
XU9 ad01d0 $PINS A=n69 B=n58 CI=n9 CO=n8 S=product[7] VDD=VDD VSS=VSS
XU10 ad01d0 $PINS A=n79 B=n70 CI=n10 CO=n9 S=product[6] VDD=VDD VSS=VSS
XU11 ad01d0 $PINS A=n87 B=n80 CI=n11 CO=n10 S=product[5] VDD=VDD VSS=VSS
XU12 ad01d1 $PINS A=n93 B=n88 CI=n12 CO=n11 S=product[4] VDD=VDD VSS=VSS
XU13 ad01d0 $PINS A=n96 B=n13 CI=n94 CO=n12 S=product[3] VDD=VDD VSS=VSS
XU14 ad01d0 $PINS A=n146 B=n14 CI=n98 CO=n13 S=product[2] VDD=VDD VSS=VSS
XU15 ah01d1 $PINS A=n161 B=n154 CO=n14 S=product[1] VDD=VDD VSS=VSS
XU16 ad01d0 $PINS A=n107 B=n100 CI=n19 CO=n15 S=n16 VDD=VDD VSS=VSS
XU17 ad01d0 $PINS A=n25 B=n20 CI=n23 CO=n17 S=n18 VDD=VDD VSS=VSS
XU18 ad01d0 $PINS A=n115 B=n101 CI=n108 CO=n19 S=n20 VDD=VDD VSS=VSS
XU19 ad01d0 $PINS A=n31 B=n24 CI=n29 CO=n21 S=n22 VDD=VDD VSS=VSS
XU20 ad01d0 $PINS A=n116 B=n33 CI=n26 CO=n23 S=n24 VDD=VDD VSS=VSS
XU21 ad01d0 $PINS A=n123 B=n102 CI=n109 CO=n25 S=n26 VDD=VDD VSS=VSS
XU22 ad01d0 $PINS A=n32 B=n37 CI=n30 CO=n27 S=n28 VDD=VDD VSS=VSS
XU23 ad01d0 $PINS A=n41 B=n34 CI=n39 CO=n29 S=n30 VDD=VDD VSS=VSS
XU24 ad01d0 $PINS A=n124 B=n117 CI=n43 CO=n31 S=n32 VDD=VDD VSS=VSS
XU25 ad01d0 $PINS A=n131 B=n103 CI=n110 CO=n33 S=n34 VDD=VDD VSS=VSS
XU26 ad01d0 $PINS A=n40 B=n47 CI=n38 CO=n35 S=n36 VDD=VDD VSS=VSS
XU27 ad01d0 $PINS A=n44 B=n51 CI=n49 CO=n37 S=n38 VDD=VDD VSS=VSS
XU28 ad01d0 $PINS A=n55 B=n53 CI=n42 CO=n39 S=n40 VDD=VDD VSS=VSS
XU29 ad01d0 $PINS A=n118 B=n125 CI=n132 CO=n41 S=n42 VDD=VDD VSS=VSS
XU30 ad01d0 $PINS A=n139 B=n104 CI=n111 CO=n43 S=n44 VDD=VDD VSS=VSS
XU31 ad01d0 $PINS A=n50 B=n59 CI=n48 CO=n45 S=n46 VDD=VDD VSS=VSS
XU32 ad01d0 $PINS A=n54 B=n52 CI=n61 CO=n47 S=n48 VDD=VDD VSS=VSS
XU33 ad01d0 $PINS A=n56 B=n65 CI=n63 CO=n49 S=n50 VDD=VDD VSS=VSS
XU34 ad01d0 $PINS A=n140 B=n133 CI=n67 CO=n51 S=n52 VDD=VDD VSS=VSS
XU35 ad01d0 $PINS A=n126 B=n119 CI=n147 CO=n53 S=n54 VDD=VDD VSS=VSS
XU36 ah01d1 $PINS A=n105 B=n112 CO=n55 S=n56 VDD=VDD VSS=VSS
XU37 ad01d0 $PINS A=n71 B=n62 CI=n60 CO=n57 S=n58 VDD=VDD VSS=VSS
XU38 ad01d0 $PINS A=n64 B=n66 CI=n73 CO=n59 S=n60 VDD=VDD VSS=VSS
XU39 ad01d0 $PINS A=n77 B=n68 CI=n75 CO=n61 S=n62 VDD=VDD VSS=VSS
XU40 ad01d0 $PINS A=n141 B=n127 CI=n134 CO=n63 S=n64 VDD=VDD VSS=VSS
XU41 ad01d0 $PINS A=n155 B=n120 CI=n148 CO=n65 S=n66 VDD=VDD VSS=VSS
XU42 ah01d1 $PINS A=n106 B=n113 CO=n67 S=n68 VDD=VDD VSS=VSS
XU43 ad01d0 $PINS A=n81 B=n74 CI=n72 CO=n69 S=n70 VDD=VDD VSS=VSS
XU44 ad01d0 $PINS A=n78 B=n83 CI=n76 CO=n71 S=n72 VDD=VDD VSS=VSS
XU45 ad01d0 $PINS A=n142 B=n135 CI=n85 CO=n73 S=n74 VDD=VDD VSS=VSS
XU46 ad01d0 $PINS A=n156 B=n128 CI=n149 CO=n75 S=n76 VDD=VDD VSS=VSS
XU47 ah01d1 $PINS A=n114 B=n121 CO=n77 S=n78 VDD=VDD VSS=VSS
XU48 ad01d0 $PINS A=n89 B=n84 CI=n82 CO=n79 S=n80 VDD=VDD VSS=VSS
XU49 ad01d0 $PINS A=n150 B=n91 CI=n86 CO=n81 S=n82 VDD=VDD VSS=VSS
XU50 ad01d0 $PINS A=n157 B=n136 CI=n143 CO=n83 S=n84 VDD=VDD VSS=VSS
XU51 ah01d1 $PINS A=n122 B=n129 CO=n85 S=n86 VDD=VDD VSS=VSS
XU52 ad01d0 $PINS A=n95 B=n92 CI=n90 CO=n87 S=n88 VDD=VDD VSS=VSS
XU53 ad01d0 $PINS A=n158 B=n144 CI=n151 CO=n89 S=n90 VDD=VDD VSS=VSS
XU54 ah01d1 $PINS A=n130 B=n137 CO=n91 S=n92 VDD=VDD VSS=VSS
XU55 ad01d0 $PINS A=n159 B=n152 CI=n97 CO=n93 S=n94 VDD=VDD VSS=VSS
XU56 ah01d1 $PINS A=n138 B=n145 CO=n95 S=n96 VDD=VDD VSS=VSS
XU57 ah01d1 $PINS A=n153 B=n160 CO=n97 S=n98 VDD=VDD VSS=VSS
XU140 inv0d0 $PINS I=b[4] ZN=n217 VDD=VDD VSS=VSS
XU142 inv0d0 $PINS I=b[2] ZN=n219 VDD=VDD VSS=VSS
XU144 inv0d0 $PINS I=a[2] ZN=n227 VDD=VDD VSS=VSS
XU145 inv0d0 $PINS I=b[3] ZN=n218 VDD=VDD VSS=VSS
XU146 inv0d0 $PINS I=a[5] ZN=n224 VDD=VDD VSS=VSS
XU147 inv0d0 $PINS I=b[1] ZN=n220 VDD=VDD VSS=VSS
XU148 inv0d0 $PINS I=b[0] ZN=n221 VDD=VDD VSS=VSS
XU149 inv0d0 $PINS I=a[4] ZN=n225 VDD=VDD VSS=VSS
XU150 inv0d0 $PINS I=b[6] ZN=n215 VDD=VDD VSS=VSS
XU151 inv0d0 $PINS I=a[3] ZN=n226 VDD=VDD VSS=VSS
XU152 inv0d0 $PINS I=b[5] ZN=n216 VDD=VDD VSS=VSS
XU153 inv0d0 $PINS I=b[7] ZN=n214 VDD=VDD VSS=VSS
XU154 inv0d0 $PINS I=a[6] ZN=n223 VDD=VDD VSS=VSS
XU155 inv0d0 $PINS I=a[7] ZN=n222 VDD=VDD VSS=VSS
XU156 nr02d0 $PINS A1=a[0] A2=n221 ZN=product[0] VDD=VDD VSS=VSS
XU157 nr02d0 $PINS A1=n222 A2=n214 ZN=n99 VDD=VDD VSS=VSS
XU158 nr02d0 $PINS A1=a[0] A2=n220 ZN=n161 VDD=VDD VSS=VSS
XU159 nr02d0 $PINS A1=a[0] A2=n219 ZN=n160 VDD=VDD VSS=VSS
XU160 nr02d0 $PINS A1=a[0] A2=n218 ZN=n159 VDD=VDD VSS=VSS
XU161 nr02d1 $PINS A1=a[0] A2=n217 ZN=n158 VDD=VDD VSS=VSS
XU162 nr02d0 $PINS A1=a[0] A2=n216 ZN=n157 VDD=VDD VSS=VSS
XU163 nr02d0 $PINS A1=a[0] A2=n215 ZN=n156 VDD=VDD VSS=VSS
XU164 nr02d0 $PINS A1=a[0] A2=n214 ZN=n155 VDD=VDD VSS=VSS
XU165 nr02d0 $PINS A1=n221 A2=a[1] ZN=n154 VDD=VDD VSS=VSS
XU166 nr02d0 $PINS A1=n220 A2=a[1] ZN=n153 VDD=VDD VSS=VSS
XU167 nr02d0 $PINS A1=n219 A2=a[1] ZN=n152 VDD=VDD VSS=VSS
XU168 nr02d0 $PINS A1=n218 A2=a[1] ZN=n151 VDD=VDD VSS=VSS
XU169 nr02d0 $PINS A1=n217 A2=a[1] ZN=n150 VDD=VDD VSS=VSS
XU170 nr02d0 $PINS A1=n216 A2=a[1] ZN=n149 VDD=VDD VSS=VSS
XU171 nr02d0 $PINS A1=n215 A2=a[1] ZN=n148 VDD=VDD VSS=VSS
XU172 nr02d0 $PINS A1=n214 A2=a[1] ZN=n147 VDD=VDD VSS=VSS
XU173 nr02d0 $PINS A1=n221 A2=n227 ZN=n146 VDD=VDD VSS=VSS
XU174 nr02d0 $PINS A1=n220 A2=n227 ZN=n145 VDD=VDD VSS=VSS
XU175 nr02d0 $PINS A1=n219 A2=n227 ZN=n144 VDD=VDD VSS=VSS
XU176 nr02d0 $PINS A1=n218 A2=n227 ZN=n143 VDD=VDD VSS=VSS
XU177 nr02d0 $PINS A1=n217 A2=n227 ZN=n142 VDD=VDD VSS=VSS
XU178 nr02d0 $PINS A1=n216 A2=n227 ZN=n141 VDD=VDD VSS=VSS
XU179 nr02d0 $PINS A1=n215 A2=n227 ZN=n140 VDD=VDD VSS=VSS
XU180 nr02d0 $PINS A1=n214 A2=n227 ZN=n139 VDD=VDD VSS=VSS
XU181 nr02d0 $PINS A1=n221 A2=n226 ZN=n138 VDD=VDD VSS=VSS
XU182 nr02d0 $PINS A1=n220 A2=n226 ZN=n137 VDD=VDD VSS=VSS
XU183 nr02d0 $PINS A1=n219 A2=n226 ZN=n136 VDD=VDD VSS=VSS
XU184 nr02d0 $PINS A1=n218 A2=n226 ZN=n135 VDD=VDD VSS=VSS
XU185 nr02d0 $PINS A1=n217 A2=n226 ZN=n134 VDD=VDD VSS=VSS
XU186 nr02d0 $PINS A1=n216 A2=n226 ZN=n133 VDD=VDD VSS=VSS
XU187 nr02d0 $PINS A1=n215 A2=n226 ZN=n132 VDD=VDD VSS=VSS
XU188 nr02d0 $PINS A1=n214 A2=n226 ZN=n131 VDD=VDD VSS=VSS
XU189 nr02d0 $PINS A1=n221 A2=n225 ZN=n130 VDD=VDD VSS=VSS
XU190 nr02d0 $PINS A1=n220 A2=n225 ZN=n129 VDD=VDD VSS=VSS
XU191 nr02d0 $PINS A1=n219 A2=n225 ZN=n128 VDD=VDD VSS=VSS
XU192 nr02d0 $PINS A1=n218 A2=n225 ZN=n127 VDD=VDD VSS=VSS
XU193 nr02d0 $PINS A1=n217 A2=n225 ZN=n126 VDD=VDD VSS=VSS
XU194 nr02d0 $PINS A1=n216 A2=n225 ZN=n125 VDD=VDD VSS=VSS
XU195 nr02d0 $PINS A1=n215 A2=n225 ZN=n124 VDD=VDD VSS=VSS
XU196 nr02d0 $PINS A1=n214 A2=n225 ZN=n123 VDD=VDD VSS=VSS
XU197 nr02d0 $PINS A1=n221 A2=n224 ZN=n122 VDD=VDD VSS=VSS
XU198 nr02d0 $PINS A1=n220 A2=n224 ZN=n121 VDD=VDD VSS=VSS
XU199 nr02d0 $PINS A1=n219 A2=n224 ZN=n120 VDD=VDD VSS=VSS
XU200 nr02d0 $PINS A1=n218 A2=n224 ZN=n119 VDD=VDD VSS=VSS
XU201 nr02d0 $PINS A1=n217 A2=n224 ZN=n118 VDD=VDD VSS=VSS
XU202 nr02d0 $PINS A1=n216 A2=n224 ZN=n117 VDD=VDD VSS=VSS
XU203 nr02d0 $PINS A1=n215 A2=n224 ZN=n116 VDD=VDD VSS=VSS
XU204 nr02d0 $PINS A1=n214 A2=n224 ZN=n115 VDD=VDD VSS=VSS
XU205 nr02d0 $PINS A1=n221 A2=n223 ZN=n114 VDD=VDD VSS=VSS
XU206 nr02d0 $PINS A1=n220 A2=n223 ZN=n113 VDD=VDD VSS=VSS
XU207 nr02d0 $PINS A1=n219 A2=n223 ZN=n112 VDD=VDD VSS=VSS
XU208 nr02d0 $PINS A1=n218 A2=n223 ZN=n111 VDD=VDD VSS=VSS
XU209 nr02d0 $PINS A1=n217 A2=n223 ZN=n110 VDD=VDD VSS=VSS
XU210 nr02d0 $PINS A1=n216 A2=n223 ZN=n109 VDD=VDD VSS=VSS
XU211 nr02d0 $PINS A1=n215 A2=n223 ZN=n108 VDD=VDD VSS=VSS
XU212 nr02d0 $PINS A1=n214 A2=n223 ZN=n107 VDD=VDD VSS=VSS
XU213 nr02d0 $PINS A1=n221 A2=n222 ZN=n106 VDD=VDD VSS=VSS
XU214 nr02d0 $PINS A1=n222 A2=n220 ZN=n105 VDD=VDD VSS=VSS
XU215 nr02d0 $PINS A1=n222 A2=n219 ZN=n104 VDD=VDD VSS=VSS
XU216 nr02d0 $PINS A1=n222 A2=n218 ZN=n103 VDD=VDD VSS=VSS
XU217 nr02d0 $PINS A1=n222 A2=n217 ZN=n102 VDD=VDD VSS=VSS
XU218 nr02d0 $PINS A1=n222 A2=n216 ZN=n101 VDD=VDD VSS=VSS
XU219 nr02d0 $PINS A1=n222 A2=n215 ZN=n100 VDD=VDD VSS=VSS
.ENDS

.SUBCKT unpu_pe_4_DW01_add_0_DW01_add_5 A[31] A[30] A[29] A[28] A[27] A[26]
+ A[25] A[24] A[23] A[22] A[21] A[20] A[19] A[18] A[17] A[16] A[15] A[14] A[13]
+ A[12] A[11] A[10] A[9] A[8] A[7] A[6] A[5] A[4] A[3] A[2] A[1] A[0] B[31]
+ B[30] B[29] B[28] B[27] B[26] B[25] B[24] B[23] B[22] B[21] B[20] B[19] B[18]
+ B[17] B[16] B[15] B[14] B[13] B[12] B[11] B[10] B[9] B[8] B[7] B[6] B[5] B[4]
+ B[3] B[2] B[1] B[0] CI SUM[31] SUM[30] SUM[29] SUM[28] SUM[27] SUM[26]
+ SUM[25] SUM[24] SUM[23] SUM[22] SUM[21] SUM[20] SUM[19] SUM[18] SUM[17]
+ SUM[16] SUM[15] SUM[14] SUM[13] SUM[12] SUM[11] SUM[10] SUM[9] SUM[8] SUM[7]
+ SUM[6] SUM[5] SUM[4] SUM[3] SUM[2] SUM[1] SUM[0] CO VDD VSS
XU1_31 ad01d0 $PINS A=copt_net_1937 B=B[31] CI=carry[31] S=SUM[31] VDD=VDD
+ VSS=VSS
XU1_30 ad01d0 $PINS A=copt_net_1792 B=B[30] CI=carry[30] CO=carry[31] S=SUM[30]
+ VDD=VDD VSS=VSS
XU1_29 ad01d0 $PINS A=copt_net_1636 B=B[29] CI=carry[29] CO=carry[30] S=SUM[29]
+ VDD=VDD VSS=VSS
XU1_28 ad01d0 $PINS A=copt_net_1645 B=B[28] CI=carry[28] CO=carry[29] S=SUM[28]
+ VDD=VDD VSS=VSS
XU1_27 ad01d0 $PINS A=copt_net_1468 B=B[27] CI=carry[27] CO=carry[28] S=SUM[27]
+ VDD=VDD VSS=VSS
XU1_26 ad01d0 $PINS A=copt_net_1802 B=B[26] CI=carry[26] CO=carry[27] S=SUM[26]
+ VDD=VDD VSS=VSS
XU1_25 ad01d0 $PINS A=copt_net_1661 B=B[25] CI=carry[25] CO=carry[26] S=SUM[25]
+ VDD=VDD VSS=VSS
XU1_24 ad01d0 $PINS A=copt_net_2153 B=B[24] CI=carry[24] CO=carry[25] S=SUM[24]
+ VDD=VDD VSS=VSS
XU1_23 ad01d0 $PINS A=copt_net_1145 B=B[23] CI=carry[23] CO=carry[24] S=SUM[23]
+ VDD=VDD VSS=VSS
XU1_22 ad01d0 $PINS A=copt_net_2159 B=B[22] CI=carry[22] CO=carry[23] S=SUM[22]
+ VDD=VDD VSS=VSS
XU1_21 ad01d0 $PINS A=copt_net_1666 B=B[21] CI=carry[21] CO=carry[22] S=SUM[21]
+ VDD=VDD VSS=VSS
XU1_20 ad01d0 $PINS A=copt_net_1185 B=B[20] CI=carry[20] CO=carry[21] S=SUM[20]
+ VDD=VDD VSS=VSS
XU1_19 ad01d0 $PINS A=copt_net_1692 B=B[19] CI=carry[19] CO=carry[20] S=SUM[19]
+ VDD=VDD VSS=VSS
XU1_18 ad01d0 $PINS A=copt_net_1738 B=B[18] CI=carry[18] CO=carry[19] S=SUM[18]
+ VDD=VDD VSS=VSS
XU1_17 ad01d0 $PINS A=copt_net_1733 B=B[17] CI=carry[17] CO=carry[18] S=SUM[17]
+ VDD=VDD VSS=VSS
XU1_16 ad01d0 $PINS A=copt_net_1843 B=B[16] CI=carry[16] CO=carry[17] S=SUM[16]
+ VDD=VDD VSS=VSS
XU1_15 ad01d0 $PINS A=copt_net_1932 B=B[15] CI=carry[15] CO=carry[16] S=SUM[15]
+ VDD=VDD VSS=VSS
XU1_14 ad01d0 $PINS A=copt_net_1922 B=B[14] CI=carry[14] CO=carry[15] S=SUM[14]
+ VDD=VDD VSS=VSS
XU1_13 ad01d0 $PINS A=copt_net_2081 B=B[13] CI=carry[13] CO=carry[14] S=SUM[13]
+ VDD=VDD VSS=VSS
XU1_12 ad01d0 $PINS A=copt_net_2056 B=B[12] CI=carry[12] CO=carry[13] S=SUM[12]
+ VDD=VDD VSS=VSS
XU1_11 ad01d0 $PINS A=copt_net_2076 B=B[11] CI=carry[11] CO=carry[12] S=SUM[11]
+ VDD=VDD VSS=VSS
XU1_10 ad01d4 $PINS A=copt_net_2110 B=B[10] CI=carry[10] CO=carry[11] S=SUM[10]
+ VDD=VDD VSS=VSS
XU1_9 ad01d0 $PINS A=copt_net_2058 B=B[9] CI=carry[9] CO=carry[10] S=SUM[9]
+ VDD=VDD VSS=VSS
XU1_8 ad01d0 $PINS A=copt_net_2001 B=B[8] CI=carry[8] CO=carry[9] S=SUM[8]
+ VDD=VDD VSS=VSS
XU1_7 ad01d0 $PINS A=copt_net_1986 B=B[7] CI=carry[7] CO=carry[8] S=SUM[7]
+ VDD=VDD VSS=VSS
XU1_6 ad01d0 $PINS A=copt_net_2016 B=B[6] CI=carry[6] CO=carry[7] S=SUM[6]
+ VDD=VDD VSS=VSS
XU1_5 ad01d0 $PINS A=copt_net_1942 B=B[5] CI=carry[5] CO=carry[6] S=SUM[5]
+ VDD=VDD VSS=VSS
XU1_4 ad01d0 $PINS A=copt_net_1676 B=B[4] CI=carry[4] CO=carry[5] S=SUM[4]
+ VDD=VDD VSS=VSS
XU1_3 ad01d0 $PINS A=copt_net_1833 B=B[3] CI=carry[3] CO=carry[4] S=SUM[3]
+ VDD=VDD VSS=VSS
XU1_2 ad01d0 $PINS A=copt_net_1479 B=B[2] CI=carry[2] CO=carry[3] S=SUM[2]
+ VDD=VDD VSS=VSS
XU1_1 ad01d0 $PINS A=copt_net_2200 B=B[1] CI=n1 CO=carry[2] S=SUM[1] VDD=VDD
+ VSS=VSS
XU1 an02d1 $PINS A1=B[0] A2=copt_net_1886 Z=n1 VDD=VDD VSS=VSS
XU2 xr02d1 $PINS A1=copt_net_1886 A2=B[0] Z=SUM[0] VDD=VDD VSS=VSS
Xcopt_h_inst_3977 dl01d1 $PINS I=A[23] Z=copt_net_1145 VDD=VDD VSS=VSS
Xcopt_h_inst_4017 dl01d1 $PINS I=A[20] Z=copt_net_1185 VDD=VDD VSS=VSS
Xcopt_h_inst_4300 dl01d1 $PINS I=A[27] Z=copt_net_1468 VDD=VDD VSS=VSS
Xcopt_h_inst_4311 dl01d1 $PINS I=A[2] Z=copt_net_1479 VDD=VDD VSS=VSS
Xcopt_h_inst_4468 dl01d1 $PINS I=A[29] Z=copt_net_1636 VDD=VDD VSS=VSS
Xcopt_h_inst_4477 dl01d1 $PINS I=A[28] Z=copt_net_1645 VDD=VDD VSS=VSS
Xcopt_h_inst_4493 dl01d1 $PINS I=A[25] Z=copt_net_1661 VDD=VDD VSS=VSS
Xcopt_h_inst_4498 dl01d1 $PINS I=A[21] Z=copt_net_1666 VDD=VDD VSS=VSS
Xcopt_h_inst_4508 dl01d1 $PINS I=A[4] Z=copt_net_1676 VDD=VDD VSS=VSS
Xcopt_h_inst_4524 dl01d1 $PINS I=A[19] Z=copt_net_1692 VDD=VDD VSS=VSS
Xcopt_h_inst_4565 dl01d1 $PINS I=A[17] Z=copt_net_1733 VDD=VDD VSS=VSS
Xcopt_h_inst_4570 dl01d1 $PINS I=A[18] Z=copt_net_1738 VDD=VDD VSS=VSS
Xcopt_h_inst_4624 dl01d1 $PINS I=A[30] Z=copt_net_1792 VDD=VDD VSS=VSS
Xcopt_h_inst_4634 dl01d1 $PINS I=A[26] Z=copt_net_1802 VDD=VDD VSS=VSS
Xcopt_h_inst_4665 dl01d1 $PINS I=A[3] Z=copt_net_1833 VDD=VDD VSS=VSS
Xcopt_h_inst_4675 dl01d1 $PINS I=A[16] Z=copt_net_1843 VDD=VDD VSS=VSS
Xcopt_h_inst_4718 dl01d1 $PINS I=A[0] Z=copt_net_1886 VDD=VDD VSS=VSS
Xcopt_h_inst_4754 dl01d1 $PINS I=A[14] Z=copt_net_1922 VDD=VDD VSS=VSS
Xcopt_h_inst_4764 dl01d1 $PINS I=A[15] Z=copt_net_1932 VDD=VDD VSS=VSS
Xcopt_h_inst_4769 dl01d1 $PINS I=A[31] Z=copt_net_1937 VDD=VDD VSS=VSS
Xcopt_h_inst_4774 dl01d1 $PINS I=A[5] Z=copt_net_1942 VDD=VDD VSS=VSS
Xcopt_h_inst_4819 dl01d1 $PINS I=A[7] Z=copt_net_1986 VDD=VDD VSS=VSS
Xcopt_h_inst_4834 dl01d1 $PINS I=A[8] Z=copt_net_2001 VDD=VDD VSS=VSS
Xcopt_h_inst_4849 dl01d1 $PINS I=A[6] Z=copt_net_2016 VDD=VDD VSS=VSS
Xcopt_h_inst_4889 dl01d1 $PINS I=A[12] Z=copt_net_2056 VDD=VDD VSS=VSS
Xcopt_h_inst_4891 dl01d1 $PINS I=A[9] Z=copt_net_2058 VDD=VDD VSS=VSS
Xcopt_h_inst_4909 dl01d1 $PINS I=A[11] Z=copt_net_2076 VDD=VDD VSS=VSS
Xcopt_h_inst_4914 dl01d1 $PINS I=A[13] Z=copt_net_2081 VDD=VDD VSS=VSS
Xcopt_h_inst_4943 buffd1 $PINS I=A[10] Z=copt_net_2110 VDD=VDD VSS=VSS
Xcopt_h_inst_4986 dl01d1 $PINS I=A[24] Z=copt_net_2153 VDD=VDD VSS=VSS
Xcopt_h_inst_4992 buffd1 $PINS I=A[22] Z=copt_net_2159 VDD=VDD VSS=VSS
Xcopt_h_inst_5033 dl01d1 $PINS I=A[1] Z=copt_net_2200 VDD=VDD VSS=VSS
.ENDS

.SUBCKT unpu_pe_4 ZCTSNET_11 rst_n array_en weight_load mode_unsigned
+ weight_in[7] weight_in[6] weight_in[5] weight_in[4] weight_in[3] weight_in[2]
+ weight_in[1] weight_in[0] act_in[7] act_in[6] act_in[5] act_in[4] act_in[3]
+ act_in[2] act_in[1] act_in[0] psum_in[31] psum_in[30] psum_in[29] psum_in[28]
+ psum_in[27] psum_in[26] psum_in[25] psum_in[24] psum_in[23] psum_in[22]
+ psum_in[21] psum_in[20] psum_in[19] psum_in[18] psum_in[17] psum_in[16]
+ psum_in[15] psum_in[14] psum_in[13] psum_in[12] psum_in[11] psum_in[10]
+ psum_in[9] psum_in[8] psum_in[7] psum_in[6] psum_in[5] psum_in[4] psum_in[3]
+ psum_in[2] psum_in[1] psum_in[0] act_out[7] act_out[6] act_out[5] act_out[4]
+ act_out[3] act_out[2] act_out[1] act_out[0] psum_out[31] psum_out[30]
+ psum_out[29] psum_out[28] psum_out[27] psum_out[26] psum_out[25] psum_out[24]
+ psum_out[23] psum_out[22] psum_out[21] psum_out[20] psum_out[19] psum_out[18]
+ psum_out[17] psum_out[16] psum_out[15] psum_out[14] psum_out[13] psum_out[12]
+ psum_out[11] psum_out[10] psum_out[9] psum_out[8] psum_out[7] psum_out[6]
+ psum_out[5] psum_out[4] psum_out[3] psum_out[2] psum_out[1] psum_out[0] VDD
+ VSS ZCTSNET_12 HFSNET_2 HFSNET_3 HFSNET_4 HFSNET_5 HFSNET_7 HFSNET_9
+ HFSNET_10 ZCTSNET_0 ZCTSNET_2
XU2 aor22d1 $PINS A1=N_uc_30 A2=HFSNET_2 B1=mode_unsigned B2=N_uc_14
+ Z=product[9] VDD=VDD VSS=VSS
XU3 aor22d1 $PINS A1=N_uc_29 A2=HFSNET_2 B1=N_uc_13 B2=mode_unsigned
+ Z=product[8] VDD=VDD VSS=VSS
XU5 aor22d1 $PINS A1=N_uc_28 A2=HFSNET_2 B1=N_uc_12 B2=mode_unsigned
+ Z=product[7] VDD=VDD VSS=VSS
XU6 aor22d1 $PINS A1=N_uc_27 A2=HFSNET_2 B1=N_uc_11 B2=mode_unsigned
+ Z=product[6] VDD=VDD VSS=VSS
XU7 aor22d1 $PINS A1=N_uc_26 A2=HFSNET_2 B1=N_uc_10 B2=mode_unsigned
+ Z=product[5] VDD=VDD VSS=VSS
XU8 aor22d1 $PINS A1=N_uc_9 A2=mode_unsigned B1=N_uc_25 B2=HFSNET_2
+ Z=product[4] VDD=VDD VSS=VSS
XU9 aor22d1 $PINS A1=N_uc_8 A2=mode_unsigned B1=N_uc_24 B2=HFSNET_2
+ Z=product[3] VDD=VDD VSS=VSS
XU10 aor22d1 $PINS A1=N_uc_7 A2=mode_unsigned B1=N_uc_23 B2=HFSNET_2
+ Z=product[2] VDD=VDD VSS=VSS
XU11 aor22d1 $PINS A1=N_uc_6 A2=mode_unsigned B1=N_uc_22 B2=HFSNET_2
+ Z=product[1] VDD=VDD VSS=VSS
XU12 oaim21d1 $PINS B1=N_uc_20 B2=mode_unsigned A=n16 ZN=product[15] VDD=VDD
+ VSS=VSS
XU13 aor22d1 $PINS A1=N_uc_35 A2=HFSNET_2 B1=N_uc_19 B2=mode_unsigned
+ Z=product[14] VDD=VDD VSS=VSS
XU14 aor22d1 $PINS A1=N_uc_34 A2=HFSNET_2 B1=N_uc_18 B2=mode_unsigned
+ Z=product[13] VDD=VDD VSS=VSS
XU15 aor22d1 $PINS A1=N_uc_33 A2=HFSNET_2 B1=N_uc_17 B2=mode_unsigned
+ Z=product[12] VDD=VDD VSS=VSS
XU16 aor22d1 $PINS A1=N_uc_32 A2=HFSNET_2 B1=N_uc_16 B2=mode_unsigned
+ Z=product[11] VDD=VDD VSS=VSS
XU17 aor22d1 $PINS A1=N_uc_31 A2=HFSNET_2 B1=N_uc_15 B2=mode_unsigned
+ Z=product[10] VDD=VDD VSS=VSS
XU18 aor22d1 $PINS A1=N_uc_5 A2=mode_unsigned B1=N_uc_21 B2=HFSNET_2
+ Z=product[0] VDD=VDD VSS=VSS
Xadd_42 unpu_pe_4_DW01_add_0_DW01_add_5 $PINS A[31]=psum_in[31]
+ A[30]=psum_in[30] A[29]=psum_in[29] A[28]=psum_in[28] A[27]=psum_in[27]
+ A[26]=psum_in[26] A[25]=psum_in[25] A[24]=psum_in[24] A[23]=psum_in[23]
+ A[22]=psum_in[22] A[21]=psum_in[21] A[20]=psum_in[20] A[19]=psum_in[19]
+ A[18]=psum_in[18] A[17]=psum_in[17] A[16]=psum_in[16] A[15]=psum_in[15]
+ A[14]=psum_in[14] A[13]=psum_in[13] A[12]=psum_in[12] A[11]=psum_in[11]
+ A[10]=psum_in[10] A[9]=psum_in[9] A[8]=psum_in[8] A[7]=psum_in[7]
+ A[6]=psum_in[6] A[5]=psum_in[5] A[4]=psum_in[4] A[3]=psum_in[3] A[2]=psum_in[2]
+ A[1]=psum_in[1] A[0]=psum_in[0] B[31]=n2 B[30]=n2 B[29]=n2 B[28]=n2 B[27]=n2
+ B[26]=n2 B[25]=n2 B[24]=n2 B[23]=n2 B[22]=n2 B[21]=n2 B[20]=n2 B[19]=n2
+ B[18]=n2 B[17]=n2 B[16]=n2 B[15]=product[15] B[14]=product[14]
+ B[13]=product[13] B[12]=product[12] B[11]=product[11] B[10]=product[10]
+ B[9]=product[9] B[8]=product[8] B[7]=product[7] B[6]=product[6] B[5]=product[5]
+ B[4]=product[4] B[3]=product[3] B[2]=product[2] B[1]=product[1] B[0]=product[0]
+ CI=VSS SUM[31]=N_uc_71 SUM[30]=N_uc_70 SUM[29]=N_uc_69 SUM[28]=N_uc_68
+ SUM[27]=N_uc_67 SUM[26]=N_uc_66 SUM[25]=N_uc_65 SUM[24]=N_uc_64 SUM[23]=N_uc_63
+ SUM[22]=N_uc_62 SUM[21]=N_uc_61 SUM[20]=N_uc_60 SUM[19]=N_uc_59 SUM[18]=N_uc_58
+ SUM[17]=N_uc_57 SUM[16]=N_uc_56 SUM[15]=N_uc_55 SUM[14]=N_uc_54 SUM[13]=N_uc_53
+ SUM[12]=N_uc_52 SUM[11]=N_uc_51 SUM[10]=N_uc_50 SUM[9]=N_uc_49 SUM[8]=N_uc_48
+ SUM[7]=N_uc_47 SUM[6]=N_uc_46 SUM[5]=N_uc_45 SUM[4]=N_uc_44 SUM[3]=N_uc_43
+ SUM[2]=N_uc_42 SUM[1]=N_uc_41 SUM[0]=N_uc_40 VDD=VDD VSS=VSS
Xmult_28 unpu_pe_4_DW_mult_uns_0_DW_mult_uns_4 $PINS a[7]=weight_reg[7]
+ a[6]=weight_reg[6] a[5]=weight_reg[5] a[4]=weight_reg[4] a[3]=weight_reg[3]
+ a[2]=weight_reg[2] a[1]=gre_a_INV_1872_3 a[0]=gre_a_INV_2782_3 b[7]=act_in[7]
+ b[6]=act_in[6] b[5]=act_in[5] b[4]=act_in[4] b[3]=act_in[3] b[2]=act_in[2]
+ b[1]=act_in[1] b[0]=act_in[0] product[15]=N_uc_20 product[14]=N_uc_19
+ product[13]=N_uc_18 product[12]=N_uc_17 product[11]=N_uc_16 product[10]=N_uc_15
+ product[9]=N_uc_14 product[8]=N_uc_13 product[7]=N_uc_12 product[6]=N_uc_11
+ product[5]=N_uc_10 product[4]=N_uc_9 product[3]=N_uc_8 product[2]=N_uc_7
+ product[1]=N_uc_6 product[0]=N_uc_5 VDD=VDD VSS=VSS
Xmult_30 unpu_pe_4_DW_mult_tc_0_DW_mult_tc_3 $PINS a[7]=weight_reg[7]
+ a[6]=weight_reg[6] a[5]=weight_reg[5] a[4]=weight_reg[4] a[3]=weight_reg[3]
+ a[2]=weight_reg[2] a[1]=weight_reg[1] a[0]=gre_a_INV_2782_3 b[7]=act_in[7]
+ b[6]=act_in[6] b[5]=act_in[5] b[4]=act_in[4] b[3]=act_in[3] b[2]=act_in[2]
+ b[1]=act_in[1] b[0]=act_in[0] product[15]=N_uc_36 product[14]=N_uc_35
+ product[13]=N_uc_34 product[12]=N_uc_33 product[11]=N_uc_32 product[10]=N_uc_31
+ product[9]=N_uc_30 product[8]=N_uc_29 product[7]=N_uc_28 product[6]=N_uc_27
+ product[5]=N_uc_26 product[4]=N_uc_25 product[3]=N_uc_24 product[2]=N_uc_23
+ product[1]=N_uc_22 product[0]=N_uc_21 VDD=VDD VSS=VSS
+ gre_a_INV_1872_2=gre_a_INV_1872_3
Xact_out_reg_3_ decrq1 $PINS D=copt_net_595 ENN=HFSNET_6 CP=ZCTSNET_11
+ CDN=HFSNET_8 Q=_gOb33_act_out[3] VDD=VDD VSS=VSS
Xact_out_reg_2_ decrq1 $PINS D=copt_net_1171 ENN=HFSNET_6 CP=ZCTSNET_11
+ CDN=HFSNET_7 Q=_gOb35_act_out[2] VDD=VDD VSS=VSS
Xact_out_reg_1_ decrq1 $PINS D=copt_net_1142 ENN=HFSNET_6 CP=ZCTSNET_11
+ CDN=HFSNET_8 Q=_gOb37_act_out[1] VDD=VDD VSS=VSS
Xact_out_reg_7_ decrq1 $PINS D=copt_net_1102 ENN=HFSNET_4 CP=ZCTSNET_11
+ CDN=HFSNET_7 Q=_gOb25_act_out[7] VDD=VDD VSS=VSS
Xact_out_reg_6_ decrq1 $PINS D=copt_net_640 ENN=HFSNET_6 CP=ZCTSNET_11
+ CDN=HFSNET_8 Q=_gOb27_act_out[6] VDD=VDD VSS=VSS
Xact_out_reg_5_ decrq1 $PINS D=copt_net_1221 ENN=HFSNET_6 CP=ZCTSNET_0
+ CDN=rst_n Q=_gOb29_act_out[5] VDD=VDD VSS=VSS
Xact_out_reg_4_ decrq1 $PINS D=copt_net_1154 ENN=HFSNET_6 CP=ZCTSNET_11
+ CDN=HFSNET_8 Q=_gOb31_act_out[4] VDD=VDD VSS=VSS
Xact_out_reg_0_ decrq1 $PINS D=copt_net_1343 ENN=HFSNET_3 CP=ZCTSNET_0
+ CDN=rst_n Q=_gOb39_act_out[0] VDD=VDD VSS=VSS
Xpsum_out_reg_7_ decrq1 $PINS D=N_uc_47 ENN=HFSNET_6 CP=ZCTSNET_2 CDN=HFSNET_8
+ Q=psum_out[7] VDD=VDD VSS=VSS
Xpsum_out_reg_6_ decrq1 $PINS D=N_uc_46 ENN=HFSNET_6 CP=ZCTSNET_2 CDN=HFSNET_8
+ Q=psum_out[6] VDD=VDD VSS=VSS
Xpsum_out_reg_5_ decrq1 $PINS D=N_uc_45 ENN=HFSNET_6 CP=ZCTSNET_2 CDN=HFSNET_8
+ Q=psum_out[5] VDD=VDD VSS=VSS
Xpsum_out_reg_4_ decrq1 $PINS D=N_uc_44 ENN=HFSNET_6 CP=ZCTSNET_11 CDN=HFSNET_8
+ Q=psum_out[4] VDD=VDD VSS=VSS
Xpsum_out_reg_3_ decrq1 $PINS D=N_uc_43 ENN=HFSNET_6 CP=ZCTSNET_2 CDN=HFSNET_8
+ Q=psum_out[3] VDD=VDD VSS=VSS
Xpsum_out_reg_2_ decrq1 $PINS D=N_uc_42 ENN=HFSNET_6 CP=ZCTSNET_11 CDN=HFSNET_8
+ Q=psum_out[2] VDD=VDD VSS=VSS
Xpsum_out_reg_1_ decrq1 $PINS D=N_uc_41 ENN=HFSNET_6 CP=ZCTSNET_2 CDN=HFSNET_9
+ Q=psum_out[1] VDD=VDD VSS=VSS
Xpsum_out_reg_0_ decrq1 $PINS D=N_uc_40 ENN=array_en CP=ZCTSNET_2 CDN=HFSNET_9
+ Q=psum_out[0] VDD=VDD VSS=VSS
Xpsum_out_reg_8_ decrq1 $PINS D=N_uc_48 ENN=HFSNET_6 CP=ZCTSNET_2 CDN=HFSNET_8
+ Q=psum_out[8] VDD=VDD VSS=VSS
Xpsum_out_reg_9_ decrq1 $PINS D=N_uc_49 ENN=HFSNET_6 CP=ZCTSNET_2 CDN=HFSNET_8
+ Q=psum_out[9] VDD=VDD VSS=VSS
Xpsum_out_reg_10_ decrq1 $PINS D=N_uc_50 ENN=HFSNET_6 CP=ZCTSNET_2 CDN=HFSNET_8
+ Q=psum_out[10] VDD=VDD VSS=VSS
Xweight_reg_reg_7_ decrq1 $PINS D=weight_in[7] ENN=n15 CP=ZCTSNET_2
+ CDN=HFSNET_9 Q=weight_reg[7] VDD=VDD VSS=VSS
Xweight_reg_reg_6_ decrq1 $PINS D=weight_in[6] ENN=n15 CP=ZCTSNET_2
+ CDN=HFSNET_9 Q=weight_reg[6] VDD=VDD VSS=VSS
Xweight_reg_reg_5_ decrq1 $PINS D=weight_in[5] ENN=n15 CP=ZCTSNET_2
+ CDN=HFSNET_9 Q=weight_reg[5] VDD=VDD VSS=VSS
Xweight_reg_reg_4_ decrq1 $PINS D=weight_in[4] ENN=n15 CP=ZCTSNET_2
+ CDN=HFSNET_9 Q=weight_reg[4] VDD=VDD VSS=VSS
Xweight_reg_reg_3_ decrq1 $PINS D=weight_in[3] ENN=n15 CP=ZCTSNET_2
+ CDN=HFSNET_9 Q=weight_reg[3] VDD=VDD VSS=VSS
Xweight_reg_reg_2_ decrq1 $PINS D=weight_in[2] ENN=n15 CP=ZCTSNET_2 CDN=rst_n
+ Q=weight_reg[2] VDD=VDD VSS=VSS
Xweight_reg_reg_1_ decrq1 $PINS D=weight_in[1] ENN=n15 CP=ZCTSNET_0 CDN=rst_n
+ Q=weight_reg[1] VDD=VDD VSS=VSS
Xweight_reg_reg_0_ decrq1 $PINS D=weight_in[0] ENN=n15 CP=ZCTSNET_12 CDN=rst_n
+ Q=weight_reg[0] VDD=VDD VSS=VSS
Xpsum_out_reg_11_ decrq1 $PINS D=N_uc_51 ENN=HFSNET_6 CP=ZCTSNET_2 CDN=HFSNET_8
+ Q=psum_out[11] VDD=VDD VSS=VSS
Xpsum_out_reg_12_ decrq1 $PINS D=N_uc_52 ENN=HFSNET_6 CP=ZCTSNET_2 CDN=HFSNET_8
+ Q=psum_out[12] VDD=VDD VSS=VSS
Xpsum_out_reg_13_ decrq1 $PINS D=N_uc_53 ENN=HFSNET_6 CP=ZCTSNET_2 CDN=HFSNET_8
+ Q=psum_out[13] VDD=VDD VSS=VSS
Xpsum_out_reg_14_ decrq1 $PINS D=N_uc_54 ENN=HFSNET_6 CP=ZCTSNET_2 CDN=HFSNET_8
+ Q=psum_out[14] VDD=VDD VSS=VSS
Xpsum_out_reg_15_ decrq1 $PINS D=N_uc_55 ENN=HFSNET_6 CP=ZCTSNET_2 CDN=HFSNET_8
+ Q=psum_out[15] VDD=VDD VSS=VSS
Xpsum_out_reg_16_ decrq1 $PINS D=N_uc_56 ENN=HFSNET_6 CP=ZCTSNET_2 CDN=HFSNET_8
+ Q=psum_out[16] VDD=VDD VSS=VSS
Xpsum_out_reg_17_ decrq1 $PINS D=N_uc_57 ENN=HFSNET_6 CP=ZCTSNET_2 CDN=HFSNET_8
+ Q=psum_out[17] VDD=VDD VSS=VSS
Xpsum_out_reg_18_ decrq1 $PINS D=N_uc_58 ENN=HFSNET_6 CP=ZCTSNET_2 CDN=HFSNET_8
+ Q=psum_out[18] VDD=VDD VSS=VSS
Xpsum_out_reg_19_ decrq1 $PINS D=N_uc_59 ENN=HFSNET_6 CP=ZCTSNET_2 CDN=HFSNET_8
+ Q=psum_out[19] VDD=VDD VSS=VSS
Xpsum_out_reg_20_ decrq1 $PINS D=N_uc_60 ENN=HFSNET_6 CP=ZCTSNET_2 CDN=HFSNET_8
+ Q=psum_out[20] VDD=VDD VSS=VSS
Xpsum_out_reg_21_ decrq1 $PINS D=N_uc_61 ENN=array_en CP=ZCTSNET_2 CDN=HFSNET_9
+ Q=psum_out[21] VDD=VDD VSS=VSS
Xpsum_out_reg_22_ decrq1 $PINS D=copt_net_2642 ENN=HFSNET_6 CP=ZCTSNET_2
+ CDN=HFSNET_8 Q=psum_out[22] VDD=VDD VSS=VSS
Xpsum_out_reg_23_ decrq1 $PINS D=N_uc_63 ENN=HFSNET_6 CP=ZCTSNET_2 CDN=HFSNET_8
+ Q=psum_out[23] VDD=VDD VSS=VSS
Xpsum_out_reg_24_ decrq1 $PINS D=N_uc_64 ENN=HFSNET_6 CP=ZCTSNET_2 CDN=HFSNET_8
+ Q=psum_out[24] VDD=VDD VSS=VSS
Xpsum_out_reg_25_ decrq1 $PINS D=N_uc_65 ENN=HFSNET_6 CP=ZCTSNET_2 CDN=HFSNET_8
+ Q=psum_out[25] VDD=VDD VSS=VSS
Xpsum_out_reg_26_ decrq1 $PINS D=N_uc_66 ENN=HFSNET_6 CP=ZCTSNET_2 CDN=HFSNET_8
+ Q=psum_out[26] VDD=VDD VSS=VSS
Xpsum_out_reg_27_ decrq1 $PINS D=N_uc_67 ENN=HFSNET_6 CP=ZCTSNET_2 CDN=HFSNET_8
+ Q=psum_out[27] VDD=VDD VSS=VSS
Xpsum_out_reg_28_ decrq1 $PINS D=N_uc_68 ENN=HFSNET_6 CP=ZCTSNET_11
+ CDN=HFSNET_8 Q=psum_out[28] VDD=VDD VSS=VSS
Xpsum_out_reg_29_ decrq1 $PINS D=N_uc_69 ENN=HFSNET_6 CP=ZCTSNET_2 CDN=HFSNET_8
+ Q=psum_out[29] VDD=VDD VSS=VSS
Xpsum_out_reg_30_ decrq1 $PINS D=N_uc_70 ENN=HFSNET_6 CP=ZCTSNET_2 CDN=HFSNET_8
+ Q=psum_out[30] VDD=VDD VSS=VSS
Xpsum_out_reg_31_ decrq1 $PINS D=N_uc_71 ENN=HFSNET_6 CP=ZCTSNET_2 CDN=HFSNET_8
+ Q=psum_out[31] VDD=VDD VSS=VSS
XU19 inv0d2 $PINS I=n16 ZN=n2 VDD=VDD VSS=VSS
XHFSINV_55015_580 inv0d1 $PINS I=HFSNET_5 ZN=HFSNET_6 VDD=VDD VSS=VSS
XHFSINV_5182_699 inv0d2 $PINS I=HFSNET_10 ZN=HFSNET_8 VDD=VDD VSS=VSS
Xcopt_h_inst_3425 dl02d1 $PINS I=act_in[3] Z=copt_net_595 VDD=VDD VSS=VSS
Xcopt_h_inst_3470 dl02d1 $PINS I=act_in[6] Z=copt_net_640 VDD=VDD VSS=VSS
Xcopt_h_inst_3934 dl02d1 $PINS I=act_in[7] Z=copt_net_1102 VDD=VDD VSS=VSS
XU25 nd02d1 $PINS A1=weight_load A2=HFSNET_5 ZN=n15 VDD=VDD VSS=VSS
Xcopt_h_inst_3974 dl01d1 $PINS I=act_in[1] Z=copt_net_1142 VDD=VDD VSS=VSS
Xcopt_h_inst_3986 dl01d1 $PINS I=act_in[4] Z=copt_net_1154 VDD=VDD VSS=VSS
Xcopt_h_inst_4003 dl01d1 $PINS I=act_in[2] Z=copt_net_1171 VDD=VDD VSS=VSS
Xcopt_h_inst_4053 dl01d1 $PINS I=act_in[5] Z=copt_net_1221 VDD=VDD VSS=VSS
XU30 nd02d1 $PINS A1=N_uc_36 A2=HFSNET_2 ZN=n16 VDD=VDD VSS=VSS
Xcopt_h_inst_4175 dl01d1 $PINS I=act_in[0] Z=copt_net_1343 VDD=VDD VSS=VSS
Xcopt_h_inst_5475 dl01d1 $PINS I=N_uc_62 Z=copt_net_2642 VDD=VDD VSS=VSS
Xgre_a_INV_2782_inst_5815 inv0d1 $PINS I=weight_reg[0] ZN=gre_a_INV_2782_3
+ VDD=VDD VSS=VSS
Xgre_a_INV_1872_inst_5838 inv0d1 $PINS I=weight_reg[1] ZN=gre_a_INV_1872_3
+ VDD=VDD VSS=VSS
.ENDS

.SUBCKT unpu_pe_5_DW_mult_tc_0_DW_mult_tc_4 a[7] a[6] a[5] a[4] a[3] a[2] a[1]
+ a[0] b[7] b[6] b[5] b[4] b[3] b[2] b[1] b[0] product[15] product[14]
+ product[13] product[12] product[11] product[10] product[9] product[8]
+ product[7] product[6] product[5] product[4] product[3] product[2] product[1]
+ product[0] VDD VSS
XU2 ad01d0 $PINS A=n196 B=n61 CI=n2 CO=n1 S=product[14] VDD=VDD VSS=VSS
XU3 ad01d0 $PINS A=n17 B=n16 CI=n3 CO=n2 S=product[13] VDD=VDD VSS=VSS
XU4 ad01d0 $PINS A=n18 B=n19 CI=n4 CO=n3 S=product[12] VDD=VDD VSS=VSS
XU5 ad01d0 $PINS A=n20 B=n23 CI=n5 CO=n4 S=product[11] VDD=VDD VSS=VSS
XU6 ad01d0 $PINS A=n27 B=n24 CI=n6 CO=n5 S=product[10] VDD=VDD VSS=VSS
XU7 ad01d0 $PINS A=n33 B=n28 CI=n7 CO=n6 S=product[9] VDD=VDD VSS=VSS
XU8 ad01d0 $PINS A=n39 B=n34 CI=n8 CO=n7 S=product[8] VDD=VDD VSS=VSS
XU9 ad01d0 $PINS A=n45 B=n40 CI=n9 CO=n8 S=product[7] VDD=VDD VSS=VSS
XU10 ad01d0 $PINS A=n49 B=n46 CI=n10 CO=n9 S=product[6] VDD=VDD VSS=VSS
XU11 ad01d0 $PINS A=n53 B=n50 CI=n11 CO=n10 S=product[5] VDD=VDD VSS=VSS
XU12 ad01d0 $PINS A=n55 B=n54 CI=n12 CO=n11 S=product[4] VDD=VDD VSS=VSS
XU13 ad01d0 $PINS A=n59 B=n56 CI=n13 CO=n12 S=product[3] VDD=VDD VSS=VSS
XU14 ad01d0 $PINS A=n84 B=n91 CI=n14 CO=n13 S=product[2] VDD=VDD VSS=VSS
XctmTdsLR_1_2985 an02d1 $PINS A1=n58 A2=n75 Z=n51 VDD=VDD VSS=VSS
XU17 ad01d0 $PINS A=n195 B=n62 CI=n69 CO=n17 S=n18 VDD=VDD VSS=VSS
XU18 ad01d0 $PINS A=n63 B=n25 CI=n22 CO=n19 S=n20 VDD=VDD VSS=VSS
XU20 ad01d0 $PINS A=n64 B=n26 CI=n29 CO=n23 S=n24 VDD=VDD VSS=VSS
XU21 ad01d0 $PINS A=n194 B=n70 CI=n77 CO=n25 S=n26 VDD=VDD VSS=VSS
XU22 ad01d0 $PINS A=n32 B=n35 CI=n30 CO=n27 S=n28 VDD=VDD VSS=VSS
XU23 ad01d0 $PINS A=n71 B=n65 CI=n37 CO=n29 S=n30 VDD=VDD VSS=VSS
XU25 ad01d0 $PINS A=n38 B=n41 CI=n36 CO=n33 S=n34 VDD=VDD VSS=VSS
XU26 ad01d0 $PINS A=n72 B=n85 CI=n43 CO=n35 S=n36 VDD=VDD VSS=VSS
XU29 ad01d0 $PINS A=n44 B=n47 CI=n42 CO=n39 S=n40 VDD=VDD VSS=VSS
XU30 ad01d0 $PINS A=n86 B=n73 CI=n79 CO=n41 S=n42 VDD=VDD VSS=VSS
XU32 ad01d0 $PINS A=n74 B=n51 CI=n48 CO=n45 S=n46 VDD=VDD VSS=VSS
XU33 ad01d0 $PINS A=n68 B=n87 CI=n80 CO=n47 S=n48 VDD=VDD VSS=VSS
XU34 ad01d0 $PINS A=n88 B=n81 CI=n52 CO=n49 S=n50 VDD=VDD VSS=VSS
XU36 ad01d0 $PINS A=n76 B=n89 CI=n82 CO=n53 S=n54 VDD=VDD VSS=VSS
XU37 ah01d1 $PINS A=n83 B=n90 CO=n55 S=n56 VDD=VDD VSS=VSS
XU145 oai21d1 $PINS B1=n203 B2=n249 A=n222 ZN=n77 VDD=VDD VSS=VSS
XU146 oai21d1 $PINS B1=n201 B2=n250 A=n232 ZN=n69 VDD=VDD VSS=VSS
XU147 oai21d1 $PINS B1=n199 B2=n251 A=n242 ZN=n61 VDD=VDD VSS=VSS
XU148 inv0d0 $PINS I=n16 ZN=n196 VDD=VDD VSS=VSS
XU149 inv0d0 $PINS I=n223 ZN=n201 VDD=VDD VSS=VSS
XU150 inv0d0 $PINS I=n214 ZN=n203 VDD=VDD VSS=VSS
XU151 inv0d0 $PINS I=n233 ZN=n199 VDD=VDD VSS=VSS
XU152 inv0d0 $PINS I=n32 ZN=n194 VDD=VDD VSS=VSS
XU153 inv0d0 $PINS I=n22 ZN=n195 VDD=VDD VSS=VSS
XU154 nd02d1 $PINS A1=n214 A2=n249 ZN=n216 VDD=VDD VSS=VSS
XU155 xr02d1 $PINS A1=a[2] A2=n204 Z=n214 VDD=VDD VSS=VSS
XU156 inv0d1 $PINS I=a[1] ZN=n204 VDD=VDD VSS=VSS
XU157 nd02d1 $PINS A1=n223 A2=n250 ZN=n225 VDD=VDD VSS=VSS
XU158 xr02d1 $PINS A1=a[4] A2=n202 Z=n223 VDD=VDD VSS=VSS
XU159 inv0d1 $PINS I=a[3] ZN=n202 VDD=VDD VSS=VSS
XU160 nd02d1 $PINS A1=a[1] A2=a[0] ZN=n206 VDD=VDD VSS=VSS
XU162 inv0d0 $PINS I=b[0] ZN=n197 VDD=VDD VSS=VSS
XU163 xr02d1 $PINS A1=a[6] A2=n200 Z=n233 VDD=VDD VSS=VSS
XU164 inv0d1 $PINS I=a[5] ZN=n200 VDD=VDD VSS=VSS
XU165 nd02d1 $PINS A1=n233 A2=n251 ZN=n235 VDD=VDD VSS=VSS
XU166 inv0d0 $PINS I=a[7] ZN=n198 VDD=VDD VSS=VSS
XU167 inv0d0 $PINS I=n1 ZN=product[15] VDD=VDD VSS=VSS
XU168 nr02d0 $PINS A1=a[0] A2=n197 ZN=product[0] VDD=VDD VSS=VSS
XU169 oai22d1 $PINS A1=b[0] A2=n206 B1=n207 B2=a[0] ZN=n92 VDD=VDD VSS=VSS
XU170 oai22d1 $PINS A1=n207 A2=n206 B1=n208 B2=a[0] ZN=n91 VDD=VDD VSS=VSS
XU171 xr02d1 $PINS A1=b[1] A2=n204 Z=n207 VDD=VDD VSS=VSS
XU172 oai22d1 $PINS A1=n208 A2=n206 B1=n209 B2=a[0] ZN=n90 VDD=VDD VSS=VSS
XU173 xr02d1 $PINS A1=b[2] A2=n204 Z=n208 VDD=VDD VSS=VSS
XU174 oai22d1 $PINS A1=n209 A2=n206 B1=n210 B2=a[0] ZN=n89 VDD=VDD VSS=VSS
XU175 xr02d1 $PINS A1=b[3] A2=n204 Z=n209 VDD=VDD VSS=VSS
XU176 oai22d1 $PINS A1=n210 A2=n206 B1=n211 B2=a[0] ZN=n88 VDD=VDD VSS=VSS
XU177 xr02d1 $PINS A1=b[4] A2=n204 Z=n210 VDD=VDD VSS=VSS
XU178 oai22d1 $PINS A1=n211 A2=n206 B1=n212 B2=a[0] ZN=n87 VDD=VDD VSS=VSS
XU179 xr02d1 $PINS A1=b[5] A2=n204 Z=n211 VDD=VDD VSS=VSS
XU180 oai22d1 $PINS A1=n212 A2=n206 B1=n213 B2=a[0] ZN=n86 VDD=VDD VSS=VSS
XU181 xr02d1 $PINS A1=b[6] A2=n204 Z=n212 VDD=VDD VSS=VSS
XU182 aor21d1 $PINS B1=a[0] B2=n206 A=n213 Z=n85 VDD=VDD VSS=VSS
XU183 xr02d1 $PINS A1=b[7] A2=n204 Z=n213 VDD=VDD VSS=VSS
XU184 nr02d0 $PINS A1=n214 A2=n197 ZN=n84 VDD=VDD VSS=VSS
XU185 oai22d1 $PINS A1=n216 A2=n215 B1=n214 B2=n217 ZN=n83 VDD=VDD VSS=VSS
XctmTdsLR_1_2961 an02d1 $PINS A1=n60 A2=n92 Z=n14 VDD=VDD VSS=VSS
XU187 oai22d1 $PINS A1=n217 A2=n216 B1=n214 B2=n218 ZN=n82 VDD=VDD VSS=VSS
XU188 xr02d1 $PINS A1=b[1] A2=n202 Z=n217 VDD=VDD VSS=VSS
XU189 oai22d1 $PINS A1=n218 A2=n216 B1=n214 B2=n219 ZN=n81 VDD=VDD VSS=VSS
XU190 xr02d1 $PINS A1=b[2] A2=n202 Z=n218 VDD=VDD VSS=VSS
XU191 oai22d1 $PINS A1=n219 A2=n216 B1=n214 B2=n220 ZN=n80 VDD=VDD VSS=VSS
XU192 xr02d1 $PINS A1=b[3] A2=n202 Z=n219 VDD=VDD VSS=VSS
XU193 oai22d1 $PINS A1=n220 A2=n216 B1=n214 B2=n221 ZN=n79 VDD=VDD VSS=VSS
XU194 xr02d1 $PINS A1=b[4] A2=n202 Z=n220 VDD=VDD VSS=VSS
XU195 nr02d0 $PINS A1=n223 A2=n197 ZN=n76 VDD=VDD VSS=VSS
XU196 oai22d1 $PINS A1=n225 A2=n224 B1=n226 B2=n223 ZN=n75 VDD=VDD VSS=VSS
XctmTdsLR_2_2962 aoim21d1 $PINS B1=n92 B2=n60 A=n14 ZN=product[1] VDD=VDD
+ VSS=VSS
XU198 oai22d1 $PINS A1=n226 A2=n225 B1=n223 B2=n227 ZN=n74 VDD=VDD VSS=VSS
XU199 xr02d1 $PINS A1=b[1] A2=n200 Z=n226 VDD=VDD VSS=VSS
XU200 oai22d1 $PINS A1=n227 A2=n225 B1=n223 B2=n228 ZN=n73 VDD=VDD VSS=VSS
XU201 xr02d1 $PINS A1=b[2] A2=n200 Z=n227 VDD=VDD VSS=VSS
XU202 oai22d1 $PINS A1=n228 A2=n225 B1=n223 B2=n229 ZN=n72 VDD=VDD VSS=VSS
XU203 xr02d1 $PINS A1=b[3] A2=n200 Z=n228 VDD=VDD VSS=VSS
XU204 oai22d1 $PINS A1=n229 A2=n225 B1=n223 B2=n230 ZN=n71 VDD=VDD VSS=VSS
XU205 xr02d1 $PINS A1=b[4] A2=n200 Z=n229 VDD=VDD VSS=VSS
XU206 oai22d1 $PINS A1=n230 A2=n225 B1=n223 B2=n231 ZN=n70 VDD=VDD VSS=VSS
XU207 xr02d1 $PINS A1=b[5] A2=n200 Z=n230 VDD=VDD VSS=VSS
XU208 nr02d0 $PINS A1=n233 A2=n197 ZN=n68 VDD=VDD VSS=VSS
XU209 oai22d1 $PINS A1=n234 A2=n235 B1=n236 B2=n233 ZN=n67 VDD=VDD VSS=VSS
XctmTdsLR_2_2986 aoim21d1 $PINS B1=n58 B2=n75 A=n51 ZN=n52 VDD=VDD VSS=VSS
XU211 oai22d1 $PINS A1=n237 A2=n235 B1=n233 B2=n238 ZN=n65 VDD=VDD VSS=VSS
XU212 oai22d1 $PINS A1=n238 A2=n235 B1=n233 B2=n239 ZN=n64 VDD=VDD VSS=VSS
XU213 xr02d1 $PINS A1=b[3] A2=n198 Z=n238 VDD=VDD VSS=VSS
XU214 oai22d1 $PINS A1=n239 A2=n235 B1=n233 B2=n240 ZN=n63 VDD=VDD VSS=VSS
XU215 xr02d1 $PINS A1=b[4] A2=n198 Z=n239 VDD=VDD VSS=VSS
XU216 oai22d1 $PINS A1=n240 A2=n235 B1=n233 B2=n241 ZN=n62 VDD=VDD VSS=VSS
XU217 xr02d1 $PINS A1=b[5] A2=n198 Z=n240 VDD=VDD VSS=VSS
XU218 oai21d1 $PINS B1=b[0] B2=n204 A=n206 ZN=n60 VDD=VDD VSS=VSS
XU219 oai21d1 $PINS B1=n202 B2=n216 A=n243 ZN=n59 VDD=VDD VSS=VSS
XU220 nd03d0 $PINS A1=n203 A2=n197 A3=a[3] ZN=n243 VDD=VDD VSS=VSS
XU221 oai21d1 $PINS B1=n200 B2=n225 A=n244 ZN=n58 VDD=VDD VSS=VSS
XU222 nd03d0 $PINS A1=n201 A2=n197 A3=a[5] ZN=n244 VDD=VDD VSS=VSS
XU223 oai21d1 $PINS B1=n198 B2=n235 A=n245 ZN=n57 VDD=VDD VSS=VSS
XU224 nd03d0 $PINS A1=n199 A2=n197 A3=a[7] ZN=n245 VDD=VDD VSS=VSS
XU225 xn02d1 $PINS A1=n246 A2=n247 ZN=n38 VDD=VDD VSS=VSS
XU226 or02d0 $PINS A1=n247 A2=n246 Z=n37 VDD=VDD VSS=VSS
XU227 oai22d1 $PINS A1=n236 A2=n235 B1=n233 B2=n237 ZN=n246 VDD=VDD VSS=VSS
XU228 xr02d1 $PINS A1=b[2] A2=n198 Z=n237 VDD=VDD VSS=VSS
XU229 xr02d1 $PINS A1=b[1] A2=n198 Z=n236 VDD=VDD VSS=VSS
XU230 oai22d1 $PINS A1=n221 A2=n216 B1=n214 B2=n248 ZN=n247 VDD=VDD VSS=VSS
XU231 xr02d1 $PINS A1=b[5] A2=n202 Z=n221 VDD=VDD VSS=VSS
XU232 aoim22d1 $PINS A1=n203 A2=n222 B1=n248 B2=n216 Z=n32 VDD=VDD VSS=VSS
XU233 xr02d1 $PINS A1=a[3] A2=a[2] Z=n249 VDD=VDD VSS=VSS
XU234 xr02d1 $PINS A1=b[6] A2=n202 Z=n248 VDD=VDD VSS=VSS
XU235 xr02d1 $PINS A1=b[7] A2=a[3] Z=n222 VDD=VDD VSS=VSS
XU236 aoim22d1 $PINS A1=n201 A2=n232 B1=n231 B2=n225 Z=n22 VDD=VDD VSS=VSS
XU237 xr02d1 $PINS A1=a[5] A2=a[4] Z=n250 VDD=VDD VSS=VSS
XU238 xr02d1 $PINS A1=b[6] A2=n200 Z=n231 VDD=VDD VSS=VSS
XU239 xr02d1 $PINS A1=b[7] A2=a[5] Z=n232 VDD=VDD VSS=VSS
XU240 aoim22d1 $PINS A1=n199 A2=n242 B1=n241 B2=n235 Z=n16 VDD=VDD VSS=VSS
XU241 xr02d1 $PINS A1=a[7] A2=a[6] Z=n251 VDD=VDD VSS=VSS
XU242 xr02d1 $PINS A1=b[6] A2=n198 Z=n241 VDD=VDD VSS=VSS
XU243 xr02d1 $PINS A1=b[7] A2=a[7] Z=n242 VDD=VDD VSS=VSS
XctmTdsLR_1_1349 aoim22d1 $PINS A1=n202 A2=b[0] B1=n202 B2=b[0] Z=n215 VDD=VDD
+ VSS=VSS
XctmTdsLR_1_1350 aoim22d1 $PINS A1=n200 A2=b[0] B1=n200 B2=b[0] Z=n224 VDD=VDD
+ VSS=VSS
XctmTdsLR_1_1351 aoim22d1 $PINS A1=n198 A2=b[0] B1=n198 B2=b[0] Z=n234 VDD=VDD
+ VSS=VSS
XctmTdsLR_1_2987 an02d1 $PINS A1=n67 A2=n57 Z=n43 VDD=VDD VSS=VSS
XctmTdsLR_2_2988 aoim21d1 $PINS B1=n67 B2=n57 A=n43 ZN=n44 VDD=VDD VSS=VSS
.ENDS

.SUBCKT unpu_pe_5_DW_mult_uns_0_DW_mult_uns_5 a[7] a[6] a[5] a[4] a[3] a[2]
+ a[1] a[0] b[7] b[6] b[5] b[4] b[3] b[2] b[1] b[0] product[15] product[14]
+ product[13] product[12] product[11] product[10] product[9] product[8]
+ product[7] product[6] product[5] product[4] product[3] product[2] product[1]
+ product[0] VDD VSS
XU2 ad01d0 $PINS A=n99 B=n15 CI=n2 CO=product[15] S=product[14] VDD=VDD VSS=VSS
XU3 ad01d0 $PINS A=n16 B=n17 CI=n3 CO=n2 S=product[13] VDD=VDD VSS=VSS
XU4 ad01d0 $PINS A=n18 B=n21 CI=n4 CO=n3 S=product[12] VDD=VDD VSS=VSS
XU5 ad01d0 $PINS A=n27 B=n22 CI=n5 CO=n4 S=product[11] VDD=VDD VSS=VSS
XU6 ad01d0 $PINS A=n35 B=n28 CI=n6 CO=n5 S=product[10] VDD=VDD VSS=VSS
XU7 ad01d0 $PINS A=n45 B=n36 CI=n7 CO=n6 S=product[9] VDD=VDD VSS=VSS
XU8 ad01d1 $PINS A=n57 B=n46 CI=n8 CO=n7 S=product[8] VDD=VDD VSS=VSS
XU9 ad01d0 $PINS A=n69 B=n58 CI=n9 CO=n8 S=product[7] VDD=VDD VSS=VSS
XU10 ad01d0 $PINS A=n79 B=n70 CI=n10 CO=n9 S=product[6] VDD=VDD VSS=VSS
XU11 ad01d0 $PINS A=n87 B=n80 CI=n11 CO=n10 S=product[5] VDD=VDD VSS=VSS
XU12 ad01d0 $PINS A=n93 B=n88 CI=n12 CO=n11 S=product[4] VDD=VDD VSS=VSS
XU13 ad01d0 $PINS A=n96 B=n13 CI=n94 CO=n12 S=product[3] VDD=VDD VSS=VSS
XU14 ad01d0 $PINS A=n146 B=n14 CI=n98 CO=n13 S=product[2] VDD=VDD VSS=VSS
XU15 ah01d1 $PINS A=n161 B=n154 CO=n14 S=product[1] VDD=VDD VSS=VSS
XU16 ad01d0 $PINS A=n107 B=n100 CI=n19 CO=n15 S=n16 VDD=VDD VSS=VSS
XU17 ad01d0 $PINS A=n25 B=n20 CI=n23 CO=n17 S=n18 VDD=VDD VSS=VSS
XU18 ad01d0 $PINS A=n115 B=n101 CI=n108 CO=n19 S=n20 VDD=VDD VSS=VSS
XU19 ad01d0 $PINS A=n31 B=n24 CI=n29 CO=n21 S=n22 VDD=VDD VSS=VSS
XU20 ad01d0 $PINS A=n116 B=n33 CI=n26 CO=n23 S=n24 VDD=VDD VSS=VSS
XU21 ad01d0 $PINS A=n123 B=n102 CI=n109 CO=n25 S=n26 VDD=VDD VSS=VSS
XU22 ad01d0 $PINS A=n32 B=n37 CI=n30 CO=n27 S=n28 VDD=VDD VSS=VSS
XU23 ad01d0 $PINS A=n41 B=n34 CI=n39 CO=n29 S=n30 VDD=VDD VSS=VSS
XU24 ad01d0 $PINS A=n124 B=n117 CI=n43 CO=n31 S=n32 VDD=VDD VSS=VSS
XU25 ad01d0 $PINS A=n131 B=n103 CI=n110 CO=n33 S=n34 VDD=VDD VSS=VSS
XU26 ad01d0 $PINS A=n40 B=n47 CI=n38 CO=n35 S=n36 VDD=VDD VSS=VSS
XU27 ad01d0 $PINS A=n44 B=n51 CI=n49 CO=n37 S=n38 VDD=VDD VSS=VSS
XU28 ad01d0 $PINS A=n55 B=n53 CI=n42 CO=n39 S=n40 VDD=VDD VSS=VSS
XU29 ad01d0 $PINS A=n118 B=n125 CI=n132 CO=n41 S=n42 VDD=VDD VSS=VSS
XU30 ad01d0 $PINS A=n139 B=n104 CI=n111 CO=n43 S=n44 VDD=VDD VSS=VSS
XU31 ad01d0 $PINS A=n50 B=n59 CI=n48 CO=n45 S=n46 VDD=VDD VSS=VSS
XU32 ad01d0 $PINS A=n54 B=n52 CI=n61 CO=n47 S=n48 VDD=VDD VSS=VSS
XU33 ad01d0 $PINS A=n56 B=n65 CI=n63 CO=n49 S=n50 VDD=VDD VSS=VSS
XU34 ad01d0 $PINS A=n140 B=n133 CI=n67 CO=n51 S=n52 VDD=VDD VSS=VSS
XU35 ad01d0 $PINS A=n126 B=n119 CI=n147 CO=n53 S=n54 VDD=VDD VSS=VSS
XU36 ah01d1 $PINS A=n105 B=n112 CO=n55 S=n56 VDD=VDD VSS=VSS
XU37 ad01d0 $PINS A=n71 B=n62 CI=n60 CO=n57 S=n58 VDD=VDD VSS=VSS
XU38 ad01d0 $PINS A=n64 B=n66 CI=n73 CO=n59 S=n60 VDD=VDD VSS=VSS
XU39 ad01d0 $PINS A=n77 B=n68 CI=n75 CO=n61 S=n62 VDD=VDD VSS=VSS
XU40 ad01d0 $PINS A=n141 B=n127 CI=n134 CO=n63 S=n64 VDD=VDD VSS=VSS
XU41 ad01d0 $PINS A=n155 B=n120 CI=n148 CO=n65 S=n66 VDD=VDD VSS=VSS
XU42 ah01d1 $PINS A=n106 B=n113 CO=n67 S=n68 VDD=VDD VSS=VSS
XU43 ad01d0 $PINS A=n81 B=n74 CI=n72 CO=n69 S=n70 VDD=VDD VSS=VSS
XU44 ad01d0 $PINS A=n78 B=n83 CI=n76 CO=n71 S=n72 VDD=VDD VSS=VSS
XU45 ad01d0 $PINS A=n142 B=n135 CI=n85 CO=n73 S=n74 VDD=VDD VSS=VSS
XU46 ad01d0 $PINS A=n156 B=n128 CI=n149 CO=n75 S=n76 VDD=VDD VSS=VSS
XU47 ah01d1 $PINS A=n114 B=n121 CO=n77 S=n78 VDD=VDD VSS=VSS
XU48 ad01d0 $PINS A=n89 B=n84 CI=n82 CO=n79 S=n80 VDD=VDD VSS=VSS
XU49 ad01d0 $PINS A=n150 B=n91 CI=n86 CO=n81 S=n82 VDD=VDD VSS=VSS
XU50 ad01d0 $PINS A=n157 B=n136 CI=n143 CO=n83 S=n84 VDD=VDD VSS=VSS
XU51 ah01d1 $PINS A=n122 B=n129 CO=n85 S=n86 VDD=VDD VSS=VSS
XU52 ad01d0 $PINS A=n95 B=n92 CI=n90 CO=n87 S=n88 VDD=VDD VSS=VSS
XU53 ad01d1 $PINS A=n158 B=n144 CI=n151 CO=n89 S=n90 VDD=VDD VSS=VSS
XU54 ah01d1 $PINS A=n130 B=n137 CO=n91 S=n92 VDD=VDD VSS=VSS
XU55 ad01d0 $PINS A=n159 B=n152 CI=n97 CO=n93 S=n94 VDD=VDD VSS=VSS
XU56 ah01d1 $PINS A=n138 B=n145 CO=n95 S=n96 VDD=VDD VSS=VSS
XU57 ah01d1 $PINS A=n153 B=n160 CO=n97 S=n98 VDD=VDD VSS=VSS
XU140 inv0d0 $PINS I=b[4] ZN=n217 VDD=VDD VSS=VSS
XU141 inv0d0 $PINS I=a[1] ZN=n228 VDD=VDD VSS=VSS
XU142 inv0d1 $PINS I=b[2] ZN=n219 VDD=VDD VSS=VSS
XU144 inv0d0 $PINS I=a[2] ZN=n227 VDD=VDD VSS=VSS
XU145 inv0d0 $PINS I=b[3] ZN=n218 VDD=VDD VSS=VSS
XU146 inv0d0 $PINS I=a[5] ZN=n224 VDD=VDD VSS=VSS
XU147 inv0d0 $PINS I=b[1] ZN=n220 VDD=VDD VSS=VSS
XU148 inv0d0 $PINS I=b[0] ZN=n221 VDD=VDD VSS=VSS
XU149 inv0d0 $PINS I=a[4] ZN=n225 VDD=VDD VSS=VSS
XU150 inv0d0 $PINS I=b[6] ZN=n215 VDD=VDD VSS=VSS
XU151 inv0d0 $PINS I=a[3] ZN=n226 VDD=VDD VSS=VSS
XU152 inv0d0 $PINS I=b[5] ZN=n216 VDD=VDD VSS=VSS
XU153 inv0d0 $PINS I=b[7] ZN=n214 VDD=VDD VSS=VSS
XU154 inv0d0 $PINS I=a[6] ZN=n223 VDD=VDD VSS=VSS
XU155 inv0d0 $PINS I=a[7] ZN=n222 VDD=VDD VSS=VSS
XU156 nr02d0 $PINS A1=a[0] A2=n221 ZN=product[0] VDD=VDD VSS=VSS
XU157 nr02d0 $PINS A1=n222 A2=n214 ZN=n99 VDD=VDD VSS=VSS
XU158 nr02d0 $PINS A1=a[0] A2=n220 ZN=n161 VDD=VDD VSS=VSS
XU159 nr02d0 $PINS A1=a[0] A2=n219 ZN=n160 VDD=VDD VSS=VSS
XU160 nr02d0 $PINS A1=a[0] A2=n218 ZN=n159 VDD=VDD VSS=VSS
XU161 nr02d0 $PINS A1=a[0] A2=n217 ZN=n158 VDD=VDD VSS=VSS
XU162 nr02d0 $PINS A1=a[0] A2=n216 ZN=n157 VDD=VDD VSS=VSS
XU163 nr02d0 $PINS A1=a[0] A2=n215 ZN=n156 VDD=VDD VSS=VSS
XU164 nr02d0 $PINS A1=a[0] A2=n214 ZN=n155 VDD=VDD VSS=VSS
XU165 nr02d0 $PINS A1=n221 A2=n228 ZN=n154 VDD=VDD VSS=VSS
XU166 nr02d0 $PINS A1=n220 A2=n228 ZN=n153 VDD=VDD VSS=VSS
XU167 nr02d0 $PINS A1=n219 A2=n228 ZN=n152 VDD=VDD VSS=VSS
XU168 nr02d0 $PINS A1=n218 A2=n228 ZN=n151 VDD=VDD VSS=VSS
XU169 nr02d0 $PINS A1=n217 A2=n228 ZN=n150 VDD=VDD VSS=VSS
XU170 nr02d0 $PINS A1=n216 A2=n228 ZN=n149 VDD=VDD VSS=VSS
XU171 nr02d0 $PINS A1=n215 A2=n228 ZN=n148 VDD=VDD VSS=VSS
XU172 nr02d0 $PINS A1=n214 A2=n228 ZN=n147 VDD=VDD VSS=VSS
XU173 nr02d0 $PINS A1=n221 A2=n227 ZN=n146 VDD=VDD VSS=VSS
XU174 nr02d0 $PINS A1=n220 A2=n227 ZN=n145 VDD=VDD VSS=VSS
XU175 nr02d0 $PINS A1=n219 A2=n227 ZN=n144 VDD=VDD VSS=VSS
XU176 nr02d0 $PINS A1=n218 A2=n227 ZN=n143 VDD=VDD VSS=VSS
XU177 nr02d0 $PINS A1=n217 A2=n227 ZN=n142 VDD=VDD VSS=VSS
XU178 nr02d0 $PINS A1=n216 A2=n227 ZN=n141 VDD=VDD VSS=VSS
XU179 nr02d0 $PINS A1=n215 A2=n227 ZN=n140 VDD=VDD VSS=VSS
XU180 nr02d0 $PINS A1=n214 A2=n227 ZN=n139 VDD=VDD VSS=VSS
XU181 nr02d0 $PINS A1=n221 A2=n226 ZN=n138 VDD=VDD VSS=VSS
XU182 nr02d0 $PINS A1=n220 A2=n226 ZN=n137 VDD=VDD VSS=VSS
XU183 nr02d0 $PINS A1=n219 A2=n226 ZN=n136 VDD=VDD VSS=VSS
XU184 nr02d0 $PINS A1=n218 A2=n226 ZN=n135 VDD=VDD VSS=VSS
XU185 nr02d0 $PINS A1=n217 A2=n226 ZN=n134 VDD=VDD VSS=VSS
XU186 nr02d0 $PINS A1=n216 A2=n226 ZN=n133 VDD=VDD VSS=VSS
XU187 nr02d0 $PINS A1=n215 A2=n226 ZN=n132 VDD=VDD VSS=VSS
XU188 nr02d0 $PINS A1=n214 A2=n226 ZN=n131 VDD=VDD VSS=VSS
XU189 nr02d0 $PINS A1=n221 A2=n225 ZN=n130 VDD=VDD VSS=VSS
XU190 nr02d0 $PINS A1=n220 A2=n225 ZN=n129 VDD=VDD VSS=VSS
XU191 nr02d0 $PINS A1=n219 A2=n225 ZN=n128 VDD=VDD VSS=VSS
XU192 nr02d0 $PINS A1=n218 A2=n225 ZN=n127 VDD=VDD VSS=VSS
XU193 nr02d0 $PINS A1=n217 A2=n225 ZN=n126 VDD=VDD VSS=VSS
XU194 nr02d0 $PINS A1=n216 A2=n225 ZN=n125 VDD=VDD VSS=VSS
XU195 nr02d0 $PINS A1=n215 A2=n225 ZN=n124 VDD=VDD VSS=VSS
XU196 nr02d0 $PINS A1=n214 A2=n225 ZN=n123 VDD=VDD VSS=VSS
XU197 nr02d0 $PINS A1=n221 A2=n224 ZN=n122 VDD=VDD VSS=VSS
XU198 nr02d0 $PINS A1=n220 A2=n224 ZN=n121 VDD=VDD VSS=VSS
XU199 nr02d0 $PINS A1=n219 A2=n224 ZN=n120 VDD=VDD VSS=VSS
XU200 nr02d0 $PINS A1=n218 A2=n224 ZN=n119 VDD=VDD VSS=VSS
XU201 nr02d0 $PINS A1=n217 A2=n224 ZN=n118 VDD=VDD VSS=VSS
XU202 nr02d0 $PINS A1=n216 A2=n224 ZN=n117 VDD=VDD VSS=VSS
XU203 nr02d0 $PINS A1=n215 A2=n224 ZN=n116 VDD=VDD VSS=VSS
XU204 nr02d0 $PINS A1=n214 A2=n224 ZN=n115 VDD=VDD VSS=VSS
XU205 nr02d0 $PINS A1=n221 A2=n223 ZN=n114 VDD=VDD VSS=VSS
XU206 nr02d0 $PINS A1=n220 A2=n223 ZN=n113 VDD=VDD VSS=VSS
XU207 nr02d0 $PINS A1=n219 A2=n223 ZN=n112 VDD=VDD VSS=VSS
XU208 nr02d0 $PINS A1=n218 A2=n223 ZN=n111 VDD=VDD VSS=VSS
XU209 nr02d0 $PINS A1=n217 A2=n223 ZN=n110 VDD=VDD VSS=VSS
XU210 nr02d0 $PINS A1=n216 A2=n223 ZN=n109 VDD=VDD VSS=VSS
XU211 nr02d0 $PINS A1=n215 A2=n223 ZN=n108 VDD=VDD VSS=VSS
XU212 nr02d0 $PINS A1=n214 A2=n223 ZN=n107 VDD=VDD VSS=VSS
XU213 nr02d0 $PINS A1=n221 A2=n222 ZN=n106 VDD=VDD VSS=VSS
XU214 nr02d0 $PINS A1=n222 A2=n220 ZN=n105 VDD=VDD VSS=VSS
XU215 nr02d0 $PINS A1=n222 A2=n219 ZN=n104 VDD=VDD VSS=VSS
XU216 nr02d0 $PINS A1=n222 A2=n218 ZN=n103 VDD=VDD VSS=VSS
XU217 nr02d0 $PINS A1=n222 A2=n217 ZN=n102 VDD=VDD VSS=VSS
XU218 nr02d0 $PINS A1=n222 A2=n216 ZN=n101 VDD=VDD VSS=VSS
XU219 nr02d0 $PINS A1=n222 A2=n215 ZN=n100 VDD=VDD VSS=VSS
.ENDS

.SUBCKT unpu_pe_5_DW01_add_0_DW01_add_6 A[31] A[30] A[29] A[28] A[27] A[26]
+ A[25] A[24] A[23] A[22] A[21] A[20] A[19] A[18] A[17] A[16] A[15] A[14] A[13]
+ A[12] A[11] A[10] A[9] A[8] A[7] A[6] A[5] A[4] A[3] A[2] A[1] A[0] B[31]
+ B[30] B[29] B[28] B[27] B[26] B[25] B[24] B[23] B[22] B[21] B[20] B[19] B[18]
+ B[17] B[16] B[15] B[14] B[13] B[12] B[11] B[10] B[9] B[8] B[7] B[6] B[5] B[4]
+ B[3] B[2] B[1] B[0] CI SUM[31] SUM[30] SUM[29] SUM[28] SUM[27] SUM[26]
+ SUM[25] SUM[24] SUM[23] SUM[22] SUM[21] SUM[20] SUM[19] SUM[18] SUM[17]
+ SUM[16] SUM[15] SUM[14] SUM[13] SUM[12] SUM[11] SUM[10] SUM[9] SUM[8] SUM[7]
+ SUM[6] SUM[5] SUM[4] SUM[3] SUM[2] SUM[1] SUM[0] CO VDD VSS
XU1_31 ad01d0 $PINS A=copt_net_2087 B=B[31] CI=carry[31] S=SUM[31] VDD=VDD
+ VSS=VSS
XU1_30 ad01d0 $PINS A=copt_net_2028 B=B[30] CI=carry[30] CO=carry[31] S=SUM[30]
+ VDD=VDD VSS=VSS
XU1_29 ad01d0 $PINS A=copt_net_1631 B=B[29] CI=carry[29] CO=carry[30] S=SUM[29]
+ VDD=VDD VSS=VSS
XU1_28 ad01d0 $PINS A=copt_net_1518 B=B[28] CI=carry[28] CO=carry[29] S=SUM[28]
+ VDD=VDD VSS=VSS
XU1_27 ad01d0 $PINS A=copt_net_2054 B=B[27] CI=carry[27] CO=carry[28] S=SUM[27]
+ VDD=VDD VSS=VSS
XU1_26 ad01d0 $PINS A=copt_net_1943 B=B[26] CI=carry[26] CO=carry[27] S=SUM[26]
+ VDD=VDD VSS=VSS
XU1_25 ad01d0 $PINS A=copt_net_1600 B=B[25] CI=carry[25] CO=carry[26] S=SUM[25]
+ VDD=VDD VSS=VSS
XU1_24 ad01d0 $PINS A=copt_net_1573 B=B[24] CI=carry[24] CO=carry[25] S=SUM[24]
+ VDD=VDD VSS=VSS
XU1_23 ad01d0 $PINS A=copt_net_1467 B=B[23] CI=carry[23] CO=carry[24] S=SUM[23]
+ VDD=VDD VSS=VSS
XU1_22 ad01d0 $PINS A=copt_net_1603 B=B[22] CI=carry[22] CO=carry[23] S=SUM[22]
+ VDD=VDD VSS=VSS
XU1_21 ad01d0 $PINS A=copt_net_1502 B=B[21] CI=carry[21] CO=carry[22] S=SUM[21]
+ VDD=VDD VSS=VSS
XU1_20 ad01d0 $PINS A=copt_net_1612 B=B[20] CI=carry[20] CO=carry[21] S=SUM[20]
+ VDD=VDD VSS=VSS
XU1_19 ad01d0 $PINS A=copt_net_1498 B=B[19] CI=carry[19] CO=carry[20] S=SUM[19]
+ VDD=VDD VSS=VSS
XU1_18 ad01d0 $PINS A=copt_net_2008 B=B[18] CI=carry[18] CO=carry[19] S=SUM[18]
+ VDD=VDD VSS=VSS
XU1_17 ad01d0 $PINS A=copt_net_1928 B=B[17] CI=carry[17] CO=carry[18] S=SUM[17]
+ VDD=VDD VSS=VSS
XU1_16 ad01d0 $PINS A=copt_net_2009 B=B[16] CI=carry[16] CO=carry[17] S=SUM[16]
+ VDD=VDD VSS=VSS
XU1_15 ad01d0 $PINS A=copt_net_1881 B=B[15] CI=carry[15] CO=carry[16] S=SUM[15]
+ VDD=VDD VSS=VSS
XU1_14 ad01d0 $PINS A=copt_net_2019 B=B[14] CI=carry[14] CO=carry[15] S=SUM[14]
+ VDD=VDD VSS=VSS
XU1_13 ad01d0 $PINS A=copt_net_1491 B=B[13] CI=carry[13] CO=carry[14] S=SUM[13]
+ VDD=VDD VSS=VSS
XU1_12 ad01d1 $PINS A=copt_net_1691 B=B[12] CI=carry[12] CO=carry[13] S=SUM[12]
+ VDD=VDD VSS=VSS
XU1_11 ad01d0 $PINS A=copt_net_1514 B=B[11] CI=carry[11] CO=carry[12] S=SUM[11]
+ VDD=VDD VSS=VSS
XU1_10 ad01d1 $PINS A=copt_net_1605 B=B[10] CI=carry[10] CO=carry[11] S=SUM[10]
+ VDD=VDD VSS=VSS
XU1_9 ad01d1 $PINS A=copt_net_1609 B=B[9] CI=carry[9] CO=carry[10] S=SUM[9]
+ VDD=VDD VSS=VSS
XU1_8 ad01d0 $PINS A=copt_net_1629 B=B[8] CI=carry[8] CO=carry[9] S=SUM[8]
+ VDD=VDD VSS=VSS
XU1_7 ad01d0 $PINS A=copt_net_2141 B=B[7] CI=carry[7] CO=carry[8] S=SUM[7]
+ VDD=VDD VSS=VSS
XU1_6 ad01d0 $PINS A=copt_net_1701 B=B[6] CI=carry[6] CO=carry[7] S=SUM[6]
+ VDD=VDD VSS=VSS
XU1_5 ad01d0 $PINS A=copt_net_1619 B=B[5] CI=carry[5] CO=carry[6] S=SUM[5]
+ VDD=VDD VSS=VSS
XU1_4 ad01d0 $PINS A=copt_net_1526 B=B[4] CI=carry[4] CO=carry[5] S=SUM[4]
+ VDD=VDD VSS=VSS
XU1_3 ad01d0 $PINS A=copt_net_1718 B=B[3] CI=carry[3] CO=carry[4] S=SUM[3]
+ VDD=VDD VSS=VSS
XU1_2 ad01d0 $PINS A=copt_net_1530 B=B[2] CI=carry[2] CO=carry[3] S=SUM[2]
+ VDD=VDD VSS=VSS
XU1_1 ad01d0 $PINS A=copt_net_1954 B=B[1] CI=n1 CO=carry[2] S=SUM[1] VDD=VDD
+ VSS=VSS
XU1 an02d1 $PINS A1=B[0] A2=A[0] Z=n1 VDD=VDD VSS=VSS
XU2 xr02d1 $PINS A1=A[0] A2=B[0] Z=SUM[0] VDD=VDD VSS=VSS
Xcopt_h_inst_4299 dl01d1 $PINS I=A[23] Z=copt_net_1467 VDD=VDD VSS=VSS
Xcopt_h_inst_4323 dl01d1 $PINS I=A[13] Z=copt_net_1491 VDD=VDD VSS=VSS
Xcopt_h_inst_4330 dl01d1 $PINS I=A[19] Z=copt_net_1498 VDD=VDD VSS=VSS
Xcopt_h_inst_4334 dl01d1 $PINS I=A[21] Z=copt_net_1502 VDD=VDD VSS=VSS
Xcopt_h_inst_4346 dl01d1 $PINS I=A[11] Z=copt_net_1514 VDD=VDD VSS=VSS
Xcopt_h_inst_4350 dl01d1 $PINS I=A[28] Z=copt_net_1518 VDD=VDD VSS=VSS
Xcopt_h_inst_4358 dl01d1 $PINS I=A[4] Z=copt_net_1526 VDD=VDD VSS=VSS
Xcopt_h_inst_4362 dl01d1 $PINS I=A[2] Z=copt_net_1530 VDD=VDD VSS=VSS
Xcopt_h_inst_4405 dl01d1 $PINS I=A[24] Z=copt_net_1573 VDD=VDD VSS=VSS
Xcopt_h_inst_4432 dl01d1 $PINS I=A[25] Z=copt_net_1600 VDD=VDD VSS=VSS
Xcopt_h_inst_4435 dl01d1 $PINS I=A[22] Z=copt_net_1603 VDD=VDD VSS=VSS
Xcopt_h_inst_4437 dl01d1 $PINS I=A[10] Z=copt_net_1605 VDD=VDD VSS=VSS
Xcopt_h_inst_4441 dl01d1 $PINS I=A[9] Z=copt_net_1609 VDD=VDD VSS=VSS
Xcopt_h_inst_4444 dl01d1 $PINS I=A[20] Z=copt_net_1612 VDD=VDD VSS=VSS
Xcopt_h_inst_4451 dl01d1 $PINS I=A[5] Z=copt_net_1619 VDD=VDD VSS=VSS
Xcopt_h_inst_4461 dl01d1 $PINS I=A[8] Z=copt_net_1629 VDD=VDD VSS=VSS
Xcopt_h_inst_4463 dl01d1 $PINS I=A[29] Z=copt_net_1631 VDD=VDD VSS=VSS
Xcopt_h_inst_4523 dl01d1 $PINS I=A[12] Z=copt_net_1691 VDD=VDD VSS=VSS
Xcopt_h_inst_4533 dl01d1 $PINS I=A[6] Z=copt_net_1701 VDD=VDD VSS=VSS
Xcopt_h_inst_4550 dl01d1 $PINS I=A[3] Z=copt_net_1718 VDD=VDD VSS=VSS
Xcopt_h_inst_4713 dl01d1 $PINS I=A[15] Z=copt_net_1881 VDD=VDD VSS=VSS
Xcopt_h_inst_4760 dl01d1 $PINS I=A[17] Z=copt_net_1928 VDD=VDD VSS=VSS
Xcopt_h_inst_4775 dl01d1 $PINS I=A[26] Z=copt_net_1943 VDD=VDD VSS=VSS
Xcopt_h_inst_4787 dl01d1 $PINS I=A[1] Z=copt_net_1954 VDD=VDD VSS=VSS
Xcopt_h_inst_4841 dl01d1 $PINS I=A[18] Z=copt_net_2008 VDD=VDD VSS=VSS
Xcopt_h_inst_4842 dl01d1 $PINS I=A[16] Z=copt_net_2009 VDD=VDD VSS=VSS
Xcopt_h_inst_4852 dl01d1 $PINS I=A[14] Z=copt_net_2019 VDD=VDD VSS=VSS
Xcopt_h_inst_4861 dl01d1 $PINS I=A[30] Z=copt_net_2028 VDD=VDD VSS=VSS
Xcopt_h_inst_4887 dl01d1 $PINS I=A[27] Z=copt_net_2054 VDD=VDD VSS=VSS
Xcopt_h_inst_4920 buffd1 $PINS I=A[31] Z=copt_net_2087 VDD=VDD VSS=VSS
Xcopt_h_inst_4974 buffd1 $PINS I=A[7] Z=copt_net_2141 VDD=VDD VSS=VSS
.ENDS

.SUBCKT unpu_pe_5 clk rst_n array_en weight_load mode_unsigned weight_in[7]
+ weight_in[6] weight_in[5] weight_in[4] weight_in[3] weight_in[2] weight_in[1]
+ weight_in[0] act_in[7] act_in[6] act_in[5] act_in[4] act_in[3] act_in[2]
+ act_in[1] act_in[0] psum_in[31] psum_in[30] psum_in[29] psum_in[28]
+ psum_in[27] psum_in[26] psum_in[25] psum_in[24] psum_in[23] psum_in[22]
+ psum_in[21] psum_in[20] psum_in[19] psum_in[18] psum_in[17] psum_in[16]
+ psum_in[15] psum_in[14] psum_in[13] psum_in[12] psum_in[11] psum_in[10]
+ psum_in[9] psum_in[8] psum_in[7] psum_in[6] psum_in[5] psum_in[4] psum_in[3]
+ psum_in[2] psum_in[1] psum_in[0] act_out[7] act_out[6] act_out[5] act_out[4]
+ act_out[3] act_out[2] act_out[1] act_out[0] psum_out[31] psum_out[30]
+ psum_out[29] psum_out[28] psum_out[27] psum_out[26] psum_out[25] psum_out[24]
+ psum_out[23] psum_out[22] psum_out[21] psum_out[20] psum_out[19] psum_out[18]
+ psum_out[17] psum_out[16] psum_out[15] psum_out[14] psum_out[13] psum_out[12]
+ psum_out[11] psum_out[10] psum_out[9] psum_out[8] psum_out[7] psum_out[6]
+ psum_out[5] psum_out[4] psum_out[3] psum_out[2] psum_out[1] psum_out[0] VDD
+ VSS ZCTSNET_9 HFSNET_3 HFSNET_4 HFSNET_5 HFSNET_6 HFSNET_7 ZCTSNET_1
+ ZCTSNET_4
XU2 aor22d1 $PINS A1=N_uc_30 A2=HFSNET_3 B1=mode_unsigned B2=N_uc_14
+ Z=product[9] VDD=VDD VSS=VSS
XU3 aor22d1 $PINS A1=N_uc_29 A2=HFSNET_3 B1=N_uc_13 B2=mode_unsigned
+ Z=product[8] VDD=VDD VSS=VSS
XU5 aor22d1 $PINS A1=N_uc_28 A2=HFSNET_3 B1=N_uc_12 B2=mode_unsigned
+ Z=product[7] VDD=VDD VSS=VSS
XU6 aor22d1 $PINS A1=N_uc_27 A2=HFSNET_3 B1=N_uc_11 B2=mode_unsigned
+ Z=product[6] VDD=VDD VSS=VSS
XU7 aor22d1 $PINS A1=N_uc_26 A2=HFSNET_3 B1=N_uc_10 B2=mode_unsigned
+ Z=product[5] VDD=VDD VSS=VSS
XU8 aor22d1 $PINS A1=N_uc_9 A2=mode_unsigned B1=N_uc_25 B2=HFSNET_3
+ Z=product[4] VDD=VDD VSS=VSS
XU9 aor22d1 $PINS A1=N_uc_8 A2=mode_unsigned B1=N_uc_24 B2=HFSNET_3
+ Z=product[3] VDD=VDD VSS=VSS
XU10 aor22d1 $PINS A1=N_uc_7 A2=mode_unsigned B1=N_uc_23 B2=HFSNET_3
+ Z=product[2] VDD=VDD VSS=VSS
XU11 aor22d1 $PINS A1=N_uc_6 A2=mode_unsigned B1=N_uc_22 B2=HFSNET_3
+ Z=product[1] VDD=VDD VSS=VSS
XU12 oaim21d1 $PINS B1=N_uc_20 B2=mode_unsigned A=n13 ZN=product[15] VDD=VDD
+ VSS=VSS
XU13 aor22d1 $PINS A1=N_uc_35 A2=HFSNET_3 B1=N_uc_19 B2=mode_unsigned
+ Z=product[14] VDD=VDD VSS=VSS
XU14 aor22d1 $PINS A1=N_uc_34 A2=HFSNET_3 B1=N_uc_18 B2=mode_unsigned
+ Z=product[13] VDD=VDD VSS=VSS
XU15 aor22d1 $PINS A1=N_uc_33 A2=HFSNET_3 B1=N_uc_17 B2=mode_unsigned
+ Z=product[12] VDD=VDD VSS=VSS
XU16 aor22d1 $PINS A1=N_uc_32 A2=HFSNET_3 B1=N_uc_16 B2=mode_unsigned
+ Z=product[11] VDD=VDD VSS=VSS
XU17 aor22d1 $PINS A1=N_uc_31 A2=HFSNET_3 B1=N_uc_15 B2=mode_unsigned
+ Z=product[10] VDD=VDD VSS=VSS
XU18 aor22d1 $PINS A1=N_uc_5 A2=mode_unsigned B1=N_uc_21 B2=HFSNET_3
+ Z=product[0] VDD=VDD VSS=VSS
Xadd_42 unpu_pe_5_DW01_add_0_DW01_add_6 $PINS A[31]=psum_in[31]
+ A[30]=psum_in[30] A[29]=psum_in[29] A[28]=psum_in[28] A[27]=psum_in[27]
+ A[26]=psum_in[26] A[25]=psum_in[25] A[24]=psum_in[24] A[23]=psum_in[23]
+ A[22]=psum_in[22] A[21]=psum_in[21] A[20]=psum_in[20] A[19]=psum_in[19]
+ A[18]=psum_in[18] A[17]=psum_in[17] A[16]=psum_in[16] A[15]=psum_in[15]
+ A[14]=psum_in[14] A[13]=psum_in[13] A[12]=psum_in[12] A[11]=psum_in[11]
+ A[10]=psum_in[10] A[9]=psum_in[9] A[8]=psum_in[8] A[7]=psum_in[7]
+ A[6]=psum_in[6] A[5]=psum_in[5] A[4]=psum_in[4] A[3]=psum_in[3] A[2]=psum_in[2]
+ A[1]=psum_in[1] A[0]=psum_in[0] B[31]=n2 B[30]=n2 B[29]=n2 B[28]=n2 B[27]=n2
+ B[26]=n2 B[25]=n2 B[24]=n2 B[23]=n2 B[22]=n2 B[21]=n2 B[20]=n2 B[19]=n2
+ B[18]=n2 B[17]=n2 B[16]=n2 B[15]=product[15] B[14]=product[14]
+ B[13]=product[13] B[12]=product[12] B[11]=product[11] B[10]=product[10]
+ B[9]=product[9] B[8]=product[8] B[7]=product[7] B[6]=product[6] B[5]=product[5]
+ B[4]=product[4] B[3]=product[3] B[2]=product[2] B[1]=product[1] B[0]=product[0]
+ CI=VSS SUM[31]=N_uc_71 SUM[30]=N_uc_70 SUM[29]=N_uc_69 SUM[28]=N_uc_68
+ SUM[27]=N_uc_67 SUM[26]=N_uc_66 SUM[25]=N_uc_65 SUM[24]=N_uc_64 SUM[23]=N_uc_63
+ SUM[22]=N_uc_62 SUM[21]=N_uc_61 SUM[20]=N_uc_60 SUM[19]=N_uc_59 SUM[18]=N_uc_58
+ SUM[17]=N_uc_57 SUM[16]=N_uc_56 SUM[15]=N_uc_55 SUM[14]=N_uc_54 SUM[13]=N_uc_53
+ SUM[12]=N_uc_52 SUM[11]=N_uc_51 SUM[10]=N_uc_50 SUM[9]=N_uc_49 SUM[8]=N_uc_48
+ SUM[7]=N_uc_47 SUM[6]=N_uc_46 SUM[5]=N_uc_45 SUM[4]=N_uc_44 SUM[3]=N_uc_43
+ SUM[2]=N_uc_42 SUM[1]=N_uc_41 SUM[0]=N_uc_40 VDD=VDD VSS=VSS
Xmult_28 unpu_pe_5_DW_mult_uns_0_DW_mult_uns_5 $PINS a[7]=weight_reg[7]
+ a[6]=weight_reg[6] a[5]=weight_reg[5] a[4]=weight_reg[4] a[3]=weight_reg[3]
+ a[2]=weight_reg[2] a[1]=weight_reg[1] a[0]=gre_a_INV_2575_3 b[7]=act_in[7]
+ b[6]=act_in[6] b[5]=act_in[5] b[4]=act_in[4] b[3]=act_in[3] b[2]=act_in[2]
+ b[1]=act_in[1] b[0]=act_in[0] product[15]=N_uc_20 product[14]=N_uc_19
+ product[13]=N_uc_18 product[12]=N_uc_17 product[11]=N_uc_16 product[10]=N_uc_15
+ product[9]=N_uc_14 product[8]=N_uc_13 product[7]=N_uc_12 product[6]=N_uc_11
+ product[5]=N_uc_10 product[4]=N_uc_9 product[3]=N_uc_8 product[2]=N_uc_7
+ product[1]=N_uc_6 product[0]=N_uc_5 VDD=VDD VSS=VSS
Xmult_30 unpu_pe_5_DW_mult_tc_0_DW_mult_tc_4 $PINS a[7]=weight_reg[7]
+ a[6]=weight_reg[6] a[5]=weight_reg[5] a[4]=weight_reg[4] a[3]=weight_reg[3]
+ a[2]=weight_reg[2] a[1]=weight_reg[1] a[0]=gre_a_INV_2575_3 b[7]=act_in[7]
+ b[6]=act_in[6] b[5]=act_in[5] b[4]=act_in[4] b[3]=act_in[3] b[2]=act_in[2]
+ b[1]=act_in[1] b[0]=act_in[0] product[15]=N_uc_36 product[14]=N_uc_35
+ product[13]=N_uc_34 product[12]=N_uc_33 product[11]=N_uc_32 product[10]=N_uc_31
+ product[9]=N_uc_30 product[8]=N_uc_29 product[7]=N_uc_28 product[6]=N_uc_27
+ product[5]=N_uc_26 product[4]=N_uc_25 product[3]=N_uc_24 product[2]=N_uc_23
+ product[1]=N_uc_22 product[0]=N_uc_21 VDD=VDD VSS=VSS
Xact_out_reg_3_ decrq1 $PINS D=copt_net_1960 ENN=HFSNET_4 CP=ZCTSNET_4
+ CDN=HFSNET_7 Q=act_out[3] VDD=VDD VSS=VSS
Xact_out_reg_2_ decrq1 $PINS D=copt_net_2109 ENN=HFSNET_4 CP=clk CDN=HFSNET_7
+ Q=act_out[2] VDD=VDD VSS=VSS
Xact_out_reg_1_ decrq1 $PINS D=copt_net_2105 ENN=HFSNET_4 CP=clk CDN=HFSNET_7
+ Q=act_out[1] VDD=VDD VSS=VSS
Xact_out_reg_7_ decrq1 $PINS D=ropt_net_3210 ENN=HFSNET_4 CP=ZCTSNET_1
+ CDN=HFSNET_7 Q=act_out[7] VDD=VDD VSS=VSS
Xact_out_reg_6_ decrq1 $PINS D=act_in[6] ENN=HFSNET_4 CP=ZCTSNET_4 CDN=HFSNET_7
+ Q=act_out[6] VDD=VDD VSS=VSS
Xact_out_reg_5_ decrq1 $PINS D=copt_net_2137 ENN=HFSNET_4 CP=ZCTSNET_1
+ CDN=HFSNET_7 Q=act_out[5] VDD=VDD VSS=VSS
Xact_out_reg_4_ decrq1 $PINS D=copt_net_2133 ENN=HFSNET_4 CP=clk CDN=HFSNET_7
+ Q=act_out[4] VDD=VDD VSS=VSS
Xact_out_reg_0_ decrq1 $PINS D=copt_net_2805 ENN=HFSNET_4 CP=ZCTSNET_1
+ CDN=HFSNET_7 Q=act_out[0] VDD=VDD VSS=VSS
Xpsum_out_reg_7_ decrq1 $PINS D=N_uc_47 ENN=HFSNET_5 CP=ZCTSNET_4 CDN=HFSNET_6
+ Q=psum_out[7] VDD=VDD VSS=VSS
Xpsum_out_reg_6_ decrq1 $PINS D=N_uc_46 ENN=HFSNET_5 CP=ZCTSNET_3 CDN=HFSNET_6
+ Q=psum_out[6] VDD=VDD VSS=VSS
Xpsum_out_reg_5_ decrq1 $PINS D=N_uc_45 ENN=HFSNET_5 CP=ZCTSNET_3 CDN=HFSNET_6
+ Q=psum_out[5] VDD=VDD VSS=VSS
Xpsum_out_reg_4_ decrq1 $PINS D=N_uc_44 ENN=HFSNET_5 CP=ZCTSNET_3 CDN=HFSNET_6
+ Q=psum_out[4] VDD=VDD VSS=VSS
Xpsum_out_reg_3_ decrq1 $PINS D=N_uc_43 ENN=HFSNET_5 CP=ZCTSNET_9 CDN=HFSNET_6
+ Q=psum_out[3] VDD=VDD VSS=VSS
Xpsum_out_reg_2_ decrq1 $PINS D=N_uc_42 ENN=HFSNET_5 CP=ZCTSNET_9 CDN=HFSNET_6
+ Q=psum_out[2] VDD=VDD VSS=VSS
Xpsum_out_reg_1_ decrq1 $PINS D=copt_net_2627 ENN=HFSNET_5 CP=ZCTSNET_9
+ CDN=HFSNET_6 Q=psum_out[1] VDD=VDD VSS=VSS
Xpsum_out_reg_0_ decrq1 $PINS D=copt_net_1208 ENN=HFSNET_5 CP=ZCTSNET_9
+ CDN=HFSNET_6 Q=psum_out[0] VDD=VDD VSS=VSS
Xpsum_out_reg_8_ decrq1 $PINS D=N_uc_48 ENN=HFSNET_5 CP=ZCTSNET_3 CDN=HFSNET_6
+ Q=psum_out[8] VDD=VDD VSS=VSS
Xpsum_out_reg_9_ decrq1 $PINS D=N_uc_49 ENN=HFSNET_5 CP=ZCTSNET_3 CDN=HFSNET_6
+ Q=psum_out[9] VDD=VDD VSS=VSS
Xpsum_out_reg_10_ decrq1 $PINS D=N_uc_50 ENN=HFSNET_5 CP=ZCTSNET_3 CDN=HFSNET_7
+ Q=psum_out[10] VDD=VDD VSS=VSS
Xweight_reg_reg_7_ decrq1 $PINS D=weight_in[7] ENN=n12 CP=ZCTSNET_9
+ CDN=HFSNET_6 Q=weight_reg[7] VDD=VDD VSS=VSS
Xweight_reg_reg_6_ decrq1 $PINS D=weight_in[6] ENN=n12 CP=ZCTSNET_9 CDN=rst_n
+ Q=weight_reg[6] VDD=VDD VSS=VSS
Xweight_reg_reg_5_ decrq1 $PINS D=weight_in[5] ENN=n12 CP=ZCTSNET_9 CDN=rst_n
+ Q=weight_reg[5] VDD=VDD VSS=VSS
Xweight_reg_reg_4_ decrq1 $PINS D=weight_in[4] ENN=n12 CP=ZCTSNET_9 CDN=rst_n
+ Q=weight_reg[4] VDD=VDD VSS=VSS
Xweight_reg_reg_3_ decrq1 $PINS D=weight_in[3] ENN=n12 CP=ZCTSNET_9 CDN=rst_n
+ Q=weight_reg[3] VDD=VDD VSS=VSS
Xweight_reg_reg_2_ decrq1 $PINS D=weight_in[2] ENN=n12 CP=ZCTSNET_9 CDN=rst_n
+ Q=weight_reg[2] VDD=VDD VSS=VSS
Xweight_reg_reg_1_ decrq1 $PINS D=weight_in[1] ENN=n12 CP=ZCTSNET_9 CDN=rst_n
+ Q=weight_reg[1] VDD=VDD VSS=VSS
Xweight_reg_reg_0_ decrq1 $PINS D=weight_in[0] ENN=n12 CP=ZCTSNET_9
+ CDN=HFSNET_7 Q=weight_reg[0] VDD=VDD VSS=VSS
Xpsum_out_reg_11_ decrq1 $PINS D=N_uc_51 ENN=HFSNET_4 CP=ZCTSNET_1 CDN=HFSNET_7
+ Q=psum_out[11] VDD=VDD VSS=VSS
Xpsum_out_reg_12_ decrq1 $PINS D=N_uc_52 ENN=HFSNET_4 CP=ZCTSNET_1 CDN=HFSNET_7
+ Q=psum_out[12] VDD=VDD VSS=VSS
Xpsum_out_reg_13_ decrq1 $PINS D=N_uc_53 ENN=HFSNET_4 CP=ZCTSNET_1 CDN=HFSNET_7
+ Q=psum_out[13] VDD=VDD VSS=VSS
Xpsum_out_reg_14_ decrq1 $PINS D=N_uc_54 ENN=HFSNET_4 CP=ZCTSNET_4 CDN=HFSNET_7
+ Q=psum_out[14] VDD=VDD VSS=VSS
Xpsum_out_reg_15_ decrq1 $PINS D=N_uc_55 ENN=HFSNET_4 CP=ZCTSNET_4 CDN=HFSNET_7
+ Q=psum_out[15] VDD=VDD VSS=VSS
Xpsum_out_reg_16_ decrq1 $PINS D=N_uc_56 ENN=HFSNET_4 CP=ZCTSNET_4 CDN=HFSNET_7
+ Q=psum_out[16] VDD=VDD VSS=VSS
Xpsum_out_reg_17_ decrq1 $PINS D=N_uc_57 ENN=HFSNET_4 CP=ZCTSNET_4 CDN=HFSNET_7
+ Q=psum_out[17] VDD=VDD VSS=VSS
Xpsum_out_reg_18_ decrq1 $PINS D=N_uc_58 ENN=HFSNET_5 CP=ZCTSNET_4 CDN=HFSNET_7
+ Q=psum_out[18] VDD=VDD VSS=VSS
Xpsum_out_reg_19_ decrq1 $PINS D=N_uc_59 ENN=HFSNET_5 CP=ZCTSNET_9 CDN=HFSNET_6
+ Q=psum_out[19] VDD=VDD VSS=VSS
Xpsum_out_reg_20_ decrq1 $PINS D=N_uc_60 ENN=HFSNET_5 CP=ZCTSNET_9 CDN=HFSNET_6
+ Q=psum_out[20] VDD=VDD VSS=VSS
Xpsum_out_reg_21_ decrq1 $PINS D=N_uc_61 ENN=HFSNET_5 CP=ZCTSNET_9 CDN=HFSNET_7
+ Q=psum_out[21] VDD=VDD VSS=VSS
Xpsum_out_reg_22_ decrq1 $PINS D=N_uc_62 ENN=HFSNET_5 CP=ZCTSNET_9 CDN=HFSNET_6
+ Q=psum_out[22] VDD=VDD VSS=VSS
Xpsum_out_reg_23_ decrq1 $PINS D=N_uc_63 ENN=HFSNET_5 CP=ZCTSNET_3 CDN=HFSNET_6
+ Q=psum_out[23] VDD=VDD VSS=VSS
Xpsum_out_reg_24_ decrq1 $PINS D=N_uc_64 ENN=HFSNET_5 CP=ZCTSNET_9 CDN=HFSNET_6
+ Q=psum_out[24] VDD=VDD VSS=VSS
Xpsum_out_reg_25_ decrq1 $PINS D=N_uc_65 ENN=HFSNET_5 CP=ZCTSNET_3 CDN=HFSNET_7
+ Q=psum_out[25] VDD=VDD VSS=VSS
Xpsum_out_reg_26_ decrq1 $PINS D=N_uc_66 ENN=HFSNET_4 CP=ZCTSNET_4 CDN=HFSNET_7
+ Q=psum_out[26] VDD=VDD VSS=VSS
Xpsum_out_reg_27_ decrq1 $PINS D=N_uc_67 ENN=HFSNET_4 CP=ZCTSNET_4 CDN=HFSNET_7
+ Q=psum_out[27] VDD=VDD VSS=VSS
Xpsum_out_reg_28_ decrq1 $PINS D=N_uc_68 ENN=HFSNET_5 CP=ZCTSNET_3 CDN=HFSNET_6
+ Q=psum_out[28] VDD=VDD VSS=VSS
Xpsum_out_reg_29_ decrq1 $PINS D=N_uc_69 ENN=HFSNET_5 CP=ZCTSNET_3 CDN=HFSNET_6
+ Q=psum_out[29] VDD=VDD VSS=VSS
Xpsum_out_reg_30_ decrq1 $PINS D=N_uc_70 ENN=HFSNET_4 CP=ZCTSNET_4 CDN=HFSNET_7
+ Q=psum_out[30] VDD=VDD VSS=VSS
Xpsum_out_reg_31_ decrq1 $PINS D=N_uc_71 ENN=HFSNET_4 CP=ZCTSNET_4 CDN=HFSNET_7
+ Q=psum_out[31] VDD=VDD VSS=VSS
XU19 inv0d2 $PINS I=n13 ZN=n2 VDD=VDD VSS=VSS
XZCTSBUF_88487_2529 buffd3 $PINS I=ZCTSNET_4 Z=ZCTSNET_3 VDD=VDD VSS=VSS
Xcopt_h_inst_4040 dl01d1 $PINS I=N_uc_40 Z=copt_net_1208 VDD=VDD VSS=VSS
XU22 nd02d1 $PINS A1=weight_load A2=array_en ZN=n12 VDD=VDD VSS=VSS
Xcopt_h_inst_4793 dl01d1 $PINS I=act_in[3] Z=copt_net_1960 VDD=VDD VSS=VSS
Xcopt_h_inst_4890 buffd1 $PINS I=act_in[7] Z=copt_net_2057 VDD=VDD VSS=VSS
Xcopt_h_inst_4938 buffd1 $PINS I=act_in[1] Z=copt_net_2105 VDD=VDD VSS=VSS
Xcopt_h_inst_4942 buffd1 $PINS I=act_in[2] Z=copt_net_2109 VDD=VDD VSS=VSS
XU27 nd02d1 $PINS A1=N_uc_36 A2=HFSNET_3 ZN=n13 VDD=VDD VSS=VSS
Xcopt_h_inst_4966 buffd1 $PINS I=act_in[4] Z=copt_net_2133 VDD=VDD VSS=VSS
Xcopt_h_inst_4970 buffd1 $PINS I=act_in[5] Z=copt_net_2137 VDD=VDD VSS=VSS
Xcopt_h_inst_5460 dl01d1 $PINS I=N_uc_41 Z=copt_net_2627 VDD=VDD VSS=VSS
Xcopt_h_inst_5638 buffd1 $PINS I=act_in[0] Z=copt_net_2805 VDD=VDD VSS=VSS
Xgre_a_INV_2575_inst_5810 inv0d1 $PINS I=weight_reg[0] ZN=gre_a_INV_2575_3
+ VDD=VDD VSS=VSS
Xropt_h_inst_5866 buffd1 $PINS I=copt_net_2057 Z=ropt_net_3210 VDD=VDD VSS=VSS
.ENDS

.SUBCKT unpu_pe_6_DW_mult_tc_0_DW_mult_tc_5 a[7] a[6] a[5] a[4] a[3] a[2] a[1]
+ a[0] b[7] b[6] b[5] b[4] b[3] b[2] b[1] b[0] product[15] product[14]
+ product[13] product[12] product[11] product[10] product[9] product[8]
+ product[7] product[6] product[5] product[4] product[3] product[2] product[1]
+ product[0] VDD VSS gre_a_INV_1546_2
XU2 ad01d0 $PINS A=n196 B=n61 CI=n2 CO=n1 S=product[14] VDD=VDD VSS=VSS
XU3 ad01d0 $PINS A=n17 B=n16 CI=n3 CO=n2 S=product[13] VDD=VDD VSS=VSS
XU4 ad01d0 $PINS A=n18 B=n19 CI=n4 CO=n3 S=product[12] VDD=VDD VSS=VSS
XU5 ad01d0 $PINS A=n20 B=n23 CI=n5 CO=n4 S=product[11] VDD=VDD VSS=VSS
XU6 ad01d0 $PINS A=n27 B=n24 CI=n6 CO=n5 S=product[10] VDD=VDD VSS=VSS
XU7 ad01d0 $PINS A=n33 B=n28 CI=n7 CO=n6 S=product[9] VDD=VDD VSS=VSS
XU8 ad01d0 $PINS A=n39 B=n34 CI=n8 CO=n7 S=product[8] VDD=VDD VSS=VSS
XU9 ad01d0 $PINS A=n45 B=n40 CI=n9 CO=n8 S=product[7] VDD=VDD VSS=VSS
XU10 ad01d0 $PINS A=n49 B=n46 CI=n10 CO=n9 S=product[6] VDD=VDD VSS=VSS
XU11 ad01d0 $PINS A=n53 B=n50 CI=n11 CO=n10 S=product[5] VDD=VDD VSS=VSS
XU12 ad01d0 $PINS A=n55 B=n54 CI=n12 CO=n11 S=product[4] VDD=VDD VSS=VSS
XU13 ad01d0 $PINS A=n59 B=n56 CI=n13 CO=n12 S=product[3] VDD=VDD VSS=VSS
XU14 ad01d0 $PINS A=n84 B=n91 CI=n14 CO=n13 S=product[2] VDD=VDD VSS=VSS
XctmTdsLR_1_2957 an02d1 $PINS A1=n58 A2=n75 Z=n51 VDD=VDD VSS=VSS
XU17 ad01d0 $PINS A=n195 B=n62 CI=n69 CO=n17 S=n18 VDD=VDD VSS=VSS
XU18 ad01d0 $PINS A=n63 B=n25 CI=n22 CO=n19 S=n20 VDD=VDD VSS=VSS
XU20 ad01d0 $PINS A=n64 B=n26 CI=n29 CO=n23 S=n24 VDD=VDD VSS=VSS
XU21 ad01d0 $PINS A=n194 B=n70 CI=n77 CO=n25 S=n26 VDD=VDD VSS=VSS
XU22 ad01d0 $PINS A=n32 B=n35 CI=n30 CO=n27 S=n28 VDD=VDD VSS=VSS
XU23 ad01d0 $PINS A=n71 B=n65 CI=n37 CO=n29 S=n30 VDD=VDD VSS=VSS
XU25 ad01d0 $PINS A=n38 B=n41 CI=n36 CO=n33 S=n34 VDD=VDD VSS=VSS
XU26 ad01d0 $PINS A=n72 B=n85 CI=n43 CO=n35 S=n36 VDD=VDD VSS=VSS
XU29 ad01d0 $PINS A=n44 B=n47 CI=n42 CO=n39 S=n40 VDD=VDD VSS=VSS
XU30 ad01d0 $PINS A=n86 B=n73 CI=n79 CO=n41 S=n42 VDD=VDD VSS=VSS
XU32 ad01d0 $PINS A=n74 B=n51 CI=n48 CO=n45 S=n46 VDD=VDD VSS=VSS
XU33 ad01d0 $PINS A=n68 B=n87 CI=n80 CO=n47 S=n48 VDD=VDD VSS=VSS
XU34 ad01d0 $PINS A=n88 B=n81 CI=n52 CO=n49 S=n50 VDD=VDD VSS=VSS
XU36 ad01d0 $PINS A=n76 B=n89 CI=n82 CO=n53 S=n54 VDD=VDD VSS=VSS
XU37 ah01d1 $PINS A=n83 B=n90 CO=n55 S=n56 VDD=VDD VSS=VSS
XU145 oai21d1 $PINS B1=n203 B2=n249 A=n222 ZN=n77 VDD=VDD VSS=VSS
XU146 oai21d1 $PINS B1=n201 B2=n250 A=n232 ZN=n69 VDD=VDD VSS=VSS
XU147 oai21d1 $PINS B1=n199 B2=n251 A=n242 ZN=n61 VDD=VDD VSS=VSS
XU148 inv0d0 $PINS I=n16 ZN=n196 VDD=VDD VSS=VSS
XU149 inv0d0 $PINS I=n223 ZN=n201 VDD=VDD VSS=VSS
XU150 inv0d0 $PINS I=n214 ZN=n203 VDD=VDD VSS=VSS
XU151 inv0d0 $PINS I=n233 ZN=n199 VDD=VDD VSS=VSS
XU152 inv0d0 $PINS I=n32 ZN=n194 VDD=VDD VSS=VSS
XU153 inv0d0 $PINS I=n22 ZN=n195 VDD=VDD VSS=VSS
XU154 nd02d1 $PINS A1=n214 A2=n249 ZN=n216 VDD=VDD VSS=VSS
XU155 xr02d1 $PINS A1=a[2] A2=n204 Z=n214 VDD=VDD VSS=VSS
XU156 inv0d1 $PINS I=a[1] ZN=n204 VDD=VDD VSS=VSS
XU157 nd02d1 $PINS A1=n223 A2=n250 ZN=n225 VDD=VDD VSS=VSS
XU158 xr02d1 $PINS A1=a[4] A2=n202 Z=n223 VDD=VDD VSS=VSS
XU159 inv0d1 $PINS I=a[3] ZN=n202 VDD=VDD VSS=VSS
XU160 nd02d1 $PINS A1=a[1] A2=a[0] ZN=n206 VDD=VDD VSS=VSS
XU162 inv0d0 $PINS I=b[0] ZN=n197 VDD=VDD VSS=VSS
XU163 xr02d1 $PINS A1=a[6] A2=n200 Z=n233 VDD=VDD VSS=VSS
XU164 inv0d1 $PINS I=a[5] ZN=n200 VDD=VDD VSS=VSS
XU165 nd02d1 $PINS A1=n233 A2=n251 ZN=n235 VDD=VDD VSS=VSS
XU167 inv0d0 $PINS I=n1 ZN=product[15] VDD=VDD VSS=VSS
XU168 nr02d0 $PINS A1=a[0] A2=n197 ZN=product[0] VDD=VDD VSS=VSS
XU169 oai22d1 $PINS A1=b[0] A2=n206 B1=n207 B2=a[0] ZN=n92 VDD=VDD VSS=VSS
XU170 oai22d1 $PINS A1=n207 A2=n206 B1=n208 B2=a[0] ZN=n91 VDD=VDD VSS=VSS
XU171 xr02d1 $PINS A1=b[1] A2=n204 Z=n207 VDD=VDD VSS=VSS
XU172 oai22d1 $PINS A1=n208 A2=n206 B1=n209 B2=a[0] ZN=n90 VDD=VDD VSS=VSS
XU173 xr02d1 $PINS A1=b[2] A2=n204 Z=n208 VDD=VDD VSS=VSS
XU174 oai22d1 $PINS A1=n209 A2=n206 B1=n210 B2=a[0] ZN=n89 VDD=VDD VSS=VSS
XU175 xr02d1 $PINS A1=b[3] A2=n204 Z=n209 VDD=VDD VSS=VSS
XU176 oai22d1 $PINS A1=n210 A2=n206 B1=n211 B2=a[0] ZN=n88 VDD=VDD VSS=VSS
XU177 xr02d1 $PINS A1=b[4] A2=n204 Z=n210 VDD=VDD VSS=VSS
XU178 oai22d1 $PINS A1=n211 A2=n206 B1=n212 B2=a[0] ZN=n87 VDD=VDD VSS=VSS
XU179 xr02d1 $PINS A1=b[5] A2=n204 Z=n211 VDD=VDD VSS=VSS
XU180 oai22d1 $PINS A1=n212 A2=n206 B1=n213 B2=a[0] ZN=n86 VDD=VDD VSS=VSS
XU181 xr02d1 $PINS A1=b[6] A2=n204 Z=n212 VDD=VDD VSS=VSS
XU182 aor21d1 $PINS B1=a[0] B2=n206 A=n213 Z=n85 VDD=VDD VSS=VSS
XU183 xr02d1 $PINS A1=b[7] A2=n204 Z=n213 VDD=VDD VSS=VSS
XU184 nr02d0 $PINS A1=n214 A2=n197 ZN=n84 VDD=VDD VSS=VSS
XU185 oai22d1 $PINS A1=n216 A2=n215 B1=n214 B2=n217 ZN=n83 VDD=VDD VSS=VSS
XctmTdsLR_1_2947 an02d1 $PINS A1=n60 A2=n92 Z=n14 VDD=VDD VSS=VSS
XU187 oai22d1 $PINS A1=n217 A2=n216 B1=n214 B2=n218 ZN=n82 VDD=VDD VSS=VSS
XU188 xr02d1 $PINS A1=b[1] A2=n202 Z=n217 VDD=VDD VSS=VSS
XU189 oai22d1 $PINS A1=n218 A2=n216 B1=n214 B2=n219 ZN=n81 VDD=VDD VSS=VSS
XU190 xr02d1 $PINS A1=b[2] A2=n202 Z=n218 VDD=VDD VSS=VSS
XU191 oai22d1 $PINS A1=n219 A2=n216 B1=n214 B2=n220 ZN=n80 VDD=VDD VSS=VSS
XU192 xr02d1 $PINS A1=b[3] A2=n202 Z=n219 VDD=VDD VSS=VSS
XU193 oai22d1 $PINS A1=n220 A2=n216 B1=n214 B2=n221 ZN=n79 VDD=VDD VSS=VSS
XU194 xr02d1 $PINS A1=b[4] A2=n202 Z=n220 VDD=VDD VSS=VSS
XU195 nr02d0 $PINS A1=n223 A2=n197 ZN=n76 VDD=VDD VSS=VSS
XU196 oai22d1 $PINS A1=n225 A2=n224 B1=n223 B2=n226 ZN=n75 VDD=VDD VSS=VSS
XctmTdsLR_2_2948 aoim21d1 $PINS B1=n92 B2=n60 A=n14 ZN=product[1] VDD=VDD
+ VSS=VSS
XU198 oai22d1 $PINS A1=n226 A2=n225 B1=n223 B2=n227 ZN=n74 VDD=VDD VSS=VSS
XU199 xr02d1 $PINS A1=b[1] A2=n200 Z=n226 VDD=VDD VSS=VSS
XU200 oai22d1 $PINS A1=n227 A2=n225 B1=n223 B2=n228 ZN=n73 VDD=VDD VSS=VSS
XU201 xr02d1 $PINS A1=b[2] A2=n200 Z=n227 VDD=VDD VSS=VSS
XU202 oai22d1 $PINS A1=n228 A2=n225 B1=n223 B2=n229 ZN=n72 VDD=VDD VSS=VSS
XU203 xr02d1 $PINS A1=b[3] A2=n200 Z=n228 VDD=VDD VSS=VSS
XU204 oai22d1 $PINS A1=n229 A2=n225 B1=n223 B2=n230 ZN=n71 VDD=VDD VSS=VSS
XU205 xr02d1 $PINS A1=b[4] A2=n200 Z=n229 VDD=VDD VSS=VSS
XU206 oai22d1 $PINS A1=n230 A2=n225 B1=n223 B2=n231 ZN=n70 VDD=VDD VSS=VSS
XU207 xr02d1 $PINS A1=b[5] A2=n200 Z=n230 VDD=VDD VSS=VSS
XU208 nr02d0 $PINS A1=n233 A2=n197 ZN=n68 VDD=VDD VSS=VSS
XU209 oai22d1 $PINS A1=n234 A2=n235 B1=n236 B2=n233 ZN=n67 VDD=VDD VSS=VSS
XctmTdsLR_2_2958 aoim21d1 $PINS B1=n58 B2=n75 A=n51 ZN=n52 VDD=VDD VSS=VSS
XU211 oai22d1 $PINS A1=n237 A2=n235 B1=n233 B2=n238 ZN=n65 VDD=VDD VSS=VSS
XU212 oai22d1 $PINS A1=n238 A2=n235 B1=n233 B2=n239 ZN=n64 VDD=VDD VSS=VSS
XU213 xr02d1 $PINS A1=b[3] A2=gre_a_INV_1546_2 Z=n238 VDD=VDD VSS=VSS
XU214 oai22d1 $PINS A1=n239 A2=n235 B1=n233 B2=n240 ZN=n63 VDD=VDD VSS=VSS
XU215 xr02d1 $PINS A1=b[4] A2=gre_a_INV_1546_2 Z=n239 VDD=VDD VSS=VSS
XU216 oai22d1 $PINS A1=n240 A2=n235 B1=n233 B2=n241 ZN=n62 VDD=VDD VSS=VSS
XU217 xr02d1 $PINS A1=b[5] A2=gre_a_INV_1546_2 Z=n240 VDD=VDD VSS=VSS
XU218 oai21d1 $PINS B1=b[0] B2=n204 A=n206 ZN=n60 VDD=VDD VSS=VSS
XU219 oai21d1 $PINS B1=n202 B2=n216 A=n243 ZN=n59 VDD=VDD VSS=VSS
XU220 nd03d0 $PINS A1=n203 A2=n197 A3=a[3] ZN=n243 VDD=VDD VSS=VSS
XU221 oai21d1 $PINS B1=n200 B2=n225 A=n244 ZN=n58 VDD=VDD VSS=VSS
XU222 nd03d0 $PINS A1=n201 A2=n197 A3=a[5] ZN=n244 VDD=VDD VSS=VSS
XU223 oai21d1 $PINS B1=gre_a_INV_1546_2 B2=n235 A=n245 ZN=n57 VDD=VDD VSS=VSS
XU224 nd03d0 $PINS A1=n199 A2=n197 A3=a[7] ZN=n245 VDD=VDD VSS=VSS
XU225 xn02d1 $PINS A1=n246 A2=n247 ZN=n38 VDD=VDD VSS=VSS
XU226 or02d0 $PINS A1=n247 A2=n246 Z=n37 VDD=VDD VSS=VSS
XU227 oai22d1 $PINS A1=n236 A2=n235 B1=n233 B2=n237 ZN=n246 VDD=VDD VSS=VSS
XU228 xr02d1 $PINS A1=b[2] A2=gre_a_INV_1546_2 Z=n237 VDD=VDD VSS=VSS
XU229 xr02d1 $PINS A1=b[1] A2=gre_a_INV_1546_2 Z=n236 VDD=VDD VSS=VSS
XU230 oai22d1 $PINS A1=n221 A2=n216 B1=n214 B2=n248 ZN=n247 VDD=VDD VSS=VSS
XU231 xr02d1 $PINS A1=b[5] A2=n202 Z=n221 VDD=VDD VSS=VSS
XU232 aoim22d1 $PINS A1=n203 A2=n222 B1=n248 B2=n216 Z=n32 VDD=VDD VSS=VSS
XU233 xr02d1 $PINS A1=a[3] A2=a[2] Z=n249 VDD=VDD VSS=VSS
XU234 xr02d1 $PINS A1=b[6] A2=n202 Z=n248 VDD=VDD VSS=VSS
XU235 xr02d1 $PINS A1=b[7] A2=a[3] Z=n222 VDD=VDD VSS=VSS
XU236 aoim22d1 $PINS A1=n201 A2=n232 B1=n231 B2=n225 Z=n22 VDD=VDD VSS=VSS
XU237 xr02d1 $PINS A1=a[5] A2=a[4] Z=n250 VDD=VDD VSS=VSS
XU238 xr02d1 $PINS A1=b[6] A2=n200 Z=n231 VDD=VDD VSS=VSS
XU239 xr02d1 $PINS A1=b[7] A2=a[5] Z=n232 VDD=VDD VSS=VSS
XU240 aoim22d1 $PINS A1=n199 A2=n242 B1=n241 B2=n235 Z=n16 VDD=VDD VSS=VSS
XU241 xr02d1 $PINS A1=a[7] A2=a[6] Z=n251 VDD=VDD VSS=VSS
XU242 xr02d1 $PINS A1=b[6] A2=gre_a_INV_1546_2 Z=n241 VDD=VDD VSS=VSS
XU243 xr02d1 $PINS A1=b[7] A2=a[7] Z=n242 VDD=VDD VSS=VSS
XctmTdsLR_1_1341 aoim22d1 $PINS A1=n202 A2=b[0] B1=n202 B2=b[0] Z=n215 VDD=VDD
+ VSS=VSS
XctmTdsLR_1_1342 aoim22d1 $PINS A1=n200 A2=b[0] B1=n200 B2=b[0] Z=n224 VDD=VDD
+ VSS=VSS
XctmTdsLR_1_1343 aoim22d1 $PINS A1=gre_a_INV_1546_2 A2=b[0] B1=gre_a_INV_1546_2
+ B2=b[0] Z=n234 VDD=VDD VSS=VSS
XctmTdsLR_1_2959 an02d1 $PINS A1=n57 A2=n67 Z=n43 VDD=VDD VSS=VSS
XctmTdsLR_2_2960 aoim21d1 $PINS B1=n67 B2=n57 A=n43 ZN=n44 VDD=VDD VSS=VSS
.ENDS

.SUBCKT unpu_pe_6_DW_mult_uns_0_DW_mult_uns_6 a[7] a[6] a[5] a[4] a[3] a[2]
+ a[1] a[0] b[7] b[6] b[5] b[4] b[3] b[2] b[1] b[0] product[15] product[14]
+ product[13] product[12] product[11] product[10] product[9] product[8]
+ product[7] product[6] product[5] product[4] product[3] product[2] product[1]
+ product[0] VDD VSS
XU2 ad01d0 $PINS A=n99 B=n15 CI=n2 CO=product[15] S=product[14] VDD=VDD VSS=VSS
XU3 ad01d0 $PINS A=n16 B=n17 CI=n3 CO=n2 S=product[13] VDD=VDD VSS=VSS
XU4 ad01d0 $PINS A=n18 B=n21 CI=n4 CO=n3 S=product[12] VDD=VDD VSS=VSS
XU5 ad01d0 $PINS A=n27 B=n22 CI=n5 CO=n4 S=product[11] VDD=VDD VSS=VSS
XU6 ad01d0 $PINS A=n35 B=n28 CI=n6 CO=n5 S=product[10] VDD=VDD VSS=VSS
XU7 ad01d0 $PINS A=n45 B=n36 CI=n7 CO=n6 S=product[9] VDD=VDD VSS=VSS
XU8 ad01d0 $PINS A=n57 B=n46 CI=n8 CO=n7 S=product[8] VDD=VDD VSS=VSS
XU9 ad01d0 $PINS A=n69 B=n58 CI=n9 CO=n8 S=product[7] VDD=VDD VSS=VSS
XU10 ad01d0 $PINS A=n79 B=n70 CI=n10 CO=n9 S=product[6] VDD=VDD VSS=VSS
XU11 ad01d0 $PINS A=n87 B=n80 CI=n11 CO=n10 S=product[5] VDD=VDD VSS=VSS
XU12 ad01d0 $PINS A=n93 B=n88 CI=n12 CO=n11 S=product[4] VDD=VDD VSS=VSS
XU13 ad01d0 $PINS A=n96 B=n13 CI=n94 CO=n12 S=product[3] VDD=VDD VSS=VSS
XU14 ad01d0 $PINS A=n146 B=n14 CI=n98 CO=n13 S=product[2] VDD=VDD VSS=VSS
XU15 ah01d1 $PINS A=n161 B=n154 CO=n14 S=product[1] VDD=VDD VSS=VSS
XU16 ad01d0 $PINS A=n107 B=n100 CI=n19 CO=n15 S=n16 VDD=VDD VSS=VSS
XU17 ad01d0 $PINS A=n25 B=n20 CI=n23 CO=n17 S=n18 VDD=VDD VSS=VSS
XU18 ad01d0 $PINS A=n115 B=n101 CI=n108 CO=n19 S=n20 VDD=VDD VSS=VSS
XU19 ad01d0 $PINS A=n31 B=n24 CI=n29 CO=n21 S=n22 VDD=VDD VSS=VSS
XU20 ad01d0 $PINS A=n116 B=n33 CI=n26 CO=n23 S=n24 VDD=VDD VSS=VSS
XU21 ad01d0 $PINS A=n123 B=n102 CI=n109 CO=n25 S=n26 VDD=VDD VSS=VSS
XU22 ad01d0 $PINS A=n32 B=n37 CI=n30 CO=n27 S=n28 VDD=VDD VSS=VSS
XU23 ad01d0 $PINS A=n41 B=n34 CI=n39 CO=n29 S=n30 VDD=VDD VSS=VSS
XU24 ad01d0 $PINS A=n124 B=n117 CI=n43 CO=n31 S=n32 VDD=VDD VSS=VSS
XU25 ad01d0 $PINS A=n131 B=n103 CI=n110 CO=n33 S=n34 VDD=VDD VSS=VSS
XU26 ad01d0 $PINS A=n40 B=n47 CI=n38 CO=n35 S=n36 VDD=VDD VSS=VSS
XU27 ad01d0 $PINS A=n44 B=n51 CI=n49 CO=n37 S=n38 VDD=VDD VSS=VSS
XU28 ad01d0 $PINS A=n55 B=n53 CI=n42 CO=n39 S=n40 VDD=VDD VSS=VSS
XU29 ad01d0 $PINS A=n118 B=n125 CI=n132 CO=n41 S=n42 VDD=VDD VSS=VSS
XU30 ad01d0 $PINS A=n139 B=n104 CI=n111 CO=n43 S=n44 VDD=VDD VSS=VSS
XU31 ad01d0 $PINS A=n50 B=n59 CI=n48 CO=n45 S=n46 VDD=VDD VSS=VSS
XU32 ad01d0 $PINS A=n54 B=n52 CI=n61 CO=n47 S=n48 VDD=VDD VSS=VSS
XU33 ad01d0 $PINS A=n56 B=n65 CI=n63 CO=n49 S=n50 VDD=VDD VSS=VSS
XU34 ad01d0 $PINS A=n140 B=n133 CI=n67 CO=n51 S=n52 VDD=VDD VSS=VSS
XU35 ad01d0 $PINS A=n126 B=n119 CI=n147 CO=n53 S=n54 VDD=VDD VSS=VSS
XU36 ah01d1 $PINS A=n105 B=n112 CO=n55 S=n56 VDD=VDD VSS=VSS
XU37 ad01d0 $PINS A=n71 B=n62 CI=n60 CO=n57 S=n58 VDD=VDD VSS=VSS
XU38 ad01d0 $PINS A=n64 B=n66 CI=n73 CO=n59 S=n60 VDD=VDD VSS=VSS
XU39 ad01d0 $PINS A=n77 B=n68 CI=n75 CO=n61 S=n62 VDD=VDD VSS=VSS
XU40 ad01d0 $PINS A=n141 B=n127 CI=n134 CO=n63 S=n64 VDD=VDD VSS=VSS
XU41 ad01d0 $PINS A=n155 B=n120 CI=n148 CO=n65 S=n66 VDD=VDD VSS=VSS
XU42 ah01d1 $PINS A=n106 B=n113 CO=n67 S=n68 VDD=VDD VSS=VSS
XU43 ad01d0 $PINS A=n81 B=n74 CI=n72 CO=n69 S=n70 VDD=VDD VSS=VSS
XU44 ad01d0 $PINS A=n78 B=n83 CI=n76 CO=n71 S=n72 VDD=VDD VSS=VSS
XU45 ad01d0 $PINS A=n142 B=n135 CI=n85 CO=n73 S=n74 VDD=VDD VSS=VSS
XU46 ad01d0 $PINS A=n156 B=n128 CI=n149 CO=n75 S=n76 VDD=VDD VSS=VSS
XU47 ah01d1 $PINS A=n114 B=n121 CO=n77 S=n78 VDD=VDD VSS=VSS
XU48 ad01d0 $PINS A=n89 B=n84 CI=n82 CO=n79 S=n80 VDD=VDD VSS=VSS
XU49 ad01d0 $PINS A=n150 B=n91 CI=n86 CO=n81 S=n82 VDD=VDD VSS=VSS
XU50 ad01d0 $PINS A=n157 B=n136 CI=n143 CO=n83 S=n84 VDD=VDD VSS=VSS
XU51 ah01d1 $PINS A=n122 B=n129 CO=n85 S=n86 VDD=VDD VSS=VSS
XU52 ad01d0 $PINS A=n95 B=n92 CI=n90 CO=n87 S=n88 VDD=VDD VSS=VSS
XU53 ad01d0 $PINS A=n158 B=n144 CI=n151 CO=n89 S=n90 VDD=VDD VSS=VSS
XU54 ah01d1 $PINS A=n130 B=n137 CO=n91 S=n92 VDD=VDD VSS=VSS
XU55 ad01d0 $PINS A=n159 B=n152 CI=n97 CO=n93 S=n94 VDD=VDD VSS=VSS
XU56 ah01d1 $PINS A=n138 B=n145 CO=n95 S=n96 VDD=VDD VSS=VSS
XU57 ah01d1 $PINS A=n153 B=n160 CO=n97 S=n98 VDD=VDD VSS=VSS
XU140 inv0d0 $PINS I=b[4] ZN=n217 VDD=VDD VSS=VSS
XU141 inv0d0 $PINS I=a[1] ZN=n228 VDD=VDD VSS=VSS
XU142 inv0d0 $PINS I=b[2] ZN=n219 VDD=VDD VSS=VSS
XU144 inv0d0 $PINS I=a[2] ZN=n227 VDD=VDD VSS=VSS
XU145 inv0d0 $PINS I=b[3] ZN=n218 VDD=VDD VSS=VSS
XU146 inv0d0 $PINS I=a[5] ZN=n224 VDD=VDD VSS=VSS
XU147 inv0d0 $PINS I=b[1] ZN=n220 VDD=VDD VSS=VSS
XU148 inv0d0 $PINS I=b[0] ZN=n221 VDD=VDD VSS=VSS
XU149 inv0d0 $PINS I=a[4] ZN=n225 VDD=VDD VSS=VSS
XU150 inv0d0 $PINS I=b[6] ZN=n215 VDD=VDD VSS=VSS
XU151 inv0d0 $PINS I=a[3] ZN=n226 VDD=VDD VSS=VSS
XU152 inv0d0 $PINS I=b[5] ZN=n216 VDD=VDD VSS=VSS
XU153 inv0d0 $PINS I=b[7] ZN=n214 VDD=VDD VSS=VSS
XU154 inv0d0 $PINS I=a[6] ZN=n223 VDD=VDD VSS=VSS
XU156 nr02d0 $PINS A1=a[0] A2=n221 ZN=product[0] VDD=VDD VSS=VSS
XU157 nr02d0 $PINS A1=a[7] A2=n214 ZN=n99 VDD=VDD VSS=VSS
XU158 nr02d0 $PINS A1=a[0] A2=n220 ZN=n161 VDD=VDD VSS=VSS
XU159 nr02d0 $PINS A1=a[0] A2=n219 ZN=n160 VDD=VDD VSS=VSS
XU160 nr02d0 $PINS A1=a[0] A2=n218 ZN=n159 VDD=VDD VSS=VSS
XU161 nr02d0 $PINS A1=a[0] A2=n217 ZN=n158 VDD=VDD VSS=VSS
XU162 nr02d0 $PINS A1=a[0] A2=n216 ZN=n157 VDD=VDD VSS=VSS
XU163 nr02d0 $PINS A1=a[0] A2=n215 ZN=n156 VDD=VDD VSS=VSS
XU164 nr02d0 $PINS A1=a[0] A2=n214 ZN=n155 VDD=VDD VSS=VSS
XU165 nr02d0 $PINS A1=n221 A2=n228 ZN=n154 VDD=VDD VSS=VSS
XU166 nr02d0 $PINS A1=n220 A2=n228 ZN=n153 VDD=VDD VSS=VSS
XU167 nr02d0 $PINS A1=n219 A2=n228 ZN=n152 VDD=VDD VSS=VSS
XU168 nr02d0 $PINS A1=n218 A2=n228 ZN=n151 VDD=VDD VSS=VSS
XU169 nr02d0 $PINS A1=n217 A2=n228 ZN=n150 VDD=VDD VSS=VSS
XU170 nr02d0 $PINS A1=n216 A2=n228 ZN=n149 VDD=VDD VSS=VSS
XU171 nr02d0 $PINS A1=n215 A2=n228 ZN=n148 VDD=VDD VSS=VSS
XU172 nr02d0 $PINS A1=n214 A2=n228 ZN=n147 VDD=VDD VSS=VSS
XU173 nr02d0 $PINS A1=n221 A2=n227 ZN=n146 VDD=VDD VSS=VSS
XU174 nr02d0 $PINS A1=n220 A2=n227 ZN=n145 VDD=VDD VSS=VSS
XU175 nr02d0 $PINS A1=n219 A2=n227 ZN=n144 VDD=VDD VSS=VSS
XU176 nr02d0 $PINS A1=n218 A2=n227 ZN=n143 VDD=VDD VSS=VSS
XU177 nr02d0 $PINS A1=n217 A2=n227 ZN=n142 VDD=VDD VSS=VSS
XU178 nr02d0 $PINS A1=n216 A2=n227 ZN=n141 VDD=VDD VSS=VSS
XU179 nr02d0 $PINS A1=n215 A2=n227 ZN=n140 VDD=VDD VSS=VSS
XU180 nr02d0 $PINS A1=n214 A2=n227 ZN=n139 VDD=VDD VSS=VSS
XU181 nr02d0 $PINS A1=n221 A2=n226 ZN=n138 VDD=VDD VSS=VSS
XU182 nr02d0 $PINS A1=n220 A2=n226 ZN=n137 VDD=VDD VSS=VSS
XU183 nr02d0 $PINS A1=n219 A2=n226 ZN=n136 VDD=VDD VSS=VSS
XU184 nr02d0 $PINS A1=n218 A2=n226 ZN=n135 VDD=VDD VSS=VSS
XU185 nr02d0 $PINS A1=n217 A2=n226 ZN=n134 VDD=VDD VSS=VSS
XU186 nr02d0 $PINS A1=n216 A2=n226 ZN=n133 VDD=VDD VSS=VSS
XU187 nr02d0 $PINS A1=n215 A2=n226 ZN=n132 VDD=VDD VSS=VSS
XU188 nr02d0 $PINS A1=n214 A2=n226 ZN=n131 VDD=VDD VSS=VSS
XU189 nr02d0 $PINS A1=n221 A2=n225 ZN=n130 VDD=VDD VSS=VSS
XU190 nr02d0 $PINS A1=n220 A2=n225 ZN=n129 VDD=VDD VSS=VSS
XU191 nr02d0 $PINS A1=n219 A2=n225 ZN=n128 VDD=VDD VSS=VSS
XU192 nr02d0 $PINS A1=n218 A2=n225 ZN=n127 VDD=VDD VSS=VSS
XU193 nr02d0 $PINS A1=n217 A2=n225 ZN=n126 VDD=VDD VSS=VSS
XU194 nr02d0 $PINS A1=n216 A2=n225 ZN=n125 VDD=VDD VSS=VSS
XU195 nr02d0 $PINS A1=n215 A2=n225 ZN=n124 VDD=VDD VSS=VSS
XU196 nr02d0 $PINS A1=n214 A2=n225 ZN=n123 VDD=VDD VSS=VSS
XU197 nr02d0 $PINS A1=n221 A2=n224 ZN=n122 VDD=VDD VSS=VSS
XU198 nr02d0 $PINS A1=n220 A2=n224 ZN=n121 VDD=VDD VSS=VSS
XU199 nr02d0 $PINS A1=n219 A2=n224 ZN=n120 VDD=VDD VSS=VSS
XU200 nr02d0 $PINS A1=n218 A2=n224 ZN=n119 VDD=VDD VSS=VSS
XU201 nr02d0 $PINS A1=n217 A2=n224 ZN=n118 VDD=VDD VSS=VSS
XU202 nr02d0 $PINS A1=n216 A2=n224 ZN=n117 VDD=VDD VSS=VSS
XU203 nr02d0 $PINS A1=n215 A2=n224 ZN=n116 VDD=VDD VSS=VSS
XU204 nr02d0 $PINS A1=n214 A2=n224 ZN=n115 VDD=VDD VSS=VSS
XU205 nr02d0 $PINS A1=n221 A2=n223 ZN=n114 VDD=VDD VSS=VSS
XU206 nr02d0 $PINS A1=n220 A2=n223 ZN=n113 VDD=VDD VSS=VSS
XU207 nr02d0 $PINS A1=n219 A2=n223 ZN=n112 VDD=VDD VSS=VSS
XU208 nr02d0 $PINS A1=n218 A2=n223 ZN=n111 VDD=VDD VSS=VSS
XU209 nr02d0 $PINS A1=n217 A2=n223 ZN=n110 VDD=VDD VSS=VSS
XU210 nr02d0 $PINS A1=n216 A2=n223 ZN=n109 VDD=VDD VSS=VSS
XU211 nr02d0 $PINS A1=n215 A2=n223 ZN=n108 VDD=VDD VSS=VSS
XU212 nr02d0 $PINS A1=n214 A2=n223 ZN=n107 VDD=VDD VSS=VSS
XU213 nr02d0 $PINS A1=n221 A2=a[7] ZN=n106 VDD=VDD VSS=VSS
XU214 nr02d0 $PINS A1=a[7] A2=n220 ZN=n105 VDD=VDD VSS=VSS
XU215 nr02d0 $PINS A1=a[7] A2=n219 ZN=n104 VDD=VDD VSS=VSS
XU216 nr02d0 $PINS A1=a[7] A2=n218 ZN=n103 VDD=VDD VSS=VSS
XU217 nr02d0 $PINS A1=a[7] A2=n217 ZN=n102 VDD=VDD VSS=VSS
XU218 nr02d0 $PINS A1=a[7] A2=n216 ZN=n101 VDD=VDD VSS=VSS
XU219 nr02d0 $PINS A1=a[7] A2=n215 ZN=n100 VDD=VDD VSS=VSS
.ENDS

.SUBCKT unpu_pe_6_DW01_add_0_DW01_add_7 A[31] A[30] A[29] A[28] A[27] A[26]
+ A[25] A[24] A[23] A[22] A[21] A[20] A[19] A[18] A[17] A[16] A[15] A[14] A[13]
+ A[12] A[11] A[10] A[9] A[8] A[7] A[6] A[5] A[4] A[3] A[2] A[1] A[0] B[31]
+ B[30] B[29] B[28] B[27] B[26] B[25] B[24] B[23] B[22] B[21] B[20] B[19] B[18]
+ B[17] B[16] B[15] B[14] B[13] B[12] B[11] B[10] B[9] B[8] B[7] B[6] B[5] B[4]
+ B[3] B[2] B[1] B[0] CI SUM[31] SUM[30] SUM[29] SUM[28] SUM[27] SUM[26]
+ SUM[25] SUM[24] SUM[23] SUM[22] SUM[21] SUM[20] SUM[19] SUM[18] SUM[17]
+ SUM[16] SUM[15] SUM[14] SUM[13] SUM[12] SUM[11] SUM[10] SUM[9] SUM[8] SUM[7]
+ SUM[6] SUM[5] SUM[4] SUM[3] SUM[2] SUM[1] SUM[0] CO VDD VSS
XU1_31 ad01d1 $PINS A=copt_net_2528 B=B[31] CI=carry[31] S=SUM[31] VDD=VDD
+ VSS=VSS
XU1_30 ad01d0 $PINS A=copt_net_755 B=B[30] CI=carry[30] CO=carry[31] S=SUM[30]
+ VDD=VDD VSS=VSS
XU1_29 ad01d0 $PINS A=copt_net_2508 B=B[29] CI=carry[29] CO=carry[30] S=SUM[29]
+ VDD=VDD VSS=VSS
XU1_28 ad01d0 $PINS A=copt_net_1344 B=B[28] CI=carry[28] CO=carry[29] S=SUM[28]
+ VDD=VDD VSS=VSS
XU1_27 ad01d0 $PINS A=copt_net_1693 B=B[27] CI=carry[27] CO=carry[28] S=SUM[27]
+ VDD=VDD VSS=VSS
XU1_26 ad01d0 $PINS A=copt_net_1458 B=B[26] CI=carry[26] CO=carry[27] S=SUM[26]
+ VDD=VDD VSS=VSS
XU1_25 ad01d0 $PINS A=copt_net_1061 B=B[25] CI=carry[25] CO=carry[26] S=SUM[25]
+ VDD=VDD VSS=VSS
XU1_24 ad01d0 $PINS A=copt_net_2485 B=B[24] CI=carry[24] CO=carry[25] S=SUM[24]
+ VDD=VDD VSS=VSS
XU1_23 ad01d0 $PINS A=copt_net_739 B=B[23] CI=carry[23] CO=carry[24] S=SUM[23]
+ VDD=VDD VSS=VSS
XU1_22 ad01d0 $PINS A=copt_net_1740 B=B[22] CI=carry[22] CO=carry[23] S=SUM[22]
+ VDD=VDD VSS=VSS
XU1_21 ad01d0 $PINS A=copt_net_2383 B=B[21] CI=carry[21] CO=carry[22] S=SUM[21]
+ VDD=VDD VSS=VSS
XU1_20 ad01d0 $PINS A=copt_net_851 B=B[20] CI=carry[20] CO=carry[21] S=SUM[20]
+ VDD=VDD VSS=VSS
XU1_19 ad01d0 $PINS A=copt_net_2461 B=B[19] CI=carry[19] CO=carry[20] S=SUM[19]
+ VDD=VDD VSS=VSS
XU1_18 ad01d0 $PINS A=copt_net_1435 B=B[18] CI=carry[18] CO=carry[19] S=SUM[18]
+ VDD=VDD VSS=VSS
XU1_17 ad01d0 $PINS A=copt_net_1764 B=B[17] CI=carry[17] CO=carry[18] S=SUM[17]
+ VDD=VDD VSS=VSS
XU1_16 ad01d0 $PINS A=copt_net_1511 B=B[16] CI=carry[16] CO=carry[17] S=SUM[16]
+ VDD=VDD VSS=VSS
XU1_15 ad01d0 $PINS A=copt_net_1541 B=B[15] CI=carry[15] CO=carry[16] S=SUM[15]
+ VDD=VDD VSS=VSS
XU1_14 ad01d0 $PINS A=copt_net_1683 B=B[14] CI=carry[14] CO=carry[15] S=SUM[14]
+ VDD=VDD VSS=VSS
XU1_13 ad01d0 $PINS A=copt_net_1014 B=B[13] CI=carry[13] CO=carry[14] S=SUM[13]
+ VDD=VDD VSS=VSS
XU1_12 ad01d0 $PINS A=copt_net_2711 B=B[12] CI=carry[12] CO=carry[13] S=SUM[12]
+ VDD=VDD VSS=VSS
XU1_11 ad01d0 $PINS A=copt_net_1426 B=B[11] CI=carry[11] CO=carry[12] S=SUM[11]
+ VDD=VDD VSS=VSS
XU1_10 ad01d0 $PINS A=A[10] B=B[10] CI=carry[10] CO=carry[11] S=SUM[10] VDD=VDD
+ VSS=VSS
XU1_9 ad01d0 $PINS A=A[9] B=B[9] CI=carry[9] CO=carry[10] S=SUM[9] VDD=VDD
+ VSS=VSS
XU1_8 ad01d0 $PINS A=A[8] B=B[8] CI=carry[8] CO=carry[9] S=SUM[8] VDD=VDD
+ VSS=VSS
XU1_7 ad01d0 $PINS A=A[7] B=B[7] CI=carry[7] CO=carry[8] S=SUM[7] VDD=VDD
+ VSS=VSS
XU1_6 ad01d0 $PINS A=A[6] B=B[6] CI=carry[6] CO=carry[7] S=SUM[6] VDD=VDD
+ VSS=VSS
XU1_5 ad01d0 $PINS A=A[5] B=B[5] CI=carry[5] CO=carry[6] S=SUM[5] VDD=VDD
+ VSS=VSS
XU1_4 ad01d0 $PINS A=A[4] B=B[4] CI=carry[4] CO=carry[5] S=SUM[4] VDD=VDD
+ VSS=VSS
XU1_3 ad01d0 $PINS A=A[3] B=B[3] CI=carry[3] CO=carry[4] S=SUM[3] VDD=VDD
+ VSS=VSS
XU1_2 ad01d0 $PINS A=A[2] B=B[2] CI=carry[2] CO=carry[3] S=SUM[2] VDD=VDD
+ VSS=VSS
XU1_1 ad01d0 $PINS A=A[1] B=B[1] CI=n1 CO=carry[2] S=SUM[1] VDD=VDD VSS=VSS
XU1 an02d0 $PINS A1=B[0] A2=A[0] Z=n1 VDD=VDD VSS=VSS
XU2 xr02d1 $PINS A1=copt_net_311 A2=B[0] Z=SUM[0] VDD=VDD VSS=VSS
Xcopt_h_inst_3141 dl02d1 $PINS I=A[0] Z=copt_net_311 VDD=VDD VSS=VSS
Xcopt_h_inst_3570 dl02d1 $PINS I=A[23] Z=copt_net_739 VDD=VDD VSS=VSS
Xcopt_h_inst_3586 dl02d1 $PINS I=A[30] Z=copt_net_755 VDD=VDD VSS=VSS
Xcopt_h_inst_3683 dl02d1 $PINS I=A[20] Z=copt_net_851 VDD=VDD VSS=VSS
Xcopt_h_inst_3846 dl02d1 $PINS I=A[13] Z=copt_net_1014 VDD=VDD VSS=VSS
Xcopt_h_inst_3893 dl02d1 $PINS I=A[25] Z=copt_net_1061 VDD=VDD VSS=VSS
Xcopt_h_inst_4176 dl02d1 $PINS I=A[28] Z=copt_net_1344 VDD=VDD VSS=VSS
Xcopt_h_inst_4258 dl01d1 $PINS I=A[11] Z=copt_net_1426 VDD=VDD VSS=VSS
Xcopt_h_inst_4267 dl02d1 $PINS I=A[18] Z=copt_net_1435 VDD=VDD VSS=VSS
Xcopt_h_inst_4290 dl02d1 $PINS I=A[26] Z=copt_net_1458 VDD=VDD VSS=VSS
Xcopt_h_inst_4343 dl02d1 $PINS I=A[16] Z=copt_net_1511 VDD=VDD VSS=VSS
Xcopt_h_inst_4373 dl02d1 $PINS I=A[15] Z=copt_net_1541 VDD=VDD VSS=VSS
Xcopt_h_inst_4515 dl01d1 $PINS I=A[14] Z=copt_net_1683 VDD=VDD VSS=VSS
Xcopt_h_inst_4525 dl02d1 $PINS I=A[27] Z=copt_net_1693 VDD=VDD VSS=VSS
Xcopt_h_inst_4572 dl01d1 $PINS I=A[22] Z=copt_net_1740 VDD=VDD VSS=VSS
Xcopt_h_inst_4596 dl01d1 $PINS I=A[17] Z=copt_net_1764 VDD=VDD VSS=VSS
Xcopt_h_inst_5216 dl01d1 $PINS I=A[21] Z=copt_net_2383 VDD=VDD VSS=VSS
Xcopt_h_inst_5294 dl01d1 $PINS I=A[19] Z=copt_net_2461 VDD=VDD VSS=VSS
Xcopt_h_inst_5318 dl01d1 $PINS I=A[24] Z=copt_net_2485 VDD=VDD VSS=VSS
Xcopt_h_inst_5341 dl01d1 $PINS I=A[29] Z=copt_net_2508 VDD=VDD VSS=VSS
Xcopt_h_inst_5361 dl01d1 $PINS I=A[31] Z=copt_net_2528 VDD=VDD VSS=VSS
Xcopt_h_inst_5544 buffd1 $PINS I=A[12] Z=copt_net_2711 VDD=VDD VSS=VSS
.ENDS

.SUBCKT unpu_pe_6 ZCTSNET_8 rst_n array_en weight_load mode_unsigned
+ weight_in[7] weight_in[6] weight_in[5] weight_in[4] weight_in[3] weight_in[2]
+ weight_in[1] weight_in[0] act_in[7] act_in[6] act_in[5] act_in[4] act_in[3]
+ act_in[2] act_in[1] act_in[0] psum_in[31] psum_in[30] psum_in[29] psum_in[28]
+ psum_in[27] psum_in[26] psum_in[25] psum_in[24] psum_in[23] psum_in[22]
+ psum_in[21] psum_in[20] psum_in[19] psum_in[18] psum_in[17] psum_in[16]
+ psum_in[15] psum_in[14] psum_in[13] psum_in[12] psum_in[11] psum_in[10]
+ psum_in[9] psum_in[8] psum_in[7] psum_in[6] psum_in[5] psum_in[4] psum_in[3]
+ psum_in[2] psum_in[1] psum_in[0] act_out[7] act_out[6] act_out[5] act_out[4]
+ act_out[3] act_out[2] act_out[1] act_out[0] psum_out[31] psum_out[30]
+ psum_out[29] psum_out[28] psum_out[27] psum_out[26] psum_out[25] psum_out[24]
+ psum_out[23] psum_out[22] psum_out[21] psum_out[20] psum_out[19] psum_out[18]
+ psum_out[17] psum_out[16] psum_out[15] psum_out[14] psum_out[13] psum_out[12]
+ psum_out[11] psum_out[10] psum_out[9] psum_out[8] psum_out[7] psum_out[6]
+ psum_out[5] psum_out[4] psum_out[3] psum_out[2] psum_out[1] psum_out[0] VDD
+ VSS ZCTSNET_0 ZCTSNET_9 HFSNET_2 HFSNET_3 HFSNET_4 HFSNET_5 HFSNET_6 HFSNET_7
XU2 aor22d1 $PINS A1=N_uc_30 A2=HFSNET_2 B1=mode_unsigned B2=N_uc_14
+ Z=product[9] VDD=VDD VSS=VSS
XU3 aor22d1 $PINS A1=N_uc_29 A2=HFSNET_2 B1=N_uc_13 B2=mode_unsigned
+ Z=product[8] VDD=VDD VSS=VSS
XU5 aor22d1 $PINS A1=N_uc_28 A2=HFSNET_2 B1=N_uc_12 B2=mode_unsigned
+ Z=product[7] VDD=VDD VSS=VSS
XU6 aor22d1 $PINS A1=N_uc_27 A2=HFSNET_2 B1=N_uc_11 B2=mode_unsigned
+ Z=product[6] VDD=VDD VSS=VSS
XU7 aor22d1 $PINS A1=N_uc_26 A2=HFSNET_2 B1=N_uc_10 B2=mode_unsigned
+ Z=product[5] VDD=VDD VSS=VSS
XU8 aor22d1 $PINS A1=N_uc_9 A2=mode_unsigned B1=N_uc_25 B2=HFSNET_2
+ Z=product[4] VDD=VDD VSS=VSS
XU9 aor22d1 $PINS A1=N_uc_8 A2=mode_unsigned B1=N_uc_24 B2=HFSNET_2
+ Z=product[3] VDD=VDD VSS=VSS
XU10 aor22d1 $PINS A1=N_uc_7 A2=mode_unsigned B1=N_uc_23 B2=HFSNET_2
+ Z=product[2] VDD=VDD VSS=VSS
XU11 aor22d1 $PINS A1=N_uc_6 A2=mode_unsigned B1=N_uc_22 B2=HFSNET_2
+ Z=product[1] VDD=VDD VSS=VSS
XU12 oaim21d1 $PINS B1=N_uc_20 B2=mode_unsigned A=n16 ZN=product[15] VDD=VDD
+ VSS=VSS
XU13 aor22d1 $PINS A1=N_uc_35 A2=HFSNET_2 B1=N_uc_19 B2=mode_unsigned
+ Z=product[14] VDD=VDD VSS=VSS
XU14 aor22d1 $PINS A1=N_uc_34 A2=HFSNET_2 B1=N_uc_18 B2=mode_unsigned
+ Z=product[13] VDD=VDD VSS=VSS
XU15 aor22d1 $PINS A1=N_uc_33 A2=HFSNET_2 B1=N_uc_17 B2=mode_unsigned
+ Z=product[12] VDD=VDD VSS=VSS
XU16 aor22d1 $PINS A1=N_uc_32 A2=HFSNET_2 B1=N_uc_16 B2=mode_unsigned
+ Z=product[11] VDD=VDD VSS=VSS
XU17 aor22d1 $PINS A1=N_uc_31 A2=HFSNET_2 B1=N_uc_15 B2=mode_unsigned
+ Z=product[10] VDD=VDD VSS=VSS
XU18 aor22d1 $PINS A1=N_uc_5 A2=mode_unsigned B1=N_uc_21 B2=HFSNET_2
+ Z=product[0] VDD=VDD VSS=VSS
Xadd_42 unpu_pe_6_DW01_add_0_DW01_add_7 $PINS A[31]=psum_in[31]
+ A[30]=psum_in[30] A[29]=psum_in[29] A[28]=psum_in[28] A[27]=psum_in[27]
+ A[26]=psum_in[26] A[25]=psum_in[25] A[24]=psum_in[24] A[23]=psum_in[23]
+ A[22]=psum_in[22] A[21]=psum_in[21] A[20]=psum_in[20] A[19]=psum_in[19]
+ A[18]=psum_in[18] A[17]=psum_in[17] A[16]=psum_in[16] A[15]=psum_in[15]
+ A[14]=psum_in[14] A[13]=psum_in[13] A[12]=psum_in[12] A[11]=psum_in[11]
+ A[10]=psum_in[10] A[9]=psum_in[9] A[8]=psum_in[8] A[7]=psum_in[7]
+ A[6]=psum_in[6] A[5]=psum_in[5] A[4]=psum_in[4] A[3]=psum_in[3] A[2]=psum_in[2]
+ A[1]=psum_in[1] A[0]=psum_in[0] B[31]=n2 B[30]=n2 B[29]=n2 B[28]=n2 B[27]=n2
+ B[26]=n2 B[25]=n2 B[24]=n2 B[23]=n2 B[22]=n2 B[21]=n2 B[20]=n2 B[19]=n2
+ B[18]=n2 B[17]=n2 B[16]=n2 B[15]=product[15] B[14]=product[14]
+ B[13]=product[13] B[12]=product[12] B[11]=product[11] B[10]=product[10]
+ B[9]=product[9] B[8]=product[8] B[7]=product[7] B[6]=product[6] B[5]=product[5]
+ B[4]=product[4] B[3]=product[3] B[2]=product[2] B[1]=product[1] B[0]=product[0]
+ CI=VSS SUM[31]=N_uc_71 SUM[30]=N_uc_70 SUM[29]=N_uc_69 SUM[28]=N_uc_68
+ SUM[27]=N_uc_67 SUM[26]=N_uc_66 SUM[25]=N_uc_65 SUM[24]=N_uc_64 SUM[23]=N_uc_63
+ SUM[22]=N_uc_62 SUM[21]=N_uc_61 SUM[20]=N_uc_60 SUM[19]=N_uc_59 SUM[18]=N_uc_58
+ SUM[17]=N_uc_57 SUM[16]=N_uc_56 SUM[15]=N_uc_55 SUM[14]=N_uc_54 SUM[13]=N_uc_53
+ SUM[12]=N_uc_52 SUM[11]=N_uc_51 SUM[10]=N_uc_50 SUM[9]=N_uc_49 SUM[8]=N_uc_48
+ SUM[7]=N_uc_47 SUM[6]=N_uc_46 SUM[5]=N_uc_45 SUM[4]=N_uc_44 SUM[3]=N_uc_43
+ SUM[2]=N_uc_42 SUM[1]=N_uc_41 SUM[0]=N_uc_40 VDD=VDD VSS=VSS
Xmult_28 unpu_pe_6_DW_mult_uns_0_DW_mult_uns_6 $PINS a[7]=gre_a_INV_1546_3
+ a[6]=weight_reg[6] a[5]=weight_reg[5] a[4]=weight_reg[4] a[3]=weight_reg[3]
+ a[2]=weight_reg[2] a[1]=weight_reg[1] a[0]=gre_a_INV_1463_3 b[7]=act_in[7]
+ b[6]=act_in[6] b[5]=act_in[5] b[4]=act_in[4] b[3]=act_in[3] b[2]=act_in[2]
+ b[1]=act_in[1] b[0]=act_in[0] product[15]=N_uc_20 product[14]=N_uc_19
+ product[13]=N_uc_18 product[12]=N_uc_17 product[11]=N_uc_16 product[10]=N_uc_15
+ product[9]=N_uc_14 product[8]=N_uc_13 product[7]=N_uc_12 product[6]=N_uc_11
+ product[5]=N_uc_10 product[4]=N_uc_9 product[3]=N_uc_8 product[2]=N_uc_7
+ product[1]=N_uc_6 product[0]=N_uc_5 VDD=VDD VSS=VSS
Xmult_30 unpu_pe_6_DW_mult_tc_0_DW_mult_tc_5 $PINS a[7]=weight_reg[7]
+ a[6]=weight_reg[6] a[5]=weight_reg[5] a[4]=weight_reg[4] a[3]=weight_reg[3]
+ a[2]=weight_reg[2] a[1]=weight_reg[1] a[0]=gre_a_INV_1463_3 b[7]=act_in[7]
+ b[6]=act_in[6] b[5]=act_in[5] b[4]=act_in[4] b[3]=act_in[3] b[2]=act_in[2]
+ b[1]=act_in[1] b[0]=act_in[0] product[15]=N_uc_36 product[14]=N_uc_35
+ product[13]=N_uc_34 product[12]=N_uc_33 product[11]=N_uc_32 product[10]=N_uc_31
+ product[9]=N_uc_30 product[8]=N_uc_29 product[7]=N_uc_28 product[6]=N_uc_27
+ product[5]=N_uc_26 product[4]=N_uc_25 product[3]=N_uc_24 product[2]=N_uc_23
+ product[1]=N_uc_22 product[0]=N_uc_21 VDD=VDD VSS=VSS
+ gre_a_INV_1546_2=gre_a_INV_1546_3
Xact_out_reg_3_ decrq1 $PINS D=copt_net_2233 ENN=HFSNET_4 CP=ZCTSNET_8
+ CDN=rst_n Q=act_out[3] VDD=VDD VSS=VSS
Xact_out_reg_2_ decrq1 $PINS D=copt_net_321 ENN=HFSNET_4 CP=ZCTSNET_9 CDN=rst_n
+ Q=act_out[2] VDD=VDD VSS=VSS
Xact_out_reg_1_ decrq1 $PINS D=copt_net_330 ENN=HFSNET_4 CP=ZCTSNET_9 CDN=rst_n
+ Q=act_out[1] VDD=VDD VSS=VSS
Xact_out_reg_7_ decrq1 $PINS D=copt_net_1445 ENN=HFSNET_4 CP=ZCTSNET_9
+ CDN=HFSNET_6 Q=act_out[7] VDD=VDD VSS=VSS
Xact_out_reg_6_ decrq1 $PINS D=copt_net_1386 ENN=HFSNET_4 CP=ZCTSNET_9
+ CDN=rst_n Q=act_out[6] VDD=VDD VSS=VSS
Xact_out_reg_5_ decrq1 $PINS D=copt_net_358 ENN=HFSNET_4 CP=ZCTSNET_9
+ CDN=HFSNET_6 Q=act_out[5] VDD=VDD VSS=VSS
Xact_out_reg_4_ decrq1 $PINS D=copt_net_1404 ENN=HFSNET_4 CP=ZCTSNET_9
+ CDN=rst_n Q=act_out[4] VDD=VDD VSS=VSS
Xact_out_reg_0_ decrq1 $PINS D=copt_net_1466 ENN=HFSNET_4 CP=ZCTSNET_9
+ CDN=rst_n Q=act_out[0] VDD=VDD VSS=VSS
Xpsum_out_reg_7_ decrq1 $PINS D=N_uc_47 ENN=HFSNET_3 CP=ZCTSNET_8 CDN=HFSNET_5
+ Q=psum_out[7] VDD=VDD VSS=VSS
Xpsum_out_reg_6_ decrq1 $PINS D=N_uc_46 ENN=HFSNET_3 CP=ZCTSNET_8 CDN=HFSNET_5
+ Q=psum_out[6] VDD=VDD VSS=VSS
Xpsum_out_reg_5_ decrq1 $PINS D=N_uc_45 ENN=HFSNET_3 CP=ZCTSNET_8 CDN=HFSNET_5
+ Q=psum_out[5] VDD=VDD VSS=VSS
Xpsum_out_reg_4_ decrq1 $PINS D=N_uc_44 ENN=HFSNET_3 CP=ZCTSNET_8 CDN=HFSNET_5
+ Q=psum_out[4] VDD=VDD VSS=VSS
Xpsum_out_reg_3_ decrq1 $PINS D=N_uc_43 ENN=HFSNET_3 CP=ZCTSNET_8 CDN=HFSNET_5
+ Q=psum_out[3] VDD=VDD VSS=VSS
Xpsum_out_reg_2_ decrq1 $PINS D=N_uc_42 ENN=HFSNET_3 CP=ZCTSNET_8 CDN=HFSNET_5
+ Q=psum_out[2] VDD=VDD VSS=VSS
Xpsum_out_reg_1_ decrq1 $PINS D=copt_net_2558 ENN=HFSNET_4 CP=ZCTSNET_0
+ CDN=HFSNET_6 Q=psum_out[1] VDD=VDD VSS=VSS
Xpsum_out_reg_0_ decrq1 $PINS D=N_uc_40 ENN=HFSNET_3 CP=ZCTSNET_0 CDN=HFSNET_6
+ Q=psum_out[0] VDD=VDD VSS=VSS
Xpsum_out_reg_8_ decrq1 $PINS D=N_uc_48 ENN=HFSNET_3 CP=ZCTSNET_8 CDN=HFSNET_5
+ Q=psum_out[8] VDD=VDD VSS=VSS
Xpsum_out_reg_9_ decrq1 $PINS D=N_uc_49 ENN=HFSNET_3 CP=ZCTSNET_8 CDN=HFSNET_5
+ Q=psum_out[9] VDD=VDD VSS=VSS
Xpsum_out_reg_10_ decrq1 $PINS D=N_uc_50 ENN=HFSNET_3 CP=ZCTSNET_8 CDN=HFSNET_5
+ Q=psum_out[10] VDD=VDD VSS=VSS
Xweight_reg_reg_7_ decrq1 $PINS D=copt_gre_net_2959 ENN=n15 CP=ZCTSNET_9
+ CDN=HFSNET_6 Q=weight_reg[7] VDD=VDD VSS=VSS
Xweight_reg_reg_6_ decrq1 $PINS D=weight_in[6] ENN=n15 CP=ZCTSNET_9
+ CDN=HFSNET_6 Q=weight_reg[6] VDD=VDD VSS=VSS
Xweight_reg_reg_5_ decrq1 $PINS D=weight_in[5] ENN=n15 CP=ZCTSNET_9
+ CDN=HFSNET_6 Q=weight_reg[5] VDD=VDD VSS=VSS
Xweight_reg_reg_4_ decrq1 $PINS D=weight_in[4] ENN=n15 CP=ZCTSNET_9
+ CDN=HFSNET_6 Q=weight_reg[4] VDD=VDD VSS=VSS
Xweight_reg_reg_3_ decrq1 $PINS D=weight_in[3] ENN=n15 CP=ZCTSNET_9
+ CDN=HFSNET_6 Q=weight_reg[3] VDD=VDD VSS=VSS
Xweight_reg_reg_2_ decrq1 $PINS D=weight_in[2] ENN=n15 CP=ZCTSNET_9
+ CDN=HFSNET_6 Q=weight_reg[2] VDD=VDD VSS=VSS
Xweight_reg_reg_1_ decrq1 $PINS D=weight_in[1] ENN=n15 CP=ZCTSNET_9
+ CDN=HFSNET_6 Q=weight_reg[1] VDD=VDD VSS=VSS
Xweight_reg_reg_0_ decrq1 $PINS D=weight_in[0] ENN=n15 CP=ZCTSNET_9
+ CDN=HFSNET_6 Q=weight_reg[0] VDD=VDD VSS=VSS
Xpsum_out_reg_11_ decrq1 $PINS D=N_uc_51 ENN=HFSNET_3 CP=ZCTSNET_8 CDN=HFSNET_5
+ Q=psum_out[11] VDD=VDD VSS=VSS
Xpsum_out_reg_12_ decrq1 $PINS D=N_uc_52 ENN=HFSNET_3 CP=ZCTSNET_8 CDN=HFSNET_5
+ Q=psum_out[12] VDD=VDD VSS=VSS
Xpsum_out_reg_13_ decrq1 $PINS D=N_uc_53 ENN=HFSNET_3 CP=ZCTSNET_0 CDN=HFSNET_5
+ Q=psum_out[13] VDD=VDD VSS=VSS
Xpsum_out_reg_14_ decrq1 $PINS D=N_uc_54 ENN=HFSNET_3 CP=ZCTSNET_8 CDN=HFSNET_5
+ Q=psum_out[14] VDD=VDD VSS=VSS
Xpsum_out_reg_15_ decrq1 $PINS D=N_uc_55 ENN=HFSNET_3 CP=ZCTSNET_0 CDN=HFSNET_5
+ Q=psum_out[15] VDD=VDD VSS=VSS
Xpsum_out_reg_16_ decrq1 $PINS D=N_uc_56 ENN=HFSNET_3 CP=ZCTSNET_0 CDN=HFSNET_5
+ Q=psum_out[16] VDD=VDD VSS=VSS
Xpsum_out_reg_17_ decrq1 $PINS D=N_uc_57 ENN=HFSNET_3 CP=ZCTSNET_8 CDN=HFSNET_5
+ Q=psum_out[17] VDD=VDD VSS=VSS
Xpsum_out_reg_18_ decrq1 $PINS D=N_uc_58 ENN=HFSNET_3 CP=ZCTSNET_0 CDN=HFSNET_5
+ Q=psum_out[18] VDD=VDD VSS=VSS
Xpsum_out_reg_19_ decrq1 $PINS D=N_uc_59 ENN=HFSNET_3 CP=ZCTSNET_0 CDN=HFSNET_7
+ Q=psum_out[19] VDD=VDD VSS=VSS
Xpsum_out_reg_20_ decrq1 $PINS D=N_uc_60 ENN=HFSNET_4 CP=ZCTSNET_0 CDN=HFSNET_6
+ Q=psum_out[20] VDD=VDD VSS=VSS
Xpsum_out_reg_21_ decrq1 $PINS D=N_uc_61 ENN=HFSNET_4 CP=ZCTSNET_0 CDN=HFSNET_6
+ Q=psum_out[21] VDD=VDD VSS=VSS
Xpsum_out_reg_22_ decrq1 $PINS D=N_uc_62 ENN=HFSNET_4 CP=ZCTSNET_9 CDN=HFSNET_6
+ Q=psum_out[22] VDD=VDD VSS=VSS
Xpsum_out_reg_23_ decrq1 $PINS D=N_uc_63 ENN=HFSNET_3 CP=ZCTSNET_0 CDN=HFSNET_6
+ Q=psum_out[23] VDD=VDD VSS=VSS
Xpsum_out_reg_24_ decrq1 $PINS D=N_uc_64 ENN=HFSNET_4 CP=ZCTSNET_9 CDN=HFSNET_6
+ Q=psum_out[24] VDD=VDD VSS=VSS
Xpsum_out_reg_25_ decrq1 $PINS D=N_uc_65 ENN=HFSNET_3 CP=ZCTSNET_0 CDN=HFSNET_6
+ Q=psum_out[25] VDD=VDD VSS=VSS
Xpsum_out_reg_26_ decrq1 $PINS D=N_uc_66 ENN=HFSNET_3 CP=ZCTSNET_0 CDN=HFSNET_5
+ Q=psum_out[26] VDD=VDD VSS=VSS
Xpsum_out_reg_27_ decrq1 $PINS D=N_uc_67 ENN=HFSNET_3 CP=ZCTSNET_0 CDN=HFSNET_6
+ Q=psum_out[27] VDD=VDD VSS=VSS
Xpsum_out_reg_28_ decrq1 $PINS D=N_uc_68 ENN=HFSNET_3 CP=ZCTSNET_0 CDN=HFSNET_5
+ Q=psum_out[28] VDD=VDD VSS=VSS
Xpsum_out_reg_29_ decrq1 $PINS D=N_uc_69 ENN=HFSNET_4 CP=ZCTSNET_0 CDN=HFSNET_6
+ Q=psum_out[29] VDD=VDD VSS=VSS
Xpsum_out_reg_30_ decrq1 $PINS D=N_uc_70 ENN=HFSNET_3 CP=ZCTSNET_0 CDN=HFSNET_5
+ Q=psum_out[30] VDD=VDD VSS=VSS
Xpsum_out_reg_31_ decrq1 $PINS D=N_uc_71 ENN=HFSNET_3 CP=ZCTSNET_0 CDN=HFSNET_5
+ Q=psum_out[31] VDD=VDD VSS=VSS
XU19 inv0d2 $PINS I=n16 ZN=n2 VDD=VDD VSS=VSS
Xcopt_h_inst_3151 dl02d1 $PINS I=act_in[2] Z=copt_net_321 VDD=VDD VSS=VSS
Xcopt_h_inst_3160 dl02d1 $PINS I=act_in[1] Z=copt_net_330 VDD=VDD VSS=VSS
Xcopt_h_inst_3188 dl02d1 $PINS I=act_in[5] Z=copt_net_358 VDD=VDD VSS=VSS
Xcopt_h_inst_4218 dl01d1 $PINS I=act_in[6] Z=copt_net_1386 VDD=VDD VSS=VSS
Xcopt_h_inst_4236 dl01d1 $PINS I=act_in[4] Z=copt_net_1404 VDD=VDD VSS=VSS
XU25 nd02d1 $PINS A1=weight_load A2=array_en ZN=n15 VDD=VDD VSS=VSS
Xcopt_h_inst_4277 dl01d1 $PINS I=act_in[7] Z=copt_net_1445 VDD=VDD VSS=VSS
Xcopt_h_inst_4298 dl01d1 $PINS I=act_in[0] Z=copt_net_1466 VDD=VDD VSS=VSS
Xcopt_h_inst_5066 buffd1 $PINS I=act_in[3] Z=copt_net_2233 VDD=VDD VSS=VSS
Xcopt_h_inst_5391 dl01d1 $PINS I=N_uc_41 Z=copt_net_2558 VDD=VDD VSS=VSS
XU30 nd02d1 $PINS A1=N_uc_36 A2=HFSNET_2 ZN=n16 VDD=VDD VSS=VSS
Xcopt_gre_h_inst_5787 buffd1 $PINS I=weight_in[7] Z=copt_gre_net_2959 VDD=VDD
+ VSS=VSS
Xgre_a_INV_1546_inst_5808 inv0d1 $PINS I=weight_reg[7] ZN=gre_a_INV_1546_3
+ VDD=VDD VSS=VSS
Xgre_a_INV_1463_inst_5809 inv0d1 $PINS I=weight_reg[0] ZN=gre_a_INV_1463_3
+ VDD=VDD VSS=VSS
.ENDS

.SUBCKT unpu_pe_7_DW_mult_tc_0_DW_mult_tc_13 a[7] a[6] a[5] a[4] a[3] a[2] a[1]
+ a[0] b[7] b[6] b[5] b[4] b[3] b[2] b[1] b[0] product[15] product[14]
+ product[13] product[12] product[11] product[10] product[9] product[8]
+ product[7] product[6] product[5] product[4] product[3] product[2] product[1]
+ product[0] VDD VSS gre_a_INV_2941_2
XU2 ad01d0 $PINS A=n194 B=n61 CI=n2 CO=n1 S=product[14] VDD=VDD VSS=VSS
XU3 ad01d0 $PINS A=n17 B=n16 CI=n3 CO=n2 S=product[13] VDD=VDD VSS=VSS
XU4 ad01d0 $PINS A=n18 B=n19 CI=n4 CO=n3 S=product[12] VDD=VDD VSS=VSS
XU5 ad01d0 $PINS A=n20 B=n23 CI=n5 CO=n4 S=product[11] VDD=VDD VSS=VSS
XU6 ad01d0 $PINS A=n27 B=n24 CI=n6 CO=n5 S=product[10] VDD=VDD VSS=VSS
XU7 ad01d0 $PINS A=n33 B=n28 CI=n7 CO=n6 S=product[9] VDD=VDD VSS=VSS
XU8 ad01d0 $PINS A=n39 B=n34 CI=n8 CO=n7 S=product[8] VDD=VDD VSS=VSS
XU9 ad01d0 $PINS A=n45 B=n40 CI=n9 CO=n8 S=product[7] VDD=VDD VSS=VSS
XU10 ad01d0 $PINS A=n49 B=n46 CI=n10 CO=n9 S=product[6] VDD=VDD VSS=VSS
XU11 ad01d0 $PINS A=n53 B=n50 CI=n11 CO=n10 S=product[5] VDD=VDD VSS=VSS
XU12 ad01d0 $PINS A=n55 B=n54 CI=n12 CO=n11 S=product[4] VDD=VDD VSS=VSS
XU13 ad01d0 $PINS A=n59 B=n56 CI=n13 CO=n12 S=product[3] VDD=VDD VSS=VSS
XU14 ad01d0 $PINS A=n84 B=n91 CI=n14 CO=n13 S=product[2] VDD=VDD VSS=VSS
XctmTdsLR_1_2943 an02d1 $PINS A1=n58 A2=n75 Z=n51 VDD=VDD VSS=VSS
XU17 ad01d0 $PINS A=n197 B=n62 CI=n69 CO=n17 S=n18 VDD=VDD VSS=VSS
XU18 ad01d0 $PINS A=n63 B=n25 CI=n22 CO=n19 S=n20 VDD=VDD VSS=VSS
XU20 ad01d0 $PINS A=n64 B=n26 CI=n29 CO=n23 S=n24 VDD=VDD VSS=VSS
XU21 ad01d0 $PINS A=n200 B=n70 CI=n77 CO=n25 S=n26 VDD=VDD VSS=VSS
XU22 ad01d0 $PINS A=n32 B=n35 CI=n30 CO=n27 S=n28 VDD=VDD VSS=VSS
XU23 ad01d0 $PINS A=n71 B=n65 CI=n37 CO=n29 S=n30 VDD=VDD VSS=VSS
XU25 ad01d0 $PINS A=n38 B=n41 CI=n36 CO=n33 S=n34 VDD=VDD VSS=VSS
XU26 ad01d0 $PINS A=n72 B=n85 CI=n43 CO=n35 S=n36 VDD=VDD VSS=VSS
XU29 ad01d0 $PINS A=n44 B=n47 CI=n42 CO=n39 S=n40 VDD=VDD VSS=VSS
XU30 ad01d0 $PINS A=n86 B=n73 CI=n79 CO=n41 S=n42 VDD=VDD VSS=VSS
XU32 ad01d0 $PINS A=n74 B=n51 CI=n48 CO=n45 S=n46 VDD=VDD VSS=VSS
XU33 ad01d0 $PINS A=n68 B=n87 CI=n80 CO=n47 S=n48 VDD=VDD VSS=VSS
XU34 ad01d0 $PINS A=n88 B=n81 CI=n52 CO=n49 S=n50 VDD=VDD VSS=VSS
XU36 ad01d0 $PINS A=n76 B=n89 CI=n82 CO=n53 S=n54 VDD=VDD VSS=VSS
XU37 ah01d1 $PINS A=n83 B=n90 CO=n55 S=n56 VDD=VDD VSS=VSS
XU145 oai21d1 $PINS B1=n202 B2=n249 A=n222 ZN=n77 VDD=VDD VSS=VSS
XU146 oai21d1 $PINS B1=n199 B2=n250 A=n232 ZN=n69 VDD=VDD VSS=VSS
XU147 oai21d1 $PINS B1=n196 B2=n251 A=n242 ZN=n61 VDD=VDD VSS=VSS
XU148 inv0d0 $PINS I=n16 ZN=n194 VDD=VDD VSS=VSS
XU149 inv0d0 $PINS I=n223 ZN=n199 VDD=VDD VSS=VSS
XU150 inv0d0 $PINS I=n214 ZN=n202 VDD=VDD VSS=VSS
XU151 inv0d0 $PINS I=n233 ZN=n196 VDD=VDD VSS=VSS
XU152 inv0d0 $PINS I=n32 ZN=n200 VDD=VDD VSS=VSS
XU153 inv0d0 $PINS I=n22 ZN=n197 VDD=VDD VSS=VSS
XU154 nd02d1 $PINS A1=n214 A2=n249 ZN=n216 VDD=VDD VSS=VSS
XU155 xr02d1 $PINS A1=a[2] A2=n203 Z=n214 VDD=VDD VSS=VSS
XU156 inv0d1 $PINS I=a[1] ZN=n203 VDD=VDD VSS=VSS
XU157 nd02d1 $PINS A1=n223 A2=n250 ZN=n225 VDD=VDD VSS=VSS
XU158 xr02d1 $PINS A1=a[4] A2=n201 Z=n223 VDD=VDD VSS=VSS
XU159 inv0d1 $PINS I=a[3] ZN=n201 VDD=VDD VSS=VSS
XU160 nd02d1 $PINS A1=a[1] A2=a[0] ZN=n206 VDD=VDD VSS=VSS
XU162 inv0d0 $PINS I=b[0] ZN=n205 VDD=VDD VSS=VSS
XU163 xr02d1 $PINS A1=a[6] A2=n198 Z=n233 VDD=VDD VSS=VSS
XU164 inv0d1 $PINS I=a[5] ZN=n198 VDD=VDD VSS=VSS
XU165 nd02d1 $PINS A1=n233 A2=n251 ZN=n235 VDD=VDD VSS=VSS
XU167 inv0d0 $PINS I=n1 ZN=product[15] VDD=VDD VSS=VSS
XU168 nr02d0 $PINS A1=a[0] A2=n205 ZN=product[0] VDD=VDD VSS=VSS
XU169 oai22d1 $PINS A1=b[0] A2=n206 B1=n207 B2=a[0] ZN=n92 VDD=VDD VSS=VSS
XU170 oai22d1 $PINS A1=n207 A2=n206 B1=n208 B2=a[0] ZN=n91 VDD=VDD VSS=VSS
XU171 xr02d1 $PINS A1=b[1] A2=n203 Z=n207 VDD=VDD VSS=VSS
XU172 oai22d1 $PINS A1=n208 A2=n206 B1=n209 B2=a[0] ZN=n90 VDD=VDD VSS=VSS
XU173 xr02d1 $PINS A1=b[2] A2=n203 Z=n208 VDD=VDD VSS=VSS
XU174 oai22d1 $PINS A1=n209 A2=n206 B1=n210 B2=a[0] ZN=n89 VDD=VDD VSS=VSS
XU175 xr02d1 $PINS A1=b[3] A2=n203 Z=n209 VDD=VDD VSS=VSS
XU176 oai22d1 $PINS A1=n210 A2=n206 B1=n211 B2=a[0] ZN=n88 VDD=VDD VSS=VSS
XU177 xr02d1 $PINS A1=b[4] A2=n203 Z=n210 VDD=VDD VSS=VSS
XU178 oai22d1 $PINS A1=n211 A2=n206 B1=n212 B2=a[0] ZN=n87 VDD=VDD VSS=VSS
XU179 xr02d1 $PINS A1=b[5] A2=n203 Z=n211 VDD=VDD VSS=VSS
XU180 oai22d1 $PINS A1=n212 A2=n206 B1=n213 B2=a[0] ZN=n86 VDD=VDD VSS=VSS
XU181 xr02d1 $PINS A1=b[6] A2=n203 Z=n212 VDD=VDD VSS=VSS
XU182 aor21d1 $PINS B1=a[0] B2=n206 A=n213 Z=n85 VDD=VDD VSS=VSS
XU183 xr02d1 $PINS A1=b[7] A2=n203 Z=n213 VDD=VDD VSS=VSS
XU184 nr02d0 $PINS A1=n214 A2=n205 ZN=n84 VDD=VDD VSS=VSS
XU185 oai22d1 $PINS A1=n216 A2=n215 B1=n214 B2=n217 ZN=n83 VDD=VDD VSS=VSS
XctmTdsLR_1_2933 an02d1 $PINS A1=n60 A2=n92 Z=n14 VDD=VDD VSS=VSS
XU187 oai22d1 $PINS A1=n217 A2=n216 B1=n214 B2=n218 ZN=n82 VDD=VDD VSS=VSS
XU188 xr02d1 $PINS A1=b[1] A2=n201 Z=n217 VDD=VDD VSS=VSS
XU189 oai22d1 $PINS A1=n218 A2=n216 B1=n214 B2=n219 ZN=n81 VDD=VDD VSS=VSS
XU190 xr02d1 $PINS A1=b[2] A2=n201 Z=n218 VDD=VDD VSS=VSS
XU191 oai22d1 $PINS A1=n219 A2=n216 B1=n214 B2=n220 ZN=n80 VDD=VDD VSS=VSS
XU192 xr02d1 $PINS A1=b[3] A2=n201 Z=n219 VDD=VDD VSS=VSS
XU193 oai22d1 $PINS A1=n220 A2=n216 B1=n214 B2=n221 ZN=n79 VDD=VDD VSS=VSS
XU194 xr02d1 $PINS A1=b[4] A2=n201 Z=n220 VDD=VDD VSS=VSS
XU195 nr02d0 $PINS A1=n223 A2=n205 ZN=n76 VDD=VDD VSS=VSS
XU196 oai22d1 $PINS A1=n225 A2=n224 B1=n223 B2=n226 ZN=n75 VDD=VDD VSS=VSS
XctmTdsLR_2_2934 aoim21d1 $PINS B1=n92 B2=n60 A=n14 ZN=product[1] VDD=VDD
+ VSS=VSS
XU198 oai22d1 $PINS A1=n226 A2=n225 B1=n223 B2=n227 ZN=n74 VDD=VDD VSS=VSS
XU199 xr02d1 $PINS A1=b[1] A2=n198 Z=n226 VDD=VDD VSS=VSS
XU200 oai22d1 $PINS A1=n227 A2=n225 B1=n223 B2=n228 ZN=n73 VDD=VDD VSS=VSS
XU201 xr02d1 $PINS A1=b[2] A2=n198 Z=n227 VDD=VDD VSS=VSS
XU202 oai22d1 $PINS A1=n228 A2=n225 B1=n223 B2=n229 ZN=n72 VDD=VDD VSS=VSS
XU203 xr02d1 $PINS A1=b[3] A2=n198 Z=n228 VDD=VDD VSS=VSS
XU204 oai22d1 $PINS A1=n229 A2=n225 B1=n223 B2=n230 ZN=n71 VDD=VDD VSS=VSS
XU205 xr02d1 $PINS A1=b[4] A2=n198 Z=n229 VDD=VDD VSS=VSS
XU206 oai22d1 $PINS A1=n230 A2=n225 B1=n223 B2=n231 ZN=n70 VDD=VDD VSS=VSS
XU207 xr02d1 $PINS A1=b[5] A2=n198 Z=n230 VDD=VDD VSS=VSS
XU208 nr02d0 $PINS A1=n233 A2=n205 ZN=n68 VDD=VDD VSS=VSS
XU209 oai22d1 $PINS A1=n234 A2=n235 B1=n236 B2=n233 ZN=n67 VDD=VDD VSS=VSS
XctmTdsLR_2_2944 aoim21d1 $PINS B1=n58 B2=n75 A=n51 ZN=n52 VDD=VDD VSS=VSS
XU211 oai22d1 $PINS A1=n237 A2=n235 B1=n233 B2=n238 ZN=n65 VDD=VDD VSS=VSS
XU212 oai22d1 $PINS A1=n238 A2=n235 B1=n233 B2=n239 ZN=n64 VDD=VDD VSS=VSS
XU213 xr02d1 $PINS A1=b[3] A2=gre_a_INV_2941_2 Z=n238 VDD=VDD VSS=VSS
XU214 oai22d1 $PINS A1=n239 A2=n235 B1=n233 B2=n240 ZN=n63 VDD=VDD VSS=VSS
XU215 xr02d1 $PINS A1=b[4] A2=gre_a_INV_2941_2 Z=n239 VDD=VDD VSS=VSS
XU216 oai22d1 $PINS A1=n240 A2=n235 B1=n233 B2=n241 ZN=n62 VDD=VDD VSS=VSS
XU217 xr02d1 $PINS A1=b[5] A2=gre_a_INV_2941_2 Z=n240 VDD=VDD VSS=VSS
XU218 oai21d1 $PINS B1=n203 B2=b[0] A=n206 ZN=n60 VDD=VDD VSS=VSS
XU219 oai21d1 $PINS B1=n201 B2=n216 A=n243 ZN=n59 VDD=VDD VSS=VSS
XU220 nd03d0 $PINS A1=n202 A2=n205 A3=a[3] ZN=n243 VDD=VDD VSS=VSS
XU221 oai21d1 $PINS B1=n198 B2=n225 A=n244 ZN=n58 VDD=VDD VSS=VSS
XU222 nd03d0 $PINS A1=n199 A2=n205 A3=a[5] ZN=n244 VDD=VDD VSS=VSS
XU223 oai21d1 $PINS B1=gre_a_INV_2941_2 B2=n235 A=n245 ZN=n57 VDD=VDD VSS=VSS
XU224 nd03d0 $PINS A1=n196 A2=n205 A3=a[7] ZN=n245 VDD=VDD VSS=VSS
XU225 xn02d1 $PINS A1=n246 A2=n247 ZN=n38 VDD=VDD VSS=VSS
XU226 or02d0 $PINS A1=n247 A2=n246 Z=n37 VDD=VDD VSS=VSS
XU227 oai22d1 $PINS A1=n236 A2=n235 B1=n233 B2=n237 ZN=n246 VDD=VDD VSS=VSS
XU228 xr02d1 $PINS A1=b[2] A2=gre_a_INV_2941_2 Z=n237 VDD=VDD VSS=VSS
XU229 xr02d1 $PINS A1=b[1] A2=gre_a_INV_2941_2 Z=n236 VDD=VDD VSS=VSS
XU230 oai22d1 $PINS A1=n221 A2=n216 B1=n214 B2=n248 ZN=n247 VDD=VDD VSS=VSS
XU231 xr02d1 $PINS A1=b[5] A2=n201 Z=n221 VDD=VDD VSS=VSS
XU232 aoim22d1 $PINS A1=n202 A2=n222 B1=n248 B2=n216 Z=n32 VDD=VDD VSS=VSS
XU233 xr02d1 $PINS A1=a[3] A2=a[2] Z=n249 VDD=VDD VSS=VSS
XU234 xr02d1 $PINS A1=b[6] A2=n201 Z=n248 VDD=VDD VSS=VSS
XU235 xr02d1 $PINS A1=b[7] A2=a[3] Z=n222 VDD=VDD VSS=VSS
XU236 aoim22d1 $PINS A1=n199 A2=n232 B1=n231 B2=n225 Z=n22 VDD=VDD VSS=VSS
XU237 xr02d1 $PINS A1=a[5] A2=a[4] Z=n250 VDD=VDD VSS=VSS
XU238 xr02d1 $PINS A1=b[6] A2=n198 Z=n231 VDD=VDD VSS=VSS
XU239 xr02d1 $PINS A1=b[7] A2=a[5] Z=n232 VDD=VDD VSS=VSS
XU240 aoim22d1 $PINS A1=n196 A2=n242 B1=n241 B2=n235 Z=n16 VDD=VDD VSS=VSS
XU241 xr02d1 $PINS A1=a[7] A2=a[6] Z=n251 VDD=VDD VSS=VSS
XU242 xr02d1 $PINS A1=b[6] A2=gre_a_INV_2941_2 Z=n241 VDD=VDD VSS=VSS
XU243 xr02d1 $PINS A1=b[7] A2=a[7] Z=n242 VDD=VDD VSS=VSS
XctmTdsLR_1_1330 aoim22d1 $PINS A1=n201 A2=b[0] B1=n201 B2=b[0] Z=n215 VDD=VDD
+ VSS=VSS
XctmTdsLR_1_1331 aoim22d1 $PINS A1=n198 A2=b[0] B1=n198 B2=b[0] Z=n224 VDD=VDD
+ VSS=VSS
XctmTdsLR_1_1332 aoim22d1 $PINS A1=gre_a_INV_2941_2 A2=b[0] B1=gre_a_INV_2941_2
+ B2=b[0] Z=n234 VDD=VDD VSS=VSS
XctmTdsLR_1_2945 an02d1 $PINS A1=n67 A2=n57 Z=n43 VDD=VDD VSS=VSS
XctmTdsLR_2_2946 aoim21d1 $PINS B1=n67 B2=n57 A=n43 ZN=n44 VDD=VDD VSS=VSS
.ENDS

.SUBCKT unpu_pe_7_DW_mult_uns_0_DW_mult_uns_14 a[7] a[6] a[5] a[4] a[3] a[2]
+ a[1] a[0] b[7] b[6] b[5] b[4] b[3] b[2] b[1] b[0] product[15] product[14]
+ product[13] product[12] product[11] product[10] product[9] product[8]
+ product[7] product[6] product[5] product[4] product[3] product[2] product[1]
+ product[0] VDD VSS
XU2 ad01d0 $PINS A=n99 B=n15 CI=n2 CO=product[15] S=product[14] VDD=VDD VSS=VSS
XU3 ad01d0 $PINS A=n16 B=n17 CI=n3 CO=n2 S=product[13] VDD=VDD VSS=VSS
XU4 ad01d0 $PINS A=n18 B=n21 CI=n4 CO=n3 S=product[12] VDD=VDD VSS=VSS
XU5 ad01d0 $PINS A=n27 B=n22 CI=n5 CO=n4 S=product[11] VDD=VDD VSS=VSS
XU6 ad01d0 $PINS A=n35 B=n28 CI=n6 CO=n5 S=product[10] VDD=VDD VSS=VSS
XU7 ad01d0 $PINS A=n45 B=n36 CI=n7 CO=n6 S=product[9] VDD=VDD VSS=VSS
XU8 ad01d0 $PINS A=n57 B=n46 CI=n8 CO=n7 S=product[8] VDD=VDD VSS=VSS
XU9 ad01d0 $PINS A=n69 B=n58 CI=n9 CO=n8 S=product[7] VDD=VDD VSS=VSS
XU10 ad01d0 $PINS A=n79 B=n70 CI=n10 CO=n9 S=product[6] VDD=VDD VSS=VSS
XU11 ad01d0 $PINS A=n87 B=n80 CI=n11 CO=n10 S=product[5] VDD=VDD VSS=VSS
XU12 ad01d0 $PINS A=n93 B=n88 CI=n12 CO=n11 S=product[4] VDD=VDD VSS=VSS
XU13 ad01d0 $PINS A=n96 B=n13 CI=n94 CO=n12 S=product[3] VDD=VDD VSS=VSS
XU14 ad01d0 $PINS A=n146 B=n14 CI=n98 CO=n13 S=product[2] VDD=VDD VSS=VSS
XU15 ah01d1 $PINS A=n161 B=n154 CO=n14 S=product[1] VDD=VDD VSS=VSS
XU16 ad01d0 $PINS A=n107 B=n100 CI=n19 CO=n15 S=n16 VDD=VDD VSS=VSS
XU17 ad01d0 $PINS A=n25 B=n20 CI=n23 CO=n17 S=n18 VDD=VDD VSS=VSS
XU18 ad01d0 $PINS A=n115 B=n101 CI=n108 CO=n19 S=n20 VDD=VDD VSS=VSS
XU19 ad01d0 $PINS A=n31 B=n24 CI=n29 CO=n21 S=n22 VDD=VDD VSS=VSS
XU20 ad01d0 $PINS A=n116 B=n33 CI=n26 CO=n23 S=n24 VDD=VDD VSS=VSS
XU21 ad01d0 $PINS A=n123 B=n102 CI=n109 CO=n25 S=n26 VDD=VDD VSS=VSS
XU22 ad01d0 $PINS A=n32 B=n37 CI=n30 CO=n27 S=n28 VDD=VDD VSS=VSS
XU23 ad01d0 $PINS A=n41 B=n34 CI=n39 CO=n29 S=n30 VDD=VDD VSS=VSS
XU24 ad01d0 $PINS A=n124 B=n117 CI=n43 CO=n31 S=n32 VDD=VDD VSS=VSS
XU25 ad01d0 $PINS A=n131 B=n103 CI=n110 CO=n33 S=n34 VDD=VDD VSS=VSS
XU26 ad01d0 $PINS A=n40 B=n47 CI=n38 CO=n35 S=n36 VDD=VDD VSS=VSS
XU27 ad01d0 $PINS A=n44 B=n51 CI=n49 CO=n37 S=n38 VDD=VDD VSS=VSS
XU28 ad01d0 $PINS A=n55 B=n53 CI=n42 CO=n39 S=n40 VDD=VDD VSS=VSS
XU29 ad01d0 $PINS A=n118 B=n125 CI=n132 CO=n41 S=n42 VDD=VDD VSS=VSS
XU30 ad01d0 $PINS A=n139 B=n104 CI=n111 CO=n43 S=n44 VDD=VDD VSS=VSS
XU31 ad01d0 $PINS A=n50 B=n59 CI=n48 CO=n45 S=n46 VDD=VDD VSS=VSS
XU32 ad01d0 $PINS A=n54 B=n52 CI=n61 CO=n47 S=n48 VDD=VDD VSS=VSS
XU33 ad01d0 $PINS A=n56 B=n65 CI=n63 CO=n49 S=n50 VDD=VDD VSS=VSS
XU34 ad01d0 $PINS A=n140 B=n133 CI=n67 CO=n51 S=n52 VDD=VDD VSS=VSS
XU35 ad01d0 $PINS A=n126 B=n119 CI=n147 CO=n53 S=n54 VDD=VDD VSS=VSS
XU36 ah01d1 $PINS A=n105 B=n112 CO=n55 S=n56 VDD=VDD VSS=VSS
XU37 ad01d0 $PINS A=n71 B=n62 CI=n60 CO=n57 S=n58 VDD=VDD VSS=VSS
XU38 ad01d0 $PINS A=n64 B=n66 CI=n73 CO=n59 S=n60 VDD=VDD VSS=VSS
XU39 ad01d0 $PINS A=n77 B=n68 CI=n75 CO=n61 S=n62 VDD=VDD VSS=VSS
XU40 ad01d0 $PINS A=n141 B=n127 CI=n134 CO=n63 S=n64 VDD=VDD VSS=VSS
XU41 ad01d0 $PINS A=n155 B=n120 CI=n148 CO=n65 S=n66 VDD=VDD VSS=VSS
XU42 ah01d1 $PINS A=n106 B=n113 CO=n67 S=n68 VDD=VDD VSS=VSS
XU43 ad01d0 $PINS A=n81 B=n74 CI=n72 CO=n69 S=n70 VDD=VDD VSS=VSS
XU44 ad01d0 $PINS A=n78 B=n83 CI=n76 CO=n71 S=n72 VDD=VDD VSS=VSS
XU45 ad01d0 $PINS A=n142 B=n135 CI=n85 CO=n73 S=n74 VDD=VDD VSS=VSS
XU46 ad01d0 $PINS A=n156 B=n128 CI=n149 CO=n75 S=n76 VDD=VDD VSS=VSS
XU47 ah01d1 $PINS A=n114 B=n121 CO=n77 S=n78 VDD=VDD VSS=VSS
XU48 ad01d0 $PINS A=n89 B=n84 CI=n82 CO=n79 S=n80 VDD=VDD VSS=VSS
XU49 ad01d0 $PINS A=n150 B=n91 CI=n86 CO=n81 S=n82 VDD=VDD VSS=VSS
XU50 ad01d0 $PINS A=n157 B=n136 CI=n143 CO=n83 S=n84 VDD=VDD VSS=VSS
XU51 ah01d1 $PINS A=n122 B=n129 CO=n85 S=n86 VDD=VDD VSS=VSS
XU52 ad01d0 $PINS A=n95 B=n92 CI=n90 CO=n87 S=n88 VDD=VDD VSS=VSS
XU53 ad01d0 $PINS A=n158 B=n144 CI=n151 CO=n89 S=n90 VDD=VDD VSS=VSS
XU54 ah01d1 $PINS A=n130 B=n137 CO=n91 S=n92 VDD=VDD VSS=VSS
XU55 ad01d0 $PINS A=n159 B=n152 CI=n97 CO=n93 S=n94 VDD=VDD VSS=VSS
XU56 ah01d1 $PINS A=n138 B=n145 CO=n95 S=n96 VDD=VDD VSS=VSS
XU57 ah01d1 $PINS A=n153 B=n160 CO=n97 S=n98 VDD=VDD VSS=VSS
XU140 inv0d0 $PINS I=b[4] ZN=n225 VDD=VDD VSS=VSS
XU141 inv0d0 $PINS I=a[1] ZN=n220 VDD=VDD VSS=VSS
XU142 inv0d0 $PINS I=b[2] ZN=n227 VDD=VDD VSS=VSS
XU144 inv0d0 $PINS I=a[2] ZN=n219 VDD=VDD VSS=VSS
XU145 inv0d0 $PINS I=b[3] ZN=n226 VDD=VDD VSS=VSS
XU146 inv0d0 $PINS I=a[5] ZN=n216 VDD=VDD VSS=VSS
XU147 inv0d0 $PINS I=b[1] ZN=n228 VDD=VDD VSS=VSS
XU148 inv0d0 $PINS I=b[0] ZN=n229 VDD=VDD VSS=VSS
XU149 inv0d0 $PINS I=a[4] ZN=n217 VDD=VDD VSS=VSS
XU150 inv0d0 $PINS I=b[6] ZN=n223 VDD=VDD VSS=VSS
XU151 inv0d0 $PINS I=a[3] ZN=n218 VDD=VDD VSS=VSS
XU152 inv0d0 $PINS I=b[5] ZN=n224 VDD=VDD VSS=VSS
XU153 inv0d0 $PINS I=b[7] ZN=n222 VDD=VDD VSS=VSS
XU154 inv0d0 $PINS I=a[6] ZN=n215 VDD=VDD VSS=VSS
XU156 nr02d0 $PINS A1=a[0] A2=n229 ZN=product[0] VDD=VDD VSS=VSS
XU157 nr02d0 $PINS A1=a[7] A2=n222 ZN=n99 VDD=VDD VSS=VSS
XU158 nr02d0 $PINS A1=a[0] A2=n228 ZN=n161 VDD=VDD VSS=VSS
XU159 nr02d0 $PINS A1=a[0] A2=n227 ZN=n160 VDD=VDD VSS=VSS
XU160 nr02d0 $PINS A1=a[0] A2=n226 ZN=n159 VDD=VDD VSS=VSS
XU161 nr02d0 $PINS A1=a[0] A2=n225 ZN=n158 VDD=VDD VSS=VSS
XU162 nr02d0 $PINS A1=a[0] A2=n224 ZN=n157 VDD=VDD VSS=VSS
XU163 nr02d0 $PINS A1=a[0] A2=n223 ZN=n156 VDD=VDD VSS=VSS
XU164 nr02d0 $PINS A1=a[0] A2=n222 ZN=n155 VDD=VDD VSS=VSS
XU165 nr02d0 $PINS A1=n229 A2=n220 ZN=n154 VDD=VDD VSS=VSS
XU166 nr02d0 $PINS A1=n228 A2=n220 ZN=n153 VDD=VDD VSS=VSS
XU167 nr02d0 $PINS A1=n227 A2=n220 ZN=n152 VDD=VDD VSS=VSS
XU168 nr02d0 $PINS A1=n226 A2=n220 ZN=n151 VDD=VDD VSS=VSS
XU169 nr02d0 $PINS A1=n225 A2=n220 ZN=n150 VDD=VDD VSS=VSS
XU170 nr02d0 $PINS A1=n224 A2=n220 ZN=n149 VDD=VDD VSS=VSS
XU171 nr02d0 $PINS A1=n223 A2=n220 ZN=n148 VDD=VDD VSS=VSS
XU172 nr02d0 $PINS A1=n222 A2=n220 ZN=n147 VDD=VDD VSS=VSS
XU173 nr02d0 $PINS A1=n229 A2=n219 ZN=n146 VDD=VDD VSS=VSS
XU174 nr02d0 $PINS A1=n228 A2=n219 ZN=n145 VDD=VDD VSS=VSS
XU175 nr02d0 $PINS A1=n227 A2=n219 ZN=n144 VDD=VDD VSS=VSS
XU176 nr02d0 $PINS A1=n226 A2=n219 ZN=n143 VDD=VDD VSS=VSS
XU177 nr02d0 $PINS A1=n225 A2=n219 ZN=n142 VDD=VDD VSS=VSS
XU178 nr02d0 $PINS A1=n224 A2=n219 ZN=n141 VDD=VDD VSS=VSS
XU179 nr02d0 $PINS A1=n223 A2=n219 ZN=n140 VDD=VDD VSS=VSS
XU180 nr02d0 $PINS A1=n222 A2=n219 ZN=n139 VDD=VDD VSS=VSS
XU181 nr02d0 $PINS A1=n229 A2=n218 ZN=n138 VDD=VDD VSS=VSS
XU182 nr02d0 $PINS A1=n228 A2=n218 ZN=n137 VDD=VDD VSS=VSS
XU183 nr02d0 $PINS A1=n227 A2=n218 ZN=n136 VDD=VDD VSS=VSS
XU184 nr02d0 $PINS A1=n226 A2=n218 ZN=n135 VDD=VDD VSS=VSS
XU185 nr02d0 $PINS A1=n225 A2=n218 ZN=n134 VDD=VDD VSS=VSS
XU186 nr02d0 $PINS A1=n224 A2=n218 ZN=n133 VDD=VDD VSS=VSS
XU187 nr02d0 $PINS A1=n223 A2=n218 ZN=n132 VDD=VDD VSS=VSS
XU188 nr02d0 $PINS A1=n222 A2=n218 ZN=n131 VDD=VDD VSS=VSS
XU189 nr02d0 $PINS A1=n229 A2=n217 ZN=n130 VDD=VDD VSS=VSS
XU190 nr02d0 $PINS A1=n228 A2=n217 ZN=n129 VDD=VDD VSS=VSS
XU191 nr02d0 $PINS A1=n227 A2=n217 ZN=n128 VDD=VDD VSS=VSS
XU192 nr02d0 $PINS A1=n226 A2=n217 ZN=n127 VDD=VDD VSS=VSS
XU193 nr02d0 $PINS A1=n225 A2=n217 ZN=n126 VDD=VDD VSS=VSS
XU194 nr02d0 $PINS A1=n224 A2=n217 ZN=n125 VDD=VDD VSS=VSS
XU195 nr02d0 $PINS A1=n223 A2=n217 ZN=n124 VDD=VDD VSS=VSS
XU196 nr02d0 $PINS A1=n222 A2=n217 ZN=n123 VDD=VDD VSS=VSS
XU197 nr02d0 $PINS A1=n229 A2=n216 ZN=n122 VDD=VDD VSS=VSS
XU198 nr02d0 $PINS A1=n228 A2=n216 ZN=n121 VDD=VDD VSS=VSS
XU199 nr02d0 $PINS A1=n227 A2=n216 ZN=n120 VDD=VDD VSS=VSS
XU200 nr02d0 $PINS A1=n226 A2=n216 ZN=n119 VDD=VDD VSS=VSS
XU201 nr02d0 $PINS A1=n225 A2=n216 ZN=n118 VDD=VDD VSS=VSS
XU202 nr02d0 $PINS A1=n224 A2=n216 ZN=n117 VDD=VDD VSS=VSS
XU203 nr02d0 $PINS A1=n223 A2=n216 ZN=n116 VDD=VDD VSS=VSS
XU204 nr02d0 $PINS A1=n222 A2=n216 ZN=n115 VDD=VDD VSS=VSS
XU205 nr02d0 $PINS A1=n229 A2=n215 ZN=n114 VDD=VDD VSS=VSS
XU206 nr02d0 $PINS A1=n228 A2=n215 ZN=n113 VDD=VDD VSS=VSS
XU207 nr02d0 $PINS A1=n227 A2=n215 ZN=n112 VDD=VDD VSS=VSS
XU208 nr02d0 $PINS A1=n226 A2=n215 ZN=n111 VDD=VDD VSS=VSS
XU209 nr02d0 $PINS A1=n225 A2=n215 ZN=n110 VDD=VDD VSS=VSS
XU210 nr02d0 $PINS A1=n224 A2=n215 ZN=n109 VDD=VDD VSS=VSS
XU211 nr02d0 $PINS A1=n223 A2=n215 ZN=n108 VDD=VDD VSS=VSS
XU212 nr02d0 $PINS A1=n222 A2=n215 ZN=n107 VDD=VDD VSS=VSS
XU213 nr02d0 $PINS A1=n229 A2=a[7] ZN=n106 VDD=VDD VSS=VSS
XU214 nr02d0 $PINS A1=a[7] A2=n228 ZN=n105 VDD=VDD VSS=VSS
XU215 nr02d0 $PINS A1=a[7] A2=n227 ZN=n104 VDD=VDD VSS=VSS
XU216 nr02d0 $PINS A1=a[7] A2=n226 ZN=n103 VDD=VDD VSS=VSS
XU217 nr02d0 $PINS A1=a[7] A2=n225 ZN=n102 VDD=VDD VSS=VSS
XU218 nr02d0 $PINS A1=a[7] A2=n224 ZN=n101 VDD=VDD VSS=VSS
XU219 nr02d0 $PINS A1=a[7] A2=n223 ZN=n100 VDD=VDD VSS=VSS
.ENDS

.SUBCKT unpu_pe_7_DW01_add_0_DW01_add_8 A[31] A[30] A[29] A[28] A[27] A[26]
+ A[25] A[24] A[23] A[22] A[21] A[20] A[19] A[18] A[17] A[16] A[15] A[14] A[13]
+ A[12] A[11] A[10] A[9] A[8] A[7] A[6] A[5] A[4] A[3] A[2] A[1] A[0] B[31]
+ B[30] B[29] B[28] B[27] B[26] B[25] B[24] B[23] B[22] B[21] B[20] B[19] B[18]
+ B[17] B[16] B[15] B[14] B[13] B[12] B[11] B[10] B[9] B[8] B[7] B[6] B[5] B[4]
+ B[3] B[2] B[1] B[0] CI SUM[31] SUM[30] SUM[29] SUM[28] SUM[27] SUM[26]
+ SUM[25] SUM[24] SUM[23] SUM[22] SUM[21] SUM[20] SUM[19] SUM[18] SUM[17]
+ SUM[16] SUM[15] SUM[14] SUM[13] SUM[12] SUM[11] SUM[10] SUM[9] SUM[8] SUM[7]
+ SUM[6] SUM[5] SUM[4] SUM[3] SUM[2] SUM[1] SUM[0] CO VDD VSS
XU1_31 ad01d0 $PINS A=copt_net_1747 B=B[31] CI=carry[31] S=SUM[31] VDD=VDD
+ VSS=VSS
XU1_30 ad01d0 $PINS A=copt_net_1803 B=B[30] CI=carry[30] CO=carry[31] S=SUM[30]
+ VDD=VDD VSS=VSS
XU1_29 ad01d0 $PINS A=copt_net_1385 B=B[29] CI=carry[29] CO=carry[30] S=SUM[29]
+ VDD=VDD VSS=VSS
XU1_28 ad01d0 $PINS A=copt_net_1855 B=B[28] CI=carry[28] CO=carry[29] S=SUM[28]
+ VDD=VDD VSS=VSS
XU1_27 ad01d0 $PINS A=copt_net_1279 B=B[27] CI=carry[27] CO=carry[28] S=SUM[27]
+ VDD=VDD VSS=VSS
XU1_26 ad01d0 $PINS A=copt_net_1655 B=B[26] CI=carry[26] CO=carry[27] S=SUM[26]
+ VDD=VDD VSS=VSS
XU1_25 ad01d0 $PINS A=copt_net_1961 B=B[25] CI=carry[25] CO=carry[26] S=SUM[25]
+ VDD=VDD VSS=VSS
XU1_24 ad01d0 $PINS A=copt_net_1359 B=B[24] CI=carry[24] CO=carry[25] S=SUM[24]
+ VDD=VDD VSS=VSS
XU1_23 ad01d0 $PINS A=copt_net_1492 B=B[23] CI=carry[23] CO=carry[24] S=SUM[23]
+ VDD=VDD VSS=VSS
XU1_22 ad01d0 $PINS A=copt_net_1595 B=B[22] CI=carry[22] CO=carry[23] S=SUM[22]
+ VDD=VDD VSS=VSS
XU1_21 ad01d0 $PINS A=copt_net_1525 B=B[21] CI=carry[21] CO=carry[22] S=SUM[21]
+ VDD=VDD VSS=VSS
XU1_20 ad01d0 $PINS A=copt_net_1754 B=B[20] CI=carry[20] CO=carry[21] S=SUM[20]
+ VDD=VDD VSS=VSS
XU1_19 ad01d1 $PINS A=copt_net_1800 B=B[19] CI=carry[19] CO=carry[20] S=SUM[19]
+ VDD=VDD VSS=VSS
XU1_18 ad01d1 $PINS A=copt_net_1486 B=B[18] CI=carry[18] CO=carry[19] S=SUM[18]
+ VDD=VDD VSS=VSS
XU1_17 ad01d0 $PINS A=copt_net_1785 B=B[17] CI=carry[17] CO=carry[18] S=SUM[17]
+ VDD=VDD VSS=VSS
XU1_16 ad01d1 $PINS A=copt_net_1599 B=B[16] CI=carry[16] CO=carry[17] S=SUM[16]
+ VDD=VDD VSS=VSS
XU1_15 ad01d0 $PINS A=copt_net_1552 B=B[15] CI=carry[15] CO=carry[16] S=SUM[15]
+ VDD=VDD VSS=VSS
XU1_14 ad01d1 $PINS A=copt_net_1649 B=B[14] CI=carry[14] CO=carry[15] S=SUM[14]
+ VDD=VDD VSS=VSS
XU1_13 ad01d0 $PINS A=copt_net_1579 B=B[13] CI=carry[13] CO=carry[14] S=SUM[13]
+ VDD=VDD VSS=VSS
XU1_12 ad01d0 $PINS A=copt_net_1709 B=B[12] CI=carry[12] CO=carry[13] S=SUM[12]
+ VDD=VDD VSS=VSS
XU1_11 ad01d1 $PINS A=copt_net_1753 B=B[11] CI=carry[11] CO=carry[12] S=SUM[11]
+ VDD=VDD VSS=VSS
XU1_10 ad01d1 $PINS A=copt_net_1660 B=B[10] CI=carry[10] CO=carry[11] S=SUM[10]
+ VDD=VDD VSS=VSS
XU1_9 ad01d0 $PINS A=copt_net_1611 B=B[9] CI=carry[9] CO=carry[10] S=SUM[9]
+ VDD=VDD VSS=VSS
XU1_8 ad01d1 $PINS A=copt_net_1856 B=B[8] CI=carry[8] CO=carry[9] S=SUM[8]
+ VDD=VDD VSS=VSS
XU1_7 ad01d1 $PINS A=copt_net_1765 B=B[7] CI=carry[7] CO=carry[8] S=SUM[7]
+ VDD=VDD VSS=VSS
XU1_6 ad01d1 $PINS A=copt_net_1713 B=B[6] CI=carry[6] CO=carry[7] S=SUM[6]
+ VDD=VDD VSS=VSS
XU1_5 ad01d1 $PINS A=copt_net_1748 B=B[5] CI=carry[5] CO=carry[6] S=SUM[5]
+ VDD=VDD VSS=VSS
XU1_4 ad01d0 $PINS A=copt_net_1752 B=B[4] CI=carry[4] CO=carry[5] S=SUM[4]
+ VDD=VDD VSS=VSS
XU1_3 ad01d1 $PINS A=copt_net_1512 B=B[3] CI=carry[3] CO=carry[4] S=SUM[3]
+ VDD=VDD VSS=VSS
XU1_2 ad01d4 $PINS A=copt_net_1583 B=B[2] CI=carry[2] CO=carry[3] S=SUM[2]
+ VDD=VDD VSS=VSS
XU1_1 ad01d0 $PINS A=copt_net_2018 B=B[1] CI=n1 CO=carry[2] S=SUM[1] VDD=VDD
+ VSS=VSS
XU1 an02d1 $PINS A1=B[0] A2=copt_net_1109 Z=n1 VDD=VDD VSS=VSS
XU2 xr02d1 $PINS A1=copt_net_1109 A2=B[0] Z=SUM[0] VDD=VDD VSS=VSS
Xcopt_h_inst_3941 dl01d1 $PINS I=A[0] Z=copt_net_1109 VDD=VDD VSS=VSS
Xcopt_h_inst_4111 dl01d1 $PINS I=A[27] Z=copt_net_1279 VDD=VDD VSS=VSS
Xcopt_h_inst_4191 dl01d1 $PINS I=A[24] Z=copt_net_1359 VDD=VDD VSS=VSS
Xcopt_h_inst_4217 dl01d1 $PINS I=A[29] Z=copt_net_1385 VDD=VDD VSS=VSS
Xcopt_h_inst_4318 dl01d1 $PINS I=A[18] Z=copt_net_1486 VDD=VDD VSS=VSS
Xcopt_h_inst_4324 dl01d1 $PINS I=A[23] Z=copt_net_1492 VDD=VDD VSS=VSS
Xcopt_h_inst_4344 dl01d1 $PINS I=A[3] Z=copt_net_1512 VDD=VDD VSS=VSS
Xcopt_h_inst_4357 dl01d1 $PINS I=A[21] Z=copt_net_1525 VDD=VDD VSS=VSS
Xcopt_h_inst_4384 dl01d1 $PINS I=A[15] Z=copt_net_1552 VDD=VDD VSS=VSS
Xcopt_h_inst_4411 dl02d1 $PINS I=A[13] Z=copt_net_1579 VDD=VDD VSS=VSS
Xcopt_h_inst_4415 dl01d1 $PINS I=A[2] Z=copt_net_1583 VDD=VDD VSS=VSS
Xcopt_h_inst_4427 dl02d1 $PINS I=A[22] Z=copt_net_1595 VDD=VDD VSS=VSS
Xcopt_h_inst_4431 dl01d1 $PINS I=A[16] Z=copt_net_1599 VDD=VDD VSS=VSS
Xcopt_h_inst_4443 dl01d1 $PINS I=A[9] Z=copt_net_1611 VDD=VDD VSS=VSS
Xcopt_h_inst_4481 dl01d1 $PINS I=A[14] Z=copt_net_1649 VDD=VDD VSS=VSS
Xcopt_h_inst_4487 dl02d1 $PINS I=A[26] Z=copt_net_1655 VDD=VDD VSS=VSS
Xcopt_h_inst_4492 dl01d1 $PINS I=A[10] Z=copt_net_1660 VDD=VDD VSS=VSS
Xcopt_h_inst_4541 dl01d1 $PINS I=A[12] Z=copt_net_1709 VDD=VDD VSS=VSS
Xcopt_h_inst_4545 dl01d1 $PINS I=A[6] Z=copt_net_1713 VDD=VDD VSS=VSS
Xcopt_h_inst_4579 dl02d1 $PINS I=A[31] Z=copt_net_1747 VDD=VDD VSS=VSS
Xcopt_h_inst_4580 dl01d1 $PINS I=A[5] Z=copt_net_1748 VDD=VDD VSS=VSS
Xcopt_h_inst_4584 dl01d1 $PINS I=A[4] Z=copt_net_1752 VDD=VDD VSS=VSS
Xcopt_h_inst_4585 dl01d1 $PINS I=A[11] Z=copt_net_1753 VDD=VDD VSS=VSS
Xcopt_h_inst_4586 dl02d1 $PINS I=A[20] Z=copt_net_1754 VDD=VDD VSS=VSS
Xcopt_h_inst_4597 dl02d1 $PINS I=A[7] Z=copt_net_1765 VDD=VDD VSS=VSS
Xcopt_h_inst_4617 dl02d1 $PINS I=A[17] Z=copt_net_1785 VDD=VDD VSS=VSS
Xcopt_h_inst_4632 dl02d1 $PINS I=A[19] Z=copt_net_1800 VDD=VDD VSS=VSS
Xcopt_h_inst_4635 dl02d1 $PINS I=A[30] Z=copt_net_1803 VDD=VDD VSS=VSS
Xcopt_h_inst_4687 dl02d1 $PINS I=A[28] Z=copt_net_1855 VDD=VDD VSS=VSS
Xcopt_h_inst_4688 dl02d1 $PINS I=A[8] Z=copt_net_1856 VDD=VDD VSS=VSS
Xcopt_h_inst_4794 dl02d1 $PINS I=A[25] Z=copt_net_1961 VDD=VDD VSS=VSS
Xcopt_h_inst_4851 dl01d1 $PINS I=A[1] Z=copt_net_2018 VDD=VDD VSS=VSS
.ENDS

.SUBCKT unpu_pe_7 clk rst_n array_en weight_load mode_unsigned weight_in[7]
+ weight_in[6] weight_in[5] weight_in[4] weight_in[3] weight_in[2] weight_in[1]
+ weight_in[0] act_in[7] act_in[6] act_in[5] act_in[4] act_in[3] act_in[2]
+ act_in[1] act_in[0] psum_in[31] psum_in[30] psum_in[29] psum_in[28]
+ psum_in[27] psum_in[26] psum_in[25] psum_in[24] psum_in[23] psum_in[22]
+ psum_in[21] psum_in[20] psum_in[19] psum_in[18] psum_in[17] psum_in[16]
+ psum_in[15] psum_in[14] psum_in[13] psum_in[12] psum_in[11] psum_in[10]
+ psum_in[9] psum_in[8] psum_in[7] psum_in[6] psum_in[5] psum_in[4] psum_in[3]
+ psum_in[2] psum_in[1] psum_in[0] act_out[7] act_out[6] act_out[5] act_out[4]
+ act_out[3] act_out[2] act_out[1] act_out[0] psum_out[31] psum_out[30]
+ psum_out[29] psum_out[28] psum_out[27] psum_out[26] psum_out[25] psum_out[24]
+ psum_out[23] psum_out[22] psum_out[21] psum_out[20] psum_out[19] psum_out[18]
+ psum_out[17] psum_out[16] psum_out[15] psum_out[14] psum_out[13] psum_out[12]
+ psum_out[11] psum_out[10] psum_out[9] psum_out[8] psum_out[7] psum_out[6]
+ psum_out[5] psum_out[4] psum_out[3] psum_out[2] psum_out[1] psum_out[0] VDD
+ VSS ZCTSNET_13 HFSNET_3 HFSNET_4 HFSNET_5 HFSNET_6 HFSNET_7 HFSNET_8 HFSNET_9
+ HFSNET_10 HFSNET_11 ZCTSNET_0 ZCTSNET_2 ZCTSNET_3
XU2 aor22d1 $PINS A1=N_uc_30 A2=HFSNET_3 B1=mode_unsigned B2=N_uc_14
+ Z=product[9] VDD=VDD VSS=VSS
XU3 aor22d1 $PINS A1=N_uc_29 A2=HFSNET_3 B1=N_uc_13 B2=mode_unsigned
+ Z=product[8] VDD=VDD VSS=VSS
XU5 aor22d1 $PINS A1=N_uc_28 A2=HFSNET_3 B1=N_uc_12 B2=mode_unsigned
+ Z=product[7] VDD=VDD VSS=VSS
XU6 aor22d1 $PINS A1=N_uc_27 A2=HFSNET_3 B1=N_uc_11 B2=mode_unsigned
+ Z=product[6] VDD=VDD VSS=VSS
XU7 aor22d1 $PINS A1=N_uc_26 A2=HFSNET_3 B1=N_uc_10 B2=mode_unsigned
+ Z=product[5] VDD=VDD VSS=VSS
XU8 aor22d1 $PINS A1=N_uc_9 A2=mode_unsigned B1=N_uc_25 B2=HFSNET_3
+ Z=product[4] VDD=VDD VSS=VSS
XU9 aor22d1 $PINS A1=N_uc_8 A2=mode_unsigned B1=N_uc_24 B2=HFSNET_3
+ Z=product[3] VDD=VDD VSS=VSS
XU10 aor22d1 $PINS A1=N_uc_7 A2=mode_unsigned B1=N_uc_23 B2=HFSNET_3
+ Z=product[2] VDD=VDD VSS=VSS
XU11 aor22d1 $PINS A1=N_uc_6 A2=mode_unsigned B1=N_uc_22 B2=HFSNET_3
+ Z=product[1] VDD=VDD VSS=VSS
XU12 oaim21d1 $PINS B1=N_uc_20 B2=mode_unsigned A=n16 ZN=product[15] VDD=VDD
+ VSS=VSS
XU13 aor22d1 $PINS A1=N_uc_35 A2=HFSNET_3 B1=N_uc_19 B2=mode_unsigned
+ Z=product[14] VDD=VDD VSS=VSS
XU14 aor22d1 $PINS A1=N_uc_34 A2=HFSNET_3 B1=N_uc_18 B2=mode_unsigned
+ Z=product[13] VDD=VDD VSS=VSS
XU15 aor22d1 $PINS A1=N_uc_33 A2=HFSNET_3 B1=N_uc_17 B2=mode_unsigned
+ Z=product[12] VDD=VDD VSS=VSS
XU16 aor22d1 $PINS A1=N_uc_32 A2=HFSNET_3 B1=N_uc_16 B2=mode_unsigned
+ Z=product[11] VDD=VDD VSS=VSS
XU17 aor22d1 $PINS A1=N_uc_31 A2=HFSNET_3 B1=N_uc_15 B2=mode_unsigned
+ Z=product[10] VDD=VDD VSS=VSS
XU18 aor22d1 $PINS A1=N_uc_5 A2=mode_unsigned B1=N_uc_21 B2=HFSNET_3
+ Z=product[0] VDD=VDD VSS=VSS
Xadd_42 unpu_pe_7_DW01_add_0_DW01_add_8 $PINS A[31]=psum_in[31]
+ A[30]=psum_in[30] A[29]=psum_in[29] A[28]=psum_in[28] A[27]=psum_in[27]
+ A[26]=psum_in[26] A[25]=psum_in[25] A[24]=psum_in[24] A[23]=psum_in[23]
+ A[22]=psum_in[22] A[21]=psum_in[21] A[20]=psum_in[20] A[19]=psum_in[19]
+ A[18]=psum_in[18] A[17]=psum_in[17] A[16]=psum_in[16] A[15]=psum_in[15]
+ A[14]=psum_in[14] A[13]=psum_in[13] A[12]=psum_in[12] A[11]=psum_in[11]
+ A[10]=psum_in[10] A[9]=psum_in[9] A[8]=psum_in[8] A[7]=psum_in[7]
+ A[6]=psum_in[6] A[5]=psum_in[5] A[4]=psum_in[4] A[3]=psum_in[3] A[2]=psum_in[2]
+ A[1]=psum_in[1] A[0]=psum_in[0] B[31]=n2 B[30]=n2 B[29]=n2 B[28]=n2 B[27]=n2
+ B[26]=n2 B[25]=n2 B[24]=n2 B[23]=n2 B[22]=n2 B[21]=n2 B[20]=n2 B[19]=n2
+ B[18]=n2 B[17]=n2 B[16]=n2 B[15]=product[15] B[14]=product[14]
+ B[13]=product[13] B[12]=product[12] B[11]=product[11] B[10]=product[10]
+ B[9]=product[9] B[8]=product[8] B[7]=product[7] B[6]=product[6] B[5]=product[5]
+ B[4]=product[4] B[3]=product[3] B[2]=product[2] B[1]=product[1] B[0]=product[0]
+ CI=VSS SUM[31]=N_uc_71 SUM[30]=N_uc_70 SUM[29]=N_uc_69 SUM[28]=N_uc_68
+ SUM[27]=N_uc_67 SUM[26]=N_uc_66 SUM[25]=N_uc_65 SUM[24]=N_uc_64 SUM[23]=N_uc_63
+ SUM[22]=N_uc_62 SUM[21]=N_uc_61 SUM[20]=N_uc_60 SUM[19]=N_uc_59 SUM[18]=N_uc_58
+ SUM[17]=N_uc_57 SUM[16]=N_uc_56 SUM[15]=N_uc_55 SUM[14]=N_uc_54 SUM[13]=N_uc_53
+ SUM[12]=N_uc_52 SUM[11]=N_uc_51 SUM[10]=N_uc_50 SUM[9]=N_uc_49 SUM[8]=N_uc_48
+ SUM[7]=N_uc_47 SUM[6]=N_uc_46 SUM[5]=N_uc_45 SUM[4]=N_uc_44 SUM[3]=N_uc_43
+ SUM[2]=N_uc_42 SUM[1]=N_uc_41 SUM[0]=N_uc_40 VDD=VDD VSS=VSS
Xmult_28 unpu_pe_7_DW_mult_uns_0_DW_mult_uns_14 $PINS a[7]=gre_a_INV_2941_3
+ a[6]=weight_reg[6] a[5]=weight_reg[5] a[4]=weight_reg[4] a[3]=weight_reg[3]
+ a[2]=weight_reg[2] a[1]=weight_reg[1] a[0]=gre_a_INV_2160_3 b[7]=act_in[7]
+ b[6]=act_in[6] b[5]=act_in[5] b[4]=act_in[4] b[3]=act_in[3] b[2]=act_in[2]
+ b[1]=act_in[1] b[0]=act_in[0] product[15]=N_uc_20 product[14]=N_uc_19
+ product[13]=N_uc_18 product[12]=N_uc_17 product[11]=N_uc_16 product[10]=N_uc_15
+ product[9]=N_uc_14 product[8]=N_uc_13 product[7]=N_uc_12 product[6]=N_uc_11
+ product[5]=N_uc_10 product[4]=N_uc_9 product[3]=N_uc_8 product[2]=N_uc_7
+ product[1]=N_uc_6 product[0]=N_uc_5 VDD=VDD VSS=VSS
Xmult_30 unpu_pe_7_DW_mult_tc_0_DW_mult_tc_13 $PINS a[7]=weight_reg[7]
+ a[6]=weight_reg[6] a[5]=weight_reg[5] a[4]=weight_reg[4] a[3]=weight_reg[3]
+ a[2]=weight_reg[2] a[1]=weight_reg[1] a[0]=gre_a_INV_2160_3 b[7]=act_in[7]
+ b[6]=act_in[6] b[5]=act_in[5] b[4]=act_in[4] b[3]=act_in[3] b[2]=act_in[2]
+ b[1]=act_in[1] b[0]=act_in[0] product[15]=N_uc_36 product[14]=N_uc_35
+ product[13]=N_uc_34 product[12]=N_uc_33 product[11]=N_uc_32 product[10]=N_uc_31
+ product[9]=N_uc_30 product[8]=N_uc_29 product[7]=N_uc_28 product[6]=N_uc_27
+ product[5]=N_uc_26 product[4]=N_uc_25 product[3]=N_uc_24 product[2]=N_uc_23
+ product[1]=N_uc_22 product[0]=N_uc_21 VDD=VDD VSS=VSS
+ gre_a_INV_2941_2=gre_a_INV_2941_3
Xact_out_reg_3_ decrq1 $PINS D=copt_net_277 ENN=HFSNET_5 CP=ZCTSNET_2
+ CDN=HFSNET_9 Q=act_out[3] VDD=VDD VSS=VSS
Xact_out_reg_2_ decrq1 $PINS D=act_in[2] ENN=array_en CP=ZCTSNET_3 CDN=HFSNET_9
+ Q=act_out[2] VDD=VDD VSS=VSS
Xact_out_reg_1_ decrq1 $PINS D=copt_net_1123 ENN=array_en CP=ZCTSNET_3
+ CDN=HFSNET_9 Q=act_out[1] VDD=VDD VSS=VSS
Xact_out_reg_7_ decrq1 $PINS D=copt_net_274 ENN=array_en CP=ZCTSNET_2
+ CDN=HFSNET_9 Q=act_out[7] VDD=VDD VSS=VSS
Xact_out_reg_6_ decrq1 $PINS D=copt_net_283 ENN=HFSNET_5 CP=ZCTSNET_2
+ CDN=HFSNET_9 Q=act_out[6] VDD=VDD VSS=VSS
Xact_out_reg_5_ decrq1 $PINS D=copt_net_1028 ENN=HFSNET_4 CP=ZCTSNET_3
+ CDN=HFSNET_8 Q=act_out[5] VDD=VDD VSS=VSS
Xact_out_reg_4_ decrq1 $PINS D=copt_net_278 ENN=HFSNET_5 CP=ZCTSNET_2
+ CDN=HFSNET_9 Q=act_out[4] VDD=VDD VSS=VSS
Xact_out_reg_0_ decrq1 $PINS D=copt_net_2940 ENN=array_en CP=ZCTSNET_2
+ CDN=HFSNET_9 Q=act_out[0] VDD=VDD VSS=VSS
Xpsum_out_reg_7_ decrq1 $PINS D=copt_net_2870 ENN=array_en CP=ZCTSNET_2
+ CDN=HFSNET_9 Q=psum_out[7] VDD=VDD VSS=VSS
Xpsum_out_reg_6_ decrq1 $PINS D=copt_net_2871 ENN=array_en CP=ZCTSNET_2
+ CDN=HFSNET_9 Q=psum_out[6] VDD=VDD VSS=VSS
Xpsum_out_reg_5_ decrq1 $PINS D=copt_net_2873 ENN=array_en CP=ZCTSNET_2
+ CDN=rst_n Q=psum_out[5] VDD=VDD VSS=VSS
Xpsum_out_reg_4_ decrq1 $PINS D=N_uc_44 ENN=array_en CP=ZCTSNET_2 CDN=HFSNET_9
+ Q=psum_out[4] VDD=VDD VSS=VSS
Xpsum_out_reg_3_ decrq1 $PINS D=copt_net_2795 ENN=array_en CP=ZCTSNET_2
+ CDN=HFSNET_9 Q=psum_out[3] VDD=VDD VSS=VSS
Xpsum_out_reg_2_ decrq1 $PINS D=N_uc_42 ENN=array_en CP=ZCTSNET_2 CDN=HFSNET_9
+ Q=psum_out[2] VDD=VDD VSS=VSS
Xpsum_out_reg_1_ decrq1 $PINS D=copt_net_2803 ENN=array_en CP=ZCTSNET_2
+ CDN=HFSNET_9 Q=psum_out[1] VDD=VDD VSS=VSS
Xpsum_out_reg_0_ decrq1 $PINS D=copt_net_2623 ENN=array_en CP=ZCTSNET_2
+ CDN=HFSNET_9 Q=psum_out[0] VDD=VDD VSS=VSS
Xpsum_out_reg_8_ decrq1 $PINS D=N_uc_48 ENN=array_en CP=ZCTSNET_2 CDN=rst_n
+ Q=psum_out[8] VDD=VDD VSS=VSS
Xpsum_out_reg_9_ decrq1 $PINS D=N_uc_49 ENN=array_en CP=ZCTSNET_2 CDN=rst_n
+ Q=psum_out[9] VDD=VDD VSS=VSS
Xpsum_out_reg_10_ decrq1 $PINS D=copt_net_2883 ENN=array_en CP=ZCTSNET_2
+ CDN=rst_n Q=psum_out[10] VDD=VDD VSS=VSS
Xweight_reg_reg_7_ decrq1 $PINS D=weight_in[7] ENN=n15 CP=ZCTSNET_0
+ CDN=HFSNET_11 Q=weight_reg[7] VDD=VDD VSS=VSS
Xweight_reg_reg_6_ decrq1 $PINS D=weight_in[6] ENN=n15 CP=ZCTSNET_3
+ CDN=HFSNET_9 Q=weight_reg[6] VDD=VDD VSS=VSS
Xweight_reg_reg_5_ decrq1 $PINS D=weight_in[5] ENN=n15 CP=ZCTSNET_0
+ CDN=HFSNET_11 Q=weight_reg[5] VDD=VDD VSS=VSS
Xweight_reg_reg_4_ decrq1 $PINS D=weight_in[4] ENN=n15 CP=ZCTSNET_0
+ CDN=HFSNET_9 Q=weight_reg[4] VDD=VDD VSS=VSS
Xweight_reg_reg_3_ decrq1 $PINS D=weight_in[3] ENN=n15 CP=ZCTSNET_13 CDN=rst_n
+ Q=weight_reg[3] VDD=VDD VSS=VSS
Xweight_reg_reg_2_ decrq1 $PINS D=weight_in[2] ENN=n15 CP=ZCTSNET_13
+ CDN=HFSNET_10 Q=weight_reg[2] VDD=VDD VSS=VSS
Xweight_reg_reg_1_ decrq1 $PINS D=weight_in[1] ENN=n15 CP=ZCTSNET_13 CDN=rst_n
+ Q=weight_reg[1] VDD=VDD VSS=VSS
Xweight_reg_reg_0_ decrq1 $PINS D=weight_in[0] ENN=n15 CP=ZCTSNET_3
+ CDN=HFSNET_9 Q=weight_reg[0] VDD=VDD VSS=VSS
Xpsum_out_reg_11_ decrq1 $PINS D=copt_net_2869 ENN=HFSNET_5 CP=ZCTSNET_2
+ CDN=HFSNET_9 Q=psum_out[11] VDD=VDD VSS=VSS
Xpsum_out_reg_12_ decrq1 $PINS D=copt_net_2882 ENN=HFSNET_5 CP=ZCTSNET_2
+ CDN=HFSNET_9 Q=psum_out[12] VDD=VDD VSS=VSS
Xpsum_out_reg_13_ decrq1 $PINS D=N_uc_53 ENN=array_en CP=ZCTSNET_2 CDN=HFSNET_9
+ Q=psum_out[13] VDD=VDD VSS=VSS
Xpsum_out_reg_14_ decrq1 $PINS D=copt_net_2843 ENN=HFSNET_5 CP=ZCTSNET_2
+ CDN=HFSNET_9 Q=psum_out[14] VDD=VDD VSS=VSS
Xpsum_out_reg_15_ decrq1 $PINS D=copt_net_2881 ENN=HFSNET_5 CP=ZCTSNET_2
+ CDN=HFSNET_9 Q=psum_out[15] VDD=VDD VSS=VSS
Xpsum_out_reg_16_ decrq1 $PINS D=copt_net_2868 ENN=HFSNET_5 CP=ZCTSNET_2
+ CDN=HFSNET_9 Q=psum_out[16] VDD=VDD VSS=VSS
Xpsum_out_reg_17_ decrq1 $PINS D=N_uc_57 ENN=HFSNET_5 CP=ZCTSNET_2 CDN=HFSNET_9
+ Q=psum_out[17] VDD=VDD VSS=VSS
Xpsum_out_reg_18_ decrq1 $PINS D=copt_net_2839 ENN=HFSNET_5 CP=ZCTSNET_2
+ CDN=HFSNET_9 Q=psum_out[18] VDD=VDD VSS=VSS
Xpsum_out_reg_19_ decrq1 $PINS D=N_uc_59 ENN=HFSNET_5 CP=ZCTSNET_2 CDN=HFSNET_9
+ Q=psum_out[19] VDD=VDD VSS=VSS
Xpsum_out_reg_20_ decrq1 $PINS D=N_uc_60 ENN=HFSNET_6 CP=ZCTSNET_13 CDN=rst_n
+ Q=psum_out[20] VDD=VDD VSS=VSS
Xpsum_out_reg_21_ decrq1 $PINS D=N_uc_61 ENN=HFSNET_6 CP=ZCTSNET_0
+ CDN=HFSNET_10 Q=psum_out[21] VDD=VDD VSS=VSS
Xpsum_out_reg_22_ decrq1 $PINS D=N_uc_62 ENN=HFSNET_6 CP=ZCTSNET_13
+ CDN=HFSNET_10 Q=psum_out[22] VDD=VDD VSS=VSS
Xpsum_out_reg_23_ decrq1 $PINS D=N_uc_63 ENN=HFSNET_6 CP=ZCTSNET_0
+ CDN=HFSNET_10 Q=psum_out[23] VDD=VDD VSS=VSS
Xpsum_out_reg_24_ decrq1 $PINS D=copt_net_2779 ENN=HFSNET_6 CP=ZCTSNET_13
+ CDN=HFSNET_10 Q=psum_out[24] VDD=VDD VSS=VSS
Xpsum_out_reg_25_ decrq1 $PINS D=N_uc_65 ENN=HFSNET_6 CP=ZCTSNET_13
+ CDN=HFSNET_10 Q=psum_out[25] VDD=VDD VSS=VSS
Xpsum_out_reg_26_ decrq1 $PINS D=N_uc_66 ENN=HFSNET_6 CP=ZCTSNET_13
+ CDN=HFSNET_10 Q=psum_out[26] VDD=VDD VSS=VSS
Xpsum_out_reg_27_ decrq1 $PINS D=N_uc_67 ENN=HFSNET_6 CP=clk CDN=HFSNET_10
+ Q=psum_out[27] VDD=VDD VSS=VSS
Xpsum_out_reg_28_ decrq1 $PINS D=N_uc_68 ENN=HFSNET_6 CP=ZCTSNET_13
+ CDN=HFSNET_10 Q=psum_out[28] VDD=VDD VSS=VSS
Xpsum_out_reg_29_ decrq1 $PINS D=copt_net_2607 ENN=HFSNET_6 CP=ZCTSNET_13
+ CDN=HFSNET_10 Q=psum_out[29] VDD=VDD VSS=VSS
Xpsum_out_reg_30_ decrq1 $PINS D=N_uc_70 ENN=HFSNET_6 CP=ZCTSNET_13 CDN=rst_n
+ Q=psum_out[30] VDD=VDD VSS=VSS
Xpsum_out_reg_31_ decrq1 $PINS D=N_uc_71 ENN=HFSNET_6 CP=ZCTSNET_13
+ CDN=HFSNET_10 Q=psum_out[31] VDD=VDD VSS=VSS
XU19 inv0d2 $PINS I=n16 ZN=n2 VDD=VDD VSS=VSS
Xcopt_h_inst_3104 dl02d1 $PINS I=act_in[7] Z=copt_net_274 VDD=VDD VSS=VSS
Xcopt_h_inst_3107 dl02d1 $PINS I=act_in[3] Z=copt_net_277 VDD=VDD VSS=VSS
Xcopt_h_inst_3108 dl02d1 $PINS I=act_in[4] Z=copt_net_278 VDD=VDD VSS=VSS
Xcopt_h_inst_3113 dl02d1 $PINS I=act_in[6] Z=copt_net_283 VDD=VDD VSS=VSS
Xcopt_h_inst_3860 dl02d1 $PINS I=act_in[5] Z=copt_net_1028 VDD=VDD VSS=VSS
XU25 nd02d1 $PINS A1=weight_load A2=HFSNET_7 ZN=n15 VDD=VDD VSS=VSS
Xcopt_h_inst_3955 dl01d1 $PINS I=act_in[1] Z=copt_net_1123 VDD=VDD VSS=VSS
Xcopt_h_inst_5440 dl01d1 $PINS I=N_uc_69 Z=copt_net_2607 VDD=VDD VSS=VSS
Xcopt_h_inst_5456 dl01d1 $PINS I=N_uc_40 Z=copt_net_2623 VDD=VDD VSS=VSS
Xcopt_h_inst_5612 dl01d1 $PINS I=N_uc_64 Z=copt_net_2779 VDD=VDD VSS=VSS
XU30 nd02d1 $PINS A1=N_uc_36 A2=HFSNET_3 ZN=n16 VDD=VDD VSS=VSS
Xcopt_h_inst_5628 buffd1 $PINS I=N_uc_43 Z=copt_net_2795 VDD=VDD VSS=VSS
Xgre_a_INV_2941_inst_5841 inv0d1 $PINS I=weight_reg[7] ZN=gre_a_INV_2941_3
+ VDD=VDD VSS=VSS
Xcopt_h_inst_5636 buffd1 $PINS I=N_uc_41 Z=copt_net_2803 VDD=VDD VSS=VSS
Xcopt_h_inst_5673 dl01d1 $PINS I=N_uc_58 Z=copt_net_2839 VDD=VDD VSS=VSS
Xcopt_h_inst_5677 dl01d1 $PINS I=N_uc_54 Z=copt_net_2843 VDD=VDD VSS=VSS
Xcopt_h_inst_5702 dl01d1 $PINS I=N_uc_56 Z=copt_net_2868 VDD=VDD VSS=VSS
Xcopt_h_inst_5703 buffd1 $PINS I=N_uc_51 Z=copt_net_2869 VDD=VDD VSS=VSS
Xcopt_h_inst_5704 buffd1 $PINS I=N_uc_47 Z=copt_net_2870 VDD=VDD VSS=VSS
Xcopt_h_inst_5705 buffd1 $PINS I=N_uc_46 Z=copt_net_2871 VDD=VDD VSS=VSS
Xcopt_h_inst_5707 buffd1 $PINS I=N_uc_45 Z=copt_net_2873 VDD=VDD VSS=VSS
Xcopt_h_inst_5715 buffd1 $PINS I=N_uc_55 Z=copt_net_2881 VDD=VDD VSS=VSS
Xcopt_h_inst_5716 buffd1 $PINS I=N_uc_52 Z=copt_net_2882 VDD=VDD VSS=VSS
Xcopt_h_inst_5717 buffd1 $PINS I=N_uc_50 Z=copt_net_2883 VDD=VDD VSS=VSS
Xcopt_h_inst_5774 dl02d1 $PINS I=act_in[0] Z=copt_net_2940 VDD=VDD VSS=VSS
Xgre_a_INV_2160_inst_5842 inv0d1 $PINS I=weight_reg[0] ZN=gre_a_INV_2160_3
+ VDD=VDD VSS=VSS
.ENDS

.SUBCKT unpu_pe_8_DW_mult_tc_0_DW_mult_tc_6 a[7] a[6] a[5] a[4] a[3] a[2] a[1]
+ a[0] b[7] b[6] b[5] b[4] b[3] b[2] b[1] b[0] product[15] product[14]
+ product[13] product[12] product[11] product[10] product[9] product[8]
+ product[7] product[6] product[5] product[4] product[3] product[2] product[1]
+ product[0] VDD VSS
XU2 ad01d0 $PINS A=n196 B=n61 CI=n2 CO=n1 S=product[14] VDD=VDD VSS=VSS
XU3 ad01d0 $PINS A=n17 B=n16 CI=n3 CO=n2 S=product[13] VDD=VDD VSS=VSS
XU4 ad01d0 $PINS A=n18 B=n19 CI=n4 CO=n3 S=product[12] VDD=VDD VSS=VSS
XU5 ad01d0 $PINS A=n20 B=n23 CI=n5 CO=n4 S=product[11] VDD=VDD VSS=VSS
XU6 ad01d0 $PINS A=n27 B=n24 CI=n6 CO=n5 S=product[10] VDD=VDD VSS=VSS
XU7 ad01d0 $PINS A=n33 B=n28 CI=n7 CO=n6 S=product[9] VDD=VDD VSS=VSS
XU8 ad01d0 $PINS A=n39 B=n34 CI=n8 CO=n7 S=product[8] VDD=VDD VSS=VSS
XU9 ad01d0 $PINS A=n45 B=n40 CI=n9 CO=n8 S=product[7] VDD=VDD VSS=VSS
XU10 ad01d0 $PINS A=n49 B=n46 CI=n10 CO=n9 S=product[6] VDD=VDD VSS=VSS
XU11 ad01d0 $PINS A=n53 B=n50 CI=n11 CO=n10 S=product[5] VDD=VDD VSS=VSS
XU12 ad01d0 $PINS A=n55 B=n54 CI=n12 CO=n11 S=product[4] VDD=VDD VSS=VSS
XU13 ad01d0 $PINS A=n59 B=n56 CI=n13 CO=n12 S=product[3] VDD=VDD VSS=VSS
XU14 ad01d0 $PINS A=n84 B=n91 CI=n14 CO=n13 S=product[2] VDD=VDD VSS=VSS
XctmTdsLR_1_2951 an02d1 $PINS A1=n90 A2=n83 Z=n55 VDD=VDD VSS=VSS
XU17 ad01d0 $PINS A=n195 B=n62 CI=n69 CO=n17 S=n18 VDD=VDD VSS=VSS
XU18 ad01d0 $PINS A=n63 B=n25 CI=n22 CO=n19 S=n20 VDD=VDD VSS=VSS
XU20 ad01d0 $PINS A=n64 B=n26 CI=n29 CO=n23 S=n24 VDD=VDD VSS=VSS
XU21 ad01d0 $PINS A=n194 B=n70 CI=n77 CO=n25 S=n26 VDD=VDD VSS=VSS
XU22 ad01d0 $PINS A=n32 B=n35 CI=n30 CO=n27 S=n28 VDD=VDD VSS=VSS
XU23 ad01d0 $PINS A=n71 B=n65 CI=n37 CO=n29 S=n30 VDD=VDD VSS=VSS
XU25 ad01d0 $PINS A=n38 B=n41 CI=n36 CO=n33 S=n34 VDD=VDD VSS=VSS
XU26 ad01d0 $PINS A=n72 B=n85 CI=n43 CO=n35 S=n36 VDD=VDD VSS=VSS
XU29 ad01d0 $PINS A=n44 B=n47 CI=n42 CO=n39 S=n40 VDD=VDD VSS=VSS
XU30 ad01d0 $PINS A=n86 B=n73 CI=n79 CO=n41 S=n42 VDD=VDD VSS=VSS
XU32 ad01d0 $PINS A=n74 B=n51 CI=n48 CO=n45 S=n46 VDD=VDD VSS=VSS
XU33 ad01d0 $PINS A=n68 B=n87 CI=n80 CO=n47 S=n48 VDD=VDD VSS=VSS
XU34 ad01d0 $PINS A=n88 B=n81 CI=n52 CO=n49 S=n50 VDD=VDD VSS=VSS
XU36 ad01d0 $PINS A=n76 B=n89 CI=n82 CO=n53 S=n54 VDD=VDD VSS=VSS
XU145 oai21d1 $PINS B1=n203 B2=n249 A=n222 ZN=n77 VDD=VDD VSS=VSS
XU146 oai21d1 $PINS B1=n201 B2=n250 A=n232 ZN=n69 VDD=VDD VSS=VSS
XU147 oai21d1 $PINS B1=n199 B2=n251 A=n242 ZN=n61 VDD=VDD VSS=VSS
XU148 inv0d0 $PINS I=n16 ZN=n196 VDD=VDD VSS=VSS
XU149 inv0d0 $PINS I=n223 ZN=n201 VDD=VDD VSS=VSS
XU150 inv0d0 $PINS I=n214 ZN=n203 VDD=VDD VSS=VSS
XU151 inv0d0 $PINS I=n233 ZN=n199 VDD=VDD VSS=VSS
XU152 inv0d0 $PINS I=n32 ZN=n194 VDD=VDD VSS=VSS
XU153 inv0d0 $PINS I=n22 ZN=n195 VDD=VDD VSS=VSS
XU154 nd02d1 $PINS A1=n214 A2=n249 ZN=n216 VDD=VDD VSS=VSS
XU155 xr02d1 $PINS A1=a[2] A2=n204 Z=n214 VDD=VDD VSS=VSS
XU156 inv0d1 $PINS I=a[1] ZN=n204 VDD=VDD VSS=VSS
XU157 nd02d1 $PINS A1=n223 A2=n250 ZN=n225 VDD=VDD VSS=VSS
XU158 xr02d1 $PINS A1=a[4] A2=n202 Z=n223 VDD=VDD VSS=VSS
XU159 inv0d1 $PINS I=a[3] ZN=n202 VDD=VDD VSS=VSS
XU160 nd02d0 $PINS A1=a[1] A2=a[0] ZN=n206 VDD=VDD VSS=VSS
XU162 inv0d0 $PINS I=b[0] ZN=n197 VDD=VDD VSS=VSS
XU163 xr02d1 $PINS A1=a[6] A2=n200 Z=n233 VDD=VDD VSS=VSS
XU164 inv0d1 $PINS I=a[5] ZN=n200 VDD=VDD VSS=VSS
XU165 nd02d1 $PINS A1=n233 A2=n251 ZN=n235 VDD=VDD VSS=VSS
XU166 inv0d1 $PINS I=a[7] ZN=n198 VDD=VDD VSS=VSS
XU167 inv0d0 $PINS I=n1 ZN=product[15] VDD=VDD VSS=VSS
XU168 nr02d0 $PINS A1=a[0] A2=n197 ZN=product[0] VDD=VDD VSS=VSS
XU169 oai22d1 $PINS A1=b[0] A2=n206 B1=n207 B2=a[0] ZN=n92 VDD=VDD VSS=VSS
XU170 oai22d1 $PINS A1=n207 A2=n206 B1=n208 B2=a[0] ZN=n91 VDD=VDD VSS=VSS
XU171 xr02d1 $PINS A1=b[1] A2=n204 Z=n207 VDD=VDD VSS=VSS
XU172 oai22d1 $PINS A1=n208 A2=n206 B1=n209 B2=a[0] ZN=n90 VDD=VDD VSS=VSS
XU173 xr02d1 $PINS A1=b[2] A2=n204 Z=n208 VDD=VDD VSS=VSS
XU174 oai22d1 $PINS A1=n209 A2=n206 B1=n210 B2=a[0] ZN=n89 VDD=VDD VSS=VSS
XU175 xr02d1 $PINS A1=b[3] A2=n204 Z=n209 VDD=VDD VSS=VSS
XU176 oai22d1 $PINS A1=n210 A2=n206 B1=n211 B2=a[0] ZN=n88 VDD=VDD VSS=VSS
XU177 xr02d1 $PINS A1=b[4] A2=n204 Z=n210 VDD=VDD VSS=VSS
XU178 oai22d1 $PINS A1=n211 A2=n206 B1=n212 B2=a[0] ZN=n87 VDD=VDD VSS=VSS
XU179 xr02d1 $PINS A1=b[5] A2=n204 Z=n211 VDD=VDD VSS=VSS
XU180 oai22d1 $PINS A1=n212 A2=n206 B1=n213 B2=a[0] ZN=n86 VDD=VDD VSS=VSS
XU181 xr02d1 $PINS A1=b[6] A2=n204 Z=n212 VDD=VDD VSS=VSS
XU182 aor21d1 $PINS B1=a[0] B2=n206 A=n213 Z=n85 VDD=VDD VSS=VSS
XU183 xr02d1 $PINS A1=b[7] A2=n204 Z=n213 VDD=VDD VSS=VSS
XU184 nr02d0 $PINS A1=n214 A2=n197 ZN=n84 VDD=VDD VSS=VSS
XU185 oai22d1 $PINS A1=n216 A2=n215 B1=n214 B2=n217 ZN=n83 VDD=VDD VSS=VSS
XctmTdsLR_1_2931 an02d1 $PINS A1=n92 A2=n60 Z=n14 VDD=VDD VSS=VSS
XU187 oai22d1 $PINS A1=n217 A2=n216 B1=n214 B2=n218 ZN=n82 VDD=VDD VSS=VSS
XU188 xr02d1 $PINS A1=b[1] A2=n202 Z=n217 VDD=VDD VSS=VSS
XU189 oai22d1 $PINS A1=n218 A2=n216 B1=n214 B2=n219 ZN=n81 VDD=VDD VSS=VSS
XU190 xr02d1 $PINS A1=b[2] A2=n202 Z=n218 VDD=VDD VSS=VSS
XU191 oai22d1 $PINS A1=n219 A2=n216 B1=n214 B2=n220 ZN=n80 VDD=VDD VSS=VSS
XU192 xr02d1 $PINS A1=b[3] A2=n202 Z=n219 VDD=VDD VSS=VSS
XU193 oai22d1 $PINS A1=n220 A2=n216 B1=n214 B2=n221 ZN=n79 VDD=VDD VSS=VSS
XU194 xr02d1 $PINS A1=b[4] A2=n202 Z=n220 VDD=VDD VSS=VSS
XU195 nr02d0 $PINS A1=n223 A2=n197 ZN=n76 VDD=VDD VSS=VSS
XU196 oai22d1 $PINS A1=n225 A2=n224 B1=n223 B2=n226 ZN=n75 VDD=VDD VSS=VSS
XctmTdsLR_2_2932 aoim21d1 $PINS B1=n92 B2=n60 A=n14 ZN=product[1] VDD=VDD
+ VSS=VSS
XU198 oai22d1 $PINS A1=n226 A2=n225 B1=n223 B2=n227 ZN=n74 VDD=VDD VSS=VSS
XU199 xr02d1 $PINS A1=b[1] A2=n200 Z=n226 VDD=VDD VSS=VSS
XU200 oai22d1 $PINS A1=n227 A2=n225 B1=n223 B2=n228 ZN=n73 VDD=VDD VSS=VSS
XU201 xr02d1 $PINS A1=b[2] A2=n200 Z=n227 VDD=VDD VSS=VSS
XU202 oai22d1 $PINS A1=n228 A2=n225 B1=n223 B2=n229 ZN=n72 VDD=VDD VSS=VSS
XU203 xr02d1 $PINS A1=b[3] A2=n200 Z=n228 VDD=VDD VSS=VSS
XU204 oai22d1 $PINS A1=n229 A2=n225 B1=n223 B2=n230 ZN=n71 VDD=VDD VSS=VSS
XU205 xr02d1 $PINS A1=b[4] A2=n200 Z=n229 VDD=VDD VSS=VSS
XU206 oai22d1 $PINS A1=n230 A2=n225 B1=n223 B2=n231 ZN=n70 VDD=VDD VSS=VSS
XU207 xr02d1 $PINS A1=b[5] A2=n200 Z=n230 VDD=VDD VSS=VSS
XU208 nr02d0 $PINS A1=n233 A2=n197 ZN=n68 VDD=VDD VSS=VSS
XU209 oai22d1 $PINS A1=n235 A2=n234 B1=n233 B2=n236 ZN=n67 VDD=VDD VSS=VSS
XctmTdsLR_2_2952 aoim21d1 $PINS B1=n90 B2=n83 A=n55 ZN=n56 VDD=VDD VSS=VSS
XU211 oai22d1 $PINS A1=n237 A2=n235 B1=n233 B2=n238 ZN=n65 VDD=VDD VSS=VSS
XU212 oai22d1 $PINS A1=n238 A2=n235 B1=n233 B2=n239 ZN=n64 VDD=VDD VSS=VSS
XU213 xr02d1 $PINS A1=b[3] A2=n198 Z=n238 VDD=VDD VSS=VSS
XU214 oai22d1 $PINS A1=n239 A2=n235 B1=n233 B2=n240 ZN=n63 VDD=VDD VSS=VSS
XU215 xr02d1 $PINS A1=b[4] A2=n198 Z=n239 VDD=VDD VSS=VSS
XU216 oai22d1 $PINS A1=n240 A2=n235 B1=n233 B2=n241 ZN=n62 VDD=VDD VSS=VSS
XU217 xr02d1 $PINS A1=b[5] A2=n198 Z=n240 VDD=VDD VSS=VSS
XU218 oai21d1 $PINS B1=b[0] B2=n204 A=n206 ZN=n60 VDD=VDD VSS=VSS
XU219 oai21d1 $PINS B1=n202 B2=n216 A=n243 ZN=n59 VDD=VDD VSS=VSS
XU220 nd03d0 $PINS A1=n203 A2=n197 A3=a[3] ZN=n243 VDD=VDD VSS=VSS
XU221 oai21d1 $PINS B1=n200 B2=n225 A=n244 ZN=n58 VDD=VDD VSS=VSS
XU222 nd03d0 $PINS A1=n201 A2=n197 A3=a[5] ZN=n244 VDD=VDD VSS=VSS
XU223 oai21d1 $PINS B1=n198 B2=n235 A=n245 ZN=n57 VDD=VDD VSS=VSS
XU224 nd03d0 $PINS A1=n199 A2=n197 A3=a[7] ZN=n245 VDD=VDD VSS=VSS
XU225 xn02d1 $PINS A1=n246 A2=n247 ZN=n38 VDD=VDD VSS=VSS
XU226 or02d0 $PINS A1=n247 A2=n246 Z=n37 VDD=VDD VSS=VSS
XU227 oai22d1 $PINS A1=n236 A2=n235 B1=n233 B2=n237 ZN=n246 VDD=VDD VSS=VSS
XU228 xr02d1 $PINS A1=b[2] A2=n198 Z=n237 VDD=VDD VSS=VSS
XU229 xr02d1 $PINS A1=b[1] A2=n198 Z=n236 VDD=VDD VSS=VSS
XU230 oai22d1 $PINS A1=n221 A2=n216 B1=n214 B2=n248 ZN=n247 VDD=VDD VSS=VSS
XU231 xr02d1 $PINS A1=b[5] A2=n202 Z=n221 VDD=VDD VSS=VSS
XU232 aoim22d1 $PINS A1=n203 A2=n222 B1=n248 B2=n216 Z=n32 VDD=VDD VSS=VSS
XU233 xr02d1 $PINS A1=a[3] A2=a[2] Z=n249 VDD=VDD VSS=VSS
XU234 xr02d1 $PINS A1=b[6] A2=n202 Z=n248 VDD=VDD VSS=VSS
XU235 xr02d1 $PINS A1=b[7] A2=a[3] Z=n222 VDD=VDD VSS=VSS
XU236 aoim22d1 $PINS A1=n201 A2=n232 B1=n231 B2=n225 Z=n22 VDD=VDD VSS=VSS
XU237 xr02d1 $PINS A1=a[5] A2=a[4] Z=n250 VDD=VDD VSS=VSS
XU238 xr02d1 $PINS A1=b[6] A2=n200 Z=n231 VDD=VDD VSS=VSS
XU239 xr02d1 $PINS A1=b[7] A2=a[5] Z=n232 VDD=VDD VSS=VSS
XU240 aoim22d1 $PINS A1=n199 A2=n242 B1=n241 B2=n235 Z=n16 VDD=VDD VSS=VSS
XU241 xr02d1 $PINS A1=a[7] A2=a[6] Z=n251 VDD=VDD VSS=VSS
XU242 xr02d1 $PINS A1=b[6] A2=n198 Z=n241 VDD=VDD VSS=VSS
XU243 xr02d1 $PINS A1=b[7] A2=a[7] Z=n242 VDD=VDD VSS=VSS
XctmTdsLR_1_1338 aoim22d1 $PINS A1=n202 A2=b[0] B1=n202 B2=b[0] Z=n215 VDD=VDD
+ VSS=VSS
XctmTdsLR_1_1339 aoim22d1 $PINS A1=n200 A2=b[0] B1=n200 B2=b[0] Z=n224 VDD=VDD
+ VSS=VSS
XctmTdsLR_1_1340 aoim22d1 $PINS A1=n198 A2=b[0] B1=n198 B2=b[0] Z=n234 VDD=VDD
+ VSS=VSS
XctmTdsLR_1_2953 an02d1 $PINS A1=n58 A2=n75 Z=n51 VDD=VDD VSS=VSS
XctmTdsLR_2_2954 aoim21d1 $PINS B1=n58 B2=n75 A=n51 ZN=n52 VDD=VDD VSS=VSS
XctmTdsLR_1_2955 an02d1 $PINS A1=n57 A2=n67 Z=n43 VDD=VDD VSS=VSS
XctmTdsLR_2_2956 aoim21d1 $PINS B1=n57 B2=n67 A=n43 ZN=n44 VDD=VDD VSS=VSS
.ENDS

.SUBCKT unpu_pe_8_DW_mult_uns_0_DW_mult_uns_7 a[7] a[6] a[5] a[4] a[3] a[2]
+ a[1] a[0] b[7] b[6] b[5] b[4] b[3] b[2] b[1] b[0] product[15] product[14]
+ product[13] product[12] product[11] product[10] product[9] product[8]
+ product[7] product[6] product[5] product[4] product[3] product[2] product[1]
+ product[0] VDD VSS
XU2 ad01d0 $PINS A=n99 B=n15 CI=n2 CO=product[15] S=product[14] VDD=VDD VSS=VSS
XU3 ad01d0 $PINS A=n16 B=n17 CI=n3 CO=n2 S=product[13] VDD=VDD VSS=VSS
XU4 ad01d0 $PINS A=n18 B=n21 CI=n4 CO=n3 S=product[12] VDD=VDD VSS=VSS
XU5 ad01d0 $PINS A=n27 B=n22 CI=n5 CO=n4 S=product[11] VDD=VDD VSS=VSS
XU6 ad01d0 $PINS A=n35 B=n28 CI=n6 CO=n5 S=product[10] VDD=VDD VSS=VSS
XU7 ad01d0 $PINS A=n45 B=n36 CI=n7 CO=n6 S=product[9] VDD=VDD VSS=VSS
XU8 ad01d0 $PINS A=n57 B=n46 CI=n8 CO=n7 S=product[8] VDD=VDD VSS=VSS
XU9 ad01d0 $PINS A=n69 B=n58 CI=n9 CO=n8 S=product[7] VDD=VDD VSS=VSS
XU10 ad01d0 $PINS A=n79 B=n70 CI=n10 CO=n9 S=product[6] VDD=VDD VSS=VSS
XU11 ad01d0 $PINS A=n87 B=n80 CI=n11 CO=n10 S=product[5] VDD=VDD VSS=VSS
XU12 ad01d0 $PINS A=n93 B=n88 CI=n12 CO=n11 S=product[4] VDD=VDD VSS=VSS
XU13 ad01d0 $PINS A=n96 B=n13 CI=n94 CO=n12 S=product[3] VDD=VDD VSS=VSS
XU14 ad01d0 $PINS A=n146 B=n14 CI=n98 CO=n13 S=product[2] VDD=VDD VSS=VSS
XU15 ah01d1 $PINS A=n161 B=n154 CO=n14 S=product[1] VDD=VDD VSS=VSS
XU16 ad01d0 $PINS A=n107 B=n100 CI=n19 CO=n15 S=n16 VDD=VDD VSS=VSS
XU17 ad01d0 $PINS A=n25 B=n20 CI=n23 CO=n17 S=n18 VDD=VDD VSS=VSS
XU18 ad01d0 $PINS A=n115 B=n101 CI=n108 CO=n19 S=n20 VDD=VDD VSS=VSS
XU19 ad01d0 $PINS A=n31 B=n24 CI=n29 CO=n21 S=n22 VDD=VDD VSS=VSS
XU20 ad01d0 $PINS A=n116 B=n33 CI=n26 CO=n23 S=n24 VDD=VDD VSS=VSS
XU21 ad01d0 $PINS A=n123 B=n102 CI=n109 CO=n25 S=n26 VDD=VDD VSS=VSS
XU22 ad01d0 $PINS A=n32 B=n37 CI=n30 CO=n27 S=n28 VDD=VDD VSS=VSS
XU23 ad01d0 $PINS A=n41 B=n34 CI=n39 CO=n29 S=n30 VDD=VDD VSS=VSS
XU24 ad01d0 $PINS A=n124 B=n117 CI=n43 CO=n31 S=n32 VDD=VDD VSS=VSS
XU25 ad01d0 $PINS A=n131 B=n103 CI=n110 CO=n33 S=n34 VDD=VDD VSS=VSS
XU26 ad01d0 $PINS A=n40 B=n47 CI=n38 CO=n35 S=n36 VDD=VDD VSS=VSS
XU27 ad01d0 $PINS A=n44 B=n51 CI=n49 CO=n37 S=n38 VDD=VDD VSS=VSS
XU28 ad01d0 $PINS A=n55 B=n53 CI=n42 CO=n39 S=n40 VDD=VDD VSS=VSS
XU29 ad01d0 $PINS A=n118 B=n125 CI=n132 CO=n41 S=n42 VDD=VDD VSS=VSS
XU30 ad01d0 $PINS A=n139 B=n104 CI=n111 CO=n43 S=n44 VDD=VDD VSS=VSS
XU31 ad01d0 $PINS A=n50 B=n59 CI=n48 CO=n45 S=n46 VDD=VDD VSS=VSS
XU32 ad01d0 $PINS A=n54 B=n52 CI=n61 CO=n47 S=n48 VDD=VDD VSS=VSS
XU33 ad01d0 $PINS A=n56 B=n65 CI=n63 CO=n49 S=n50 VDD=VDD VSS=VSS
XU34 ad01d0 $PINS A=n140 B=n133 CI=n67 CO=n51 S=n52 VDD=VDD VSS=VSS
XU35 ad01d0 $PINS A=n126 B=n119 CI=n147 CO=n53 S=n54 VDD=VDD VSS=VSS
XU36 ah01d1 $PINS A=n105 B=n112 CO=n55 S=n56 VDD=VDD VSS=VSS
XU37 ad01d0 $PINS A=n71 B=n62 CI=n60 CO=n57 S=n58 VDD=VDD VSS=VSS
XU38 ad01d0 $PINS A=n64 B=n66 CI=n73 CO=n59 S=n60 VDD=VDD VSS=VSS
XU39 ad01d0 $PINS A=n77 B=n68 CI=n75 CO=n61 S=n62 VDD=VDD VSS=VSS
XU40 ad01d0 $PINS A=n141 B=n127 CI=n134 CO=n63 S=n64 VDD=VDD VSS=VSS
XU41 ad01d0 $PINS A=n155 B=n120 CI=n148 CO=n65 S=n66 VDD=VDD VSS=VSS
XU42 ah01d1 $PINS A=n106 B=n113 CO=n67 S=n68 VDD=VDD VSS=VSS
XU43 ad01d0 $PINS A=n81 B=n74 CI=n72 CO=n69 S=n70 VDD=VDD VSS=VSS
XU44 ad01d0 $PINS A=n78 B=n83 CI=n76 CO=n71 S=n72 VDD=VDD VSS=VSS
XU45 ad01d0 $PINS A=n142 B=n135 CI=n85 CO=n73 S=n74 VDD=VDD VSS=VSS
XU46 ad01d0 $PINS A=n156 B=n128 CI=n149 CO=n75 S=n76 VDD=VDD VSS=VSS
XU47 ah01d1 $PINS A=n114 B=n121 CO=n77 S=n78 VDD=VDD VSS=VSS
XU48 ad01d0 $PINS A=n89 B=n84 CI=n82 CO=n79 S=n80 VDD=VDD VSS=VSS
XU49 ad01d0 $PINS A=n150 B=n91 CI=n86 CO=n81 S=n82 VDD=VDD VSS=VSS
XU50 ad01d0 $PINS A=n157 B=n136 CI=n143 CO=n83 S=n84 VDD=VDD VSS=VSS
XU51 ah01d1 $PINS A=n122 B=n129 CO=n85 S=n86 VDD=VDD VSS=VSS
XU52 ad01d0 $PINS A=n95 B=n92 CI=n90 CO=n87 S=n88 VDD=VDD VSS=VSS
XU53 ad01d0 $PINS A=n158 B=n144 CI=n151 CO=n89 S=n90 VDD=VDD VSS=VSS
XU54 ah01d1 $PINS A=n130 B=n137 CO=n91 S=n92 VDD=VDD VSS=VSS
XU55 ad01d0 $PINS A=n159 B=n152 CI=n97 CO=n93 S=n94 VDD=VDD VSS=VSS
XU56 ah01d1 $PINS A=n138 B=n145 CO=n95 S=n96 VDD=VDD VSS=VSS
XU57 ah01d1 $PINS A=n153 B=n160 CO=n97 S=n98 VDD=VDD VSS=VSS
XU140 inv0d0 $PINS I=b[4] ZN=n217 VDD=VDD VSS=VSS
XU141 inv0d0 $PINS I=a[1] ZN=n228 VDD=VDD VSS=VSS
XU142 inv0d0 $PINS I=b[2] ZN=n219 VDD=VDD VSS=VSS
XU144 inv0d0 $PINS I=a[2] ZN=n227 VDD=VDD VSS=VSS
XU145 inv0d0 $PINS I=b[3] ZN=n218 VDD=VDD VSS=VSS
XU146 inv0d0 $PINS I=a[5] ZN=n224 VDD=VDD VSS=VSS
XU147 inv0d0 $PINS I=b[1] ZN=n220 VDD=VDD VSS=VSS
XU148 inv0d0 $PINS I=b[0] ZN=n221 VDD=VDD VSS=VSS
XU149 inv0d0 $PINS I=a[4] ZN=n225 VDD=VDD VSS=VSS
XU150 inv0d0 $PINS I=b[6] ZN=n215 VDD=VDD VSS=VSS
XU151 inv0d0 $PINS I=a[3] ZN=n226 VDD=VDD VSS=VSS
XU152 inv0d0 $PINS I=b[5] ZN=n216 VDD=VDD VSS=VSS
XU153 inv0d0 $PINS I=b[7] ZN=n214 VDD=VDD VSS=VSS
XU154 inv0d0 $PINS I=a[6] ZN=n223 VDD=VDD VSS=VSS
XU155 inv0d0 $PINS I=a[7] ZN=n222 VDD=VDD VSS=VSS
XU156 nr02d0 $PINS A1=a[0] A2=n221 ZN=product[0] VDD=VDD VSS=VSS
XU157 nr02d0 $PINS A1=n222 A2=n214 ZN=n99 VDD=VDD VSS=VSS
XU158 nr02d0 $PINS A1=a[0] A2=n220 ZN=n161 VDD=VDD VSS=VSS
XU159 nr02d0 $PINS A1=a[0] A2=n219 ZN=n160 VDD=VDD VSS=VSS
XU160 nr02d0 $PINS A1=a[0] A2=n218 ZN=n159 VDD=VDD VSS=VSS
XU161 nr02d0 $PINS A1=a[0] A2=n217 ZN=n158 VDD=VDD VSS=VSS
XU162 nr02d0 $PINS A1=a[0] A2=n216 ZN=n157 VDD=VDD VSS=VSS
XU163 nr02d0 $PINS A1=a[0] A2=n215 ZN=n156 VDD=VDD VSS=VSS
XU164 nr02d0 $PINS A1=a[0] A2=n214 ZN=n155 VDD=VDD VSS=VSS
XU165 nr02d0 $PINS A1=n221 A2=n228 ZN=n154 VDD=VDD VSS=VSS
XU166 nr02d0 $PINS A1=n220 A2=n228 ZN=n153 VDD=VDD VSS=VSS
XU167 nr02d0 $PINS A1=n219 A2=n228 ZN=n152 VDD=VDD VSS=VSS
XU168 nr02d0 $PINS A1=n218 A2=n228 ZN=n151 VDD=VDD VSS=VSS
XU169 nr02d0 $PINS A1=n217 A2=n228 ZN=n150 VDD=VDD VSS=VSS
XU170 nr02d0 $PINS A1=n216 A2=n228 ZN=n149 VDD=VDD VSS=VSS
XU171 nr02d0 $PINS A1=n215 A2=n228 ZN=n148 VDD=VDD VSS=VSS
XU172 nr02d0 $PINS A1=n214 A2=n228 ZN=n147 VDD=VDD VSS=VSS
XU173 nr02d0 $PINS A1=n221 A2=n227 ZN=n146 VDD=VDD VSS=VSS
XU174 nr02d0 $PINS A1=n220 A2=n227 ZN=n145 VDD=VDD VSS=VSS
XU175 nr02d0 $PINS A1=n219 A2=n227 ZN=n144 VDD=VDD VSS=VSS
XU176 nr02d0 $PINS A1=n218 A2=n227 ZN=n143 VDD=VDD VSS=VSS
XU177 nr02d0 $PINS A1=n217 A2=n227 ZN=n142 VDD=VDD VSS=VSS
XU178 nr02d0 $PINS A1=n216 A2=n227 ZN=n141 VDD=VDD VSS=VSS
XU179 nr02d0 $PINS A1=n215 A2=n227 ZN=n140 VDD=VDD VSS=VSS
XU180 nr02d0 $PINS A1=n214 A2=n227 ZN=n139 VDD=VDD VSS=VSS
XU181 nr02d0 $PINS A1=n221 A2=n226 ZN=n138 VDD=VDD VSS=VSS
XU182 nr02d0 $PINS A1=n220 A2=n226 ZN=n137 VDD=VDD VSS=VSS
XU183 nr02d0 $PINS A1=n219 A2=n226 ZN=n136 VDD=VDD VSS=VSS
XU184 nr02d0 $PINS A1=n218 A2=n226 ZN=n135 VDD=VDD VSS=VSS
XU185 nr02d0 $PINS A1=n217 A2=n226 ZN=n134 VDD=VDD VSS=VSS
XU186 nr02d0 $PINS A1=n216 A2=n226 ZN=n133 VDD=VDD VSS=VSS
XU187 nr02d0 $PINS A1=n215 A2=n226 ZN=n132 VDD=VDD VSS=VSS
XU188 nr02d0 $PINS A1=n214 A2=n226 ZN=n131 VDD=VDD VSS=VSS
XU189 nr02d0 $PINS A1=n221 A2=n225 ZN=n130 VDD=VDD VSS=VSS
XU190 nr02d0 $PINS A1=n220 A2=n225 ZN=n129 VDD=VDD VSS=VSS
XU191 nr02d0 $PINS A1=n219 A2=n225 ZN=n128 VDD=VDD VSS=VSS
XU192 nr02d0 $PINS A1=n218 A2=n225 ZN=n127 VDD=VDD VSS=VSS
XU193 nr02d0 $PINS A1=n217 A2=n225 ZN=n126 VDD=VDD VSS=VSS
XU194 nr02d0 $PINS A1=n216 A2=n225 ZN=n125 VDD=VDD VSS=VSS
XU195 nr02d0 $PINS A1=n215 A2=n225 ZN=n124 VDD=VDD VSS=VSS
XU196 nr02d0 $PINS A1=n214 A2=n225 ZN=n123 VDD=VDD VSS=VSS
XU197 nr02d0 $PINS A1=n221 A2=n224 ZN=n122 VDD=VDD VSS=VSS
XU198 nr02d0 $PINS A1=n220 A2=n224 ZN=n121 VDD=VDD VSS=VSS
XU199 nr02d0 $PINS A1=n219 A2=n224 ZN=n120 VDD=VDD VSS=VSS
XU200 nr02d0 $PINS A1=n218 A2=n224 ZN=n119 VDD=VDD VSS=VSS
XU201 nr02d0 $PINS A1=n217 A2=n224 ZN=n118 VDD=VDD VSS=VSS
XU202 nr02d0 $PINS A1=n216 A2=n224 ZN=n117 VDD=VDD VSS=VSS
XU203 nr02d0 $PINS A1=n215 A2=n224 ZN=n116 VDD=VDD VSS=VSS
XU204 nr02d0 $PINS A1=n214 A2=n224 ZN=n115 VDD=VDD VSS=VSS
XU205 nr02d0 $PINS A1=n221 A2=n223 ZN=n114 VDD=VDD VSS=VSS
XU206 nr02d0 $PINS A1=n220 A2=n223 ZN=n113 VDD=VDD VSS=VSS
XU207 nr02d0 $PINS A1=n219 A2=n223 ZN=n112 VDD=VDD VSS=VSS
XU208 nr02d0 $PINS A1=n218 A2=n223 ZN=n111 VDD=VDD VSS=VSS
XU209 nr02d0 $PINS A1=n217 A2=n223 ZN=n110 VDD=VDD VSS=VSS
XU210 nr02d0 $PINS A1=n216 A2=n223 ZN=n109 VDD=VDD VSS=VSS
XU211 nr02d0 $PINS A1=n215 A2=n223 ZN=n108 VDD=VDD VSS=VSS
XU212 nr02d0 $PINS A1=n214 A2=n223 ZN=n107 VDD=VDD VSS=VSS
XU213 nr02d0 $PINS A1=n221 A2=n222 ZN=n106 VDD=VDD VSS=VSS
XU214 nr02d0 $PINS A1=n222 A2=n220 ZN=n105 VDD=VDD VSS=VSS
XU215 nr02d0 $PINS A1=n222 A2=n219 ZN=n104 VDD=VDD VSS=VSS
XU216 nr02d0 $PINS A1=n222 A2=n218 ZN=n103 VDD=VDD VSS=VSS
XU217 nr02d0 $PINS A1=n222 A2=n217 ZN=n102 VDD=VDD VSS=VSS
XU218 nr02d0 $PINS A1=n222 A2=n216 ZN=n101 VDD=VDD VSS=VSS
XU219 nr02d0 $PINS A1=n222 A2=n215 ZN=n100 VDD=VDD VSS=VSS
.ENDS

.SUBCKT unpu_pe_8_DW01_add_0_DW01_add_9 A[31] A[30] A[29] A[28] A[27] A[26]
+ A[25] A[24] A[23] A[22] A[21] A[20] A[19] A[18] A[17] A[16] A[15] A[14] A[13]
+ A[12] A[11] A[10] A[9] A[8] A[7] A[6] A[5] A[4] A[3] A[2] A[1] A[0] B[31]
+ B[30] B[29] B[28] B[27] B[26] B[25] B[24] B[23] B[22] B[21] B[20] B[19] B[18]
+ B[17] B[16] B[15] B[14] B[13] B[12] B[11] B[10] B[9] B[8] B[7] B[6] B[5] B[4]
+ B[3] B[2] B[1] B[0] CI SUM[31] SUM[30] SUM[29] SUM[28] SUM[27] SUM[26]
+ SUM[25] SUM[24] SUM[23] SUM[22] SUM[21] SUM[20] SUM[19] SUM[18] SUM[17]
+ SUM[16] SUM[15] SUM[14] SUM[13] SUM[12] SUM[11] SUM[10] SUM[9] SUM[8] SUM[7]
+ SUM[6] SUM[5] SUM[4] SUM[3] SUM[2] SUM[1] SUM[0] CO VDD VSS
XU1_31 ad01d0 $PINS A=copt_net_1598 B=B[31] CI=carry[31] S=SUM[31] VDD=VDD
+ VSS=VSS
XU1_30 ad01d0 $PINS A=copt_net_1472 B=B[30] CI=carry[30] CO=carry[31] S=SUM[30]
+ VDD=VDD VSS=VSS
XU1_29 ad01d0 $PINS A=copt_net_1591 B=B[29] CI=carry[29] CO=carry[30] S=SUM[29]
+ VDD=VDD VSS=VSS
XU1_28 ad01d0 $PINS A=copt_net_1459 B=B[28] CI=carry[28] CO=carry[29] S=SUM[28]
+ VDD=VDD VSS=VSS
XU1_27 ad01d0 $PINS A=copt_net_1620 B=B[27] CI=carry[27] CO=carry[28] S=SUM[27]
+ VDD=VDD VSS=VSS
XU1_26 ad01d0 $PINS A=copt_net_2498 B=B[26] CI=carry[26] CO=carry[27] S=SUM[26]
+ VDD=VDD VSS=VSS
XU1_25 ad01d0 $PINS A=copt_net_1523 B=B[25] CI=carry[25] CO=carry[26] S=SUM[25]
+ VDD=VDD VSS=VSS
XU1_24 ad01d0 $PINS A=copt_net_2566 B=B[24] CI=carry[24] CO=carry[25] S=SUM[24]
+ VDD=VDD VSS=VSS
XU1_23 ad01d0 $PINS A=copt_net_2470 B=B[23] CI=carry[23] CO=carry[24] S=SUM[23]
+ VDD=VDD VSS=VSS
XU1_22 ad01d0 $PINS A=A[22] B=B[22] CI=carry[22] CO=carry[23] S=SUM[22] VDD=VDD
+ VSS=VSS
XU1_21 ad01d0 $PINS A=copt_net_2460 B=B[21] CI=carry[21] CO=carry[22] S=SUM[21]
+ VDD=VDD VSS=VSS
XU1_20 ad01d0 $PINS A=copt_net_2652 B=B[20] CI=carry[20] CO=carry[21] S=SUM[20]
+ VDD=VDD VSS=VSS
XU1_19 ad01d0 $PINS A=copt_net_2609 B=B[19] CI=carry[19] CO=carry[20] S=SUM[19]
+ VDD=VDD VSS=VSS
XU1_18 ad01d0 $PINS A=copt_net_2588 B=B[18] CI=carry[18] CO=carry[19] S=SUM[18]
+ VDD=VDD VSS=VSS
XU1_17 ad01d0 $PINS A=copt_net_2547 B=B[17] CI=carry[17] CO=carry[18] S=SUM[17]
+ VDD=VDD VSS=VSS
XU1_16 ad01d0 $PINS A=copt_net_2538 B=B[16] CI=carry[16] CO=carry[17] S=SUM[16]
+ VDD=VDD VSS=VSS
XU1_15 ad01d0 $PINS A=copt_net_2563 B=B[15] CI=carry[15] CO=carry[16] S=SUM[15]
+ VDD=VDD VSS=VSS
XU1_14 ad01d0 $PINS A=copt_net_2602 B=B[14] CI=carry[14] CO=carry[15] S=SUM[14]
+ VDD=VDD VSS=VSS
XU1_13 ad01d0 $PINS A=copt_net_2626 B=B[13] CI=carry[13] CO=carry[14] S=SUM[13]
+ VDD=VDD VSS=VSS
XU1_12 ad01d0 $PINS A=copt_net_2601 B=B[12] CI=carry[12] CO=carry[13] S=SUM[12]
+ VDD=VDD VSS=VSS
XU1_11 ad01d0 $PINS A=copt_net_2621 B=B[11] CI=carry[11] CO=carry[12] S=SUM[11]
+ VDD=VDD VSS=VSS
XU1_10 ad01d0 $PINS A=copt_net_2580 B=B[10] CI=carry[10] CO=carry[11] S=SUM[10]
+ VDD=VDD VSS=VSS
XU1_9 ad01d0 $PINS A=copt_net_2572 B=B[9] CI=carry[9] CO=carry[10] S=SUM[9]
+ VDD=VDD VSS=VSS
XU1_8 ad01d0 $PINS A=copt_net_2613 B=B[8] CI=carry[8] CO=carry[9] S=SUM[8]
+ VDD=VDD VSS=VSS
XU1_7 ad01d0 $PINS A=copt_net_2574 B=B[7] CI=carry[7] CO=carry[8] S=SUM[7]
+ VDD=VDD VSS=VSS
XU1_6 ad01d0 $PINS A=copt_net_2598 B=B[6] CI=carry[6] CO=carry[7] S=SUM[6]
+ VDD=VDD VSS=VSS
XU1_5 ad01d0 $PINS A=copt_net_2614 B=B[5] CI=carry[5] CO=carry[6] S=SUM[5]
+ VDD=VDD VSS=VSS
XU1_4 ad01d0 $PINS A=copt_net_2599 B=B[4] CI=carry[4] CO=carry[5] S=SUM[4]
+ VDD=VDD VSS=VSS
XU1_3 ad01d0 $PINS A=copt_net_2560 B=B[3] CI=carry[3] CO=carry[4] S=SUM[3]
+ VDD=VDD VSS=VSS
XU1_2 ad01d0 $PINS A=copt_net_2608 B=B[2] CI=carry[2] CO=carry[3] S=SUM[2]
+ VDD=VDD VSS=VSS
XU1_1 ad01d0 $PINS A=A[1] B=B[1] CI=n1 CO=carry[2] S=SUM[1] VDD=VDD VSS=VSS
XU1 an02d1 $PINS A1=B[0] A2=A[0] Z=n1 VDD=VDD VSS=VSS
XU2 xr02d1 $PINS A1=A[0] A2=B[0] Z=SUM[0] VDD=VDD VSS=VSS
Xcopt_h_inst_4291 dl01d1 $PINS I=A[28] Z=copt_net_1459 VDD=VDD VSS=VSS
Xcopt_h_inst_4304 dl01d1 $PINS I=A[30] Z=copt_net_1472 VDD=VDD VSS=VSS
Xcopt_h_inst_4355 dl02d1 $PINS I=A[25] Z=copt_net_1523 VDD=VDD VSS=VSS
Xcopt_h_inst_4423 dl01d1 $PINS I=A[29] Z=copt_net_1591 VDD=VDD VSS=VSS
Xcopt_h_inst_4430 dl01d1 $PINS I=A[31] Z=copt_net_1598 VDD=VDD VSS=VSS
Xcopt_h_inst_4452 dl01d1 $PINS I=A[27] Z=copt_net_1620 VDD=VDD VSS=VSS
Xcopt_h_inst_5293 dl01d1 $PINS I=A[21] Z=copt_net_2460 VDD=VDD VSS=VSS
Xcopt_h_inst_5303 dl01d1 $PINS I=A[23] Z=copt_net_2470 VDD=VDD VSS=VSS
Xcopt_h_inst_5331 dl01d1 $PINS I=A[26] Z=copt_net_2498 VDD=VDD VSS=VSS
Xcopt_h_inst_5371 dl01d1 $PINS I=A[16] Z=copt_net_2538 VDD=VDD VSS=VSS
Xcopt_h_inst_5380 dl01d1 $PINS I=A[17] Z=copt_net_2547 VDD=VDD VSS=VSS
Xcopt_h_inst_5393 dl01d1 $PINS I=A[3] Z=copt_net_2560 VDD=VDD VSS=VSS
Xcopt_h_inst_5396 dl01d1 $PINS I=A[15] Z=copt_net_2563 VDD=VDD VSS=VSS
Xcopt_h_inst_5399 dl01d1 $PINS I=A[24] Z=copt_net_2566 VDD=VDD VSS=VSS
Xcopt_h_inst_5405 dl01d1 $PINS I=A[9] Z=copt_net_2572 VDD=VDD VSS=VSS
Xcopt_h_inst_5407 dl01d1 $PINS I=A[7] Z=copt_net_2574 VDD=VDD VSS=VSS
Xcopt_h_inst_5413 dl01d1 $PINS I=A[10] Z=copt_net_2580 VDD=VDD VSS=VSS
Xcopt_h_inst_5421 dl01d1 $PINS I=A[18] Z=copt_net_2588 VDD=VDD VSS=VSS
Xcopt_h_inst_5431 dl01d1 $PINS I=A[6] Z=copt_net_2598 VDD=VDD VSS=VSS
Xcopt_h_inst_5432 dl01d1 $PINS I=A[4] Z=copt_net_2599 VDD=VDD VSS=VSS
Xcopt_h_inst_5434 dl01d1 $PINS I=A[12] Z=copt_net_2601 VDD=VDD VSS=VSS
Xcopt_h_inst_5435 dl01d1 $PINS I=A[14] Z=copt_net_2602 VDD=VDD VSS=VSS
Xcopt_h_inst_5441 dl01d1 $PINS I=A[2] Z=copt_net_2608 VDD=VDD VSS=VSS
Xcopt_h_inst_5442 dl01d1 $PINS I=A[19] Z=copt_net_2609 VDD=VDD VSS=VSS
Xcopt_h_inst_5446 dl01d1 $PINS I=A[8] Z=copt_net_2613 VDD=VDD VSS=VSS
Xcopt_h_inst_5447 dl01d1 $PINS I=A[5] Z=copt_net_2614 VDD=VDD VSS=VSS
Xcopt_h_inst_5454 dl01d1 $PINS I=A[11] Z=copt_net_2621 VDD=VDD VSS=VSS
Xcopt_h_inst_5459 dl01d1 $PINS I=A[13] Z=copt_net_2626 VDD=VDD VSS=VSS
Xcopt_h_inst_5485 dl01d1 $PINS I=A[20] Z=copt_net_2652 VDD=VDD VSS=VSS
.ENDS

.SUBCKT unpu_pe_8 ZCTSNET_11 rst_n array_en weight_load mode_unsigned
+ weight_in[7] weight_in[6] weight_in[5] weight_in[4] weight_in[3] weight_in[2]
+ weight_in[1] weight_in[0] act_in[7] act_in[6] act_in[5] act_in[4] act_in[3]
+ act_in[2] act_in[1] act_in[0] psum_in[31] psum_in[30] psum_in[29] psum_in[28]
+ psum_in[27] psum_in[26] psum_in[25] psum_in[24] psum_in[23] psum_in[22]
+ psum_in[21] psum_in[20] psum_in[19] psum_in[18] psum_in[17] psum_in[16]
+ psum_in[15] psum_in[14] psum_in[13] psum_in[12] psum_in[11] psum_in[10]
+ psum_in[9] psum_in[8] psum_in[7] psum_in[6] psum_in[5] psum_in[4] psum_in[3]
+ psum_in[2] psum_in[1] psum_in[0] act_out[7] act_out[6] act_out[5] act_out[4]
+ act_out[3] act_out[2] act_out[1] act_out[0] psum_out[31] psum_out[30]
+ psum_out[29] psum_out[28] psum_out[27] psum_out[26] psum_out[25] psum_out[24]
+ psum_out[23] psum_out[22] psum_out[21] psum_out[20] psum_out[19] psum_out[18]
+ psum_out[17] psum_out[16] psum_out[15] psum_out[14] psum_out[13] psum_out[12]
+ psum_out[11] psum_out[10] psum_out[9] psum_out[8] psum_out[7] psum_out[6]
+ psum_out[5] psum_out[4] psum_out[3] psum_out[2] psum_out[1] psum_out[0] VDD
+ VSS ZCTSNET_12 ZCTSNET_1 HFSNET_2 HFSNET_4 HFSNET_5 HFSNET_6 HFSNET_7
+ HFSNET_8 HFSNET_9 HFSNET_10 ZCTSNET_13 ZCTSNET_0 ZCTSNET_2
XU2 aor22d1 $PINS A1=N_uc_30 A2=HFSNET_2 B1=mode_unsigned B2=N_uc_14
+ Z=product[9] VDD=VDD VSS=VSS
XU3 aor22d1 $PINS A1=N_uc_29 A2=HFSNET_2 B1=N_uc_13 B2=mode_unsigned
+ Z=product[8] VDD=VDD VSS=VSS
XU5 aor22d1 $PINS A1=N_uc_28 A2=HFSNET_2 B1=N_uc_12 B2=mode_unsigned
+ Z=product[7] VDD=VDD VSS=VSS
XU6 aor22d1 $PINS A1=N_uc_27 A2=HFSNET_2 B1=N_uc_11 B2=mode_unsigned
+ Z=product[6] VDD=VDD VSS=VSS
XU7 aor22d1 $PINS A1=N_uc_26 A2=HFSNET_2 B1=N_uc_10 B2=mode_unsigned
+ Z=product[5] VDD=VDD VSS=VSS
XU8 aor22d1 $PINS A1=N_uc_9 A2=mode_unsigned B1=N_uc_25 B2=HFSNET_2
+ Z=product[4] VDD=VDD VSS=VSS
XU9 aor22d1 $PINS A1=N_uc_8 A2=mode_unsigned B1=N_uc_24 B2=HFSNET_2
+ Z=product[3] VDD=VDD VSS=VSS
XU10 aor22d1 $PINS A1=N_uc_7 A2=mode_unsigned B1=N_uc_23 B2=HFSNET_2
+ Z=product[2] VDD=VDD VSS=VSS
XU11 aor22d1 $PINS A1=N_uc_6 A2=mode_unsigned B1=N_uc_22 B2=HFSNET_2
+ Z=product[1] VDD=VDD VSS=VSS
XU12 oaim21d1 $PINS B1=N_uc_20 B2=mode_unsigned A=n13 ZN=product[15] VDD=VDD
+ VSS=VSS
XU13 aor22d1 $PINS A1=N_uc_35 A2=HFSNET_2 B1=N_uc_19 B2=mode_unsigned
+ Z=product[14] VDD=VDD VSS=VSS
XU14 aor22d1 $PINS A1=N_uc_34 A2=HFSNET_2 B1=N_uc_18 B2=mode_unsigned
+ Z=product[13] VDD=VDD VSS=VSS
XU15 aor22d1 $PINS A1=N_uc_33 A2=HFSNET_2 B1=N_uc_17 B2=mode_unsigned
+ Z=product[12] VDD=VDD VSS=VSS
XU16 aor22d1 $PINS A1=N_uc_32 A2=HFSNET_2 B1=N_uc_16 B2=mode_unsigned
+ Z=product[11] VDD=VDD VSS=VSS
XU17 aor22d1 $PINS A1=N_uc_31 A2=HFSNET_2 B1=N_uc_15 B2=mode_unsigned
+ Z=product[10] VDD=VDD VSS=VSS
XU18 aor22d1 $PINS A1=N_uc_5 A2=mode_unsigned B1=N_uc_21 B2=HFSNET_2
+ Z=product[0] VDD=VDD VSS=VSS
Xadd_42 unpu_pe_8_DW01_add_0_DW01_add_9 $PINS A[31]=psum_in[31]
+ A[30]=psum_in[30] A[29]=psum_in[29] A[28]=psum_in[28] A[27]=psum_in[27]
+ A[26]=psum_in[26] A[25]=psum_in[25] A[24]=psum_in[24] A[23]=psum_in[23]
+ A[22]=psum_in[22] A[21]=psum_in[21] A[20]=psum_in[20] A[19]=psum_in[19]
+ A[18]=psum_in[18] A[17]=psum_in[17] A[16]=psum_in[16] A[15]=psum_in[15]
+ A[14]=psum_in[14] A[13]=psum_in[13] A[12]=psum_in[12] A[11]=psum_in[11]
+ A[10]=psum_in[10] A[9]=psum_in[9] A[8]=psum_in[8] A[7]=psum_in[7]
+ A[6]=psum_in[6] A[5]=psum_in[5] A[4]=psum_in[4] A[3]=psum_in[3] A[2]=psum_in[2]
+ A[1]=psum_in[1] A[0]=psum_in[0] B[31]=n2 B[30]=n2 B[29]=n2 B[28]=n2 B[27]=n2
+ B[26]=n2 B[25]=n2 B[24]=n2 B[23]=n2 B[22]=n2 B[21]=n2 B[20]=n2 B[19]=n2
+ B[18]=n2 B[17]=n2 B[16]=n2 B[15]=product[15] B[14]=product[14]
+ B[13]=product[13] B[12]=product[12] B[11]=product[11] B[10]=product[10]
+ B[9]=product[9] B[8]=product[8] B[7]=product[7] B[6]=product[6] B[5]=product[5]
+ B[4]=product[4] B[3]=product[3] B[2]=product[2] B[1]=product[1] B[0]=product[0]
+ CI=VSS SUM[31]=N_uc_71 SUM[30]=N_uc_70 SUM[29]=N_uc_69 SUM[28]=N_uc_68
+ SUM[27]=N_uc_67 SUM[26]=N_uc_66 SUM[25]=N_uc_65 SUM[24]=N_uc_64 SUM[23]=N_uc_63
+ SUM[22]=N_uc_62 SUM[21]=N_uc_61 SUM[20]=N_uc_60 SUM[19]=N_uc_59 SUM[18]=N_uc_58
+ SUM[17]=N_uc_57 SUM[16]=N_uc_56 SUM[15]=N_uc_55 SUM[14]=N_uc_54 SUM[13]=N_uc_53
+ SUM[12]=N_uc_52 SUM[11]=N_uc_51 SUM[10]=N_uc_50 SUM[9]=N_uc_49 SUM[8]=N_uc_48
+ SUM[7]=N_uc_47 SUM[6]=N_uc_46 SUM[5]=N_uc_45 SUM[4]=N_uc_44 SUM[3]=N_uc_43
+ SUM[2]=N_uc_42 SUM[1]=N_uc_41 SUM[0]=N_uc_40 VDD=VDD VSS=VSS
Xmult_28 unpu_pe_8_DW_mult_uns_0_DW_mult_uns_7 $PINS a[7]=weight_reg[7]
+ a[6]=weight_reg[6] a[5]=weight_reg[5] a[4]=weight_reg[4] a[3]=weight_reg[3]
+ a[2]=weight_reg[2] a[1]=weight_reg[1] a[0]=gre_a_INV_1435_3 b[7]=act_in[7]
+ b[6]=act_in[6] b[5]=act_in[5] b[4]=act_in[4] b[3]=act_in[3] b[2]=act_in[2]
+ b[1]=act_in[1] b[0]=act_in[0] product[15]=N_uc_20 product[14]=N_uc_19
+ product[13]=N_uc_18 product[12]=N_uc_17 product[11]=N_uc_16 product[10]=N_uc_15
+ product[9]=N_uc_14 product[8]=N_uc_13 product[7]=N_uc_12 product[6]=N_uc_11
+ product[5]=N_uc_10 product[4]=N_uc_9 product[3]=N_uc_8 product[2]=N_uc_7
+ product[1]=N_uc_6 product[0]=N_uc_5 VDD=VDD VSS=VSS
Xmult_30 unpu_pe_8_DW_mult_tc_0_DW_mult_tc_6 $PINS a[7]=weight_reg[7]
+ a[6]=weight_reg[6] a[5]=weight_reg[5] a[4]=weight_reg[4] a[3]=weight_reg[3]
+ a[2]=weight_reg[2] a[1]=weight_reg[1] a[0]=gre_a_INV_1435_3 b[7]=act_in[7]
+ b[6]=act_in[6] b[5]=act_in[5] b[4]=act_in[4] b[3]=act_in[3] b[2]=act_in[2]
+ b[1]=act_in[1] b[0]=act_in[0] product[15]=N_uc_36 product[14]=N_uc_35
+ product[13]=N_uc_34 product[12]=N_uc_33 product[11]=N_uc_32 product[10]=N_uc_31
+ product[9]=N_uc_30 product[8]=N_uc_29 product[7]=N_uc_28 product[6]=N_uc_27
+ product[5]=N_uc_26 product[4]=N_uc_25 product[3]=N_uc_24 product[2]=N_uc_23
+ product[1]=N_uc_22 product[0]=N_uc_21 VDD=VDD VSS=VSS
Xact_out_reg_3_ decrq1 $PINS D=copt_net_2526 ENN=HFSNET_6 CP=ZCTSNET_1
+ CDN=HFSNET_9 Q=_gOb49_act_out[3] VDD=VDD VSS=VSS
Xact_out_reg_2_ decrq1 $PINS D=copt_net_2513 ENN=HFSNET_6 CP=ZCTSNET_1
+ CDN=HFSNET_9 Q=_gOb51_act_out[2] VDD=VDD VSS=VSS
Xact_out_reg_1_ decrq1 $PINS D=copt_net_2829 ENN=HFSNET_6 CP=ZCTSNET_0
+ CDN=HFSNET_9 Q=_gOb53_act_out[1] VDD=VDD VSS=VSS
Xact_out_reg_7_ decrq1 $PINS D=copt_net_2514 ENN=HFSNET_5 CP=ZCTSNET_1
+ CDN=rst_n Q=_gOb41_act_out[7] VDD=VDD VSS=VSS
Xact_out_reg_6_ decrq1 $PINS D=copt_net_2519 ENN=HFSNET_6 CP=ZCTSNET_1
+ CDN=HFSNET_9 Q=_gOb43_act_out[6] VDD=VDD VSS=VSS
Xact_out_reg_5_ decrq1 $PINS D=copt_net_2527 ENN=HFSNET_6 CP=ZCTSNET_1
+ CDN=HFSNET_9 Q=_gOb45_act_out[5] VDD=VDD VSS=VSS
Xact_out_reg_4_ decrq1 $PINS D=copt_net_2520 ENN=HFSNET_6 CP=ZCTSNET_1
+ CDN=HFSNET_9 Q=_gOb47_act_out[4] VDD=VDD VSS=VSS
Xact_out_reg_0_ decrq1 $PINS D=copt_net_2833 ENN=HFSNET_4 CP=ZCTSNET_11
+ CDN=HFSNET_10 Q=_gOb55_act_out[0] VDD=VDD VSS=VSS
Xpsum_out_reg_7_ decrq1 $PINS D=N_uc_47 ENN=HFSNET_6 CP=ZCTSNET_12 CDN=HFSNET_9
+ Q=psum_out[7] VDD=VDD VSS=VSS
Xpsum_out_reg_6_ decrq1 $PINS D=N_uc_46 ENN=HFSNET_6 CP=ZCTSNET_12 CDN=HFSNET_9
+ Q=psum_out[6] VDD=VDD VSS=VSS
Xpsum_out_reg_5_ decrq1 $PINS D=N_uc_45 ENN=HFSNET_6 CP=ZCTSNET_12 CDN=HFSNET_9
+ Q=psum_out[5] VDD=VDD VSS=VSS
Xpsum_out_reg_4_ decrq1 $PINS D=N_uc_44 ENN=HFSNET_6 CP=ZCTSNET_12 CDN=HFSNET_9
+ Q=psum_out[4] VDD=VDD VSS=VSS
Xpsum_out_reg_3_ decrq1 $PINS D=N_uc_43 ENN=HFSNET_6 CP=ZCTSNET_12 CDN=HFSNET_9
+ Q=psum_out[3] VDD=VDD VSS=VSS
Xpsum_out_reg_2_ decrq1 $PINS D=copt_net_2783 ENN=HFSNET_6 CP=ZCTSNET_12
+ CDN=HFSNET_9 Q=psum_out[2] VDD=VDD VSS=VSS
Xpsum_out_reg_1_ decrq1 $PINS D=copt_net_2455 ENN=HFSNET_6 CP=ZCTSNET_12
+ CDN=HFSNET_9 Q=psum_out[1] VDD=VDD VSS=VSS
Xpsum_out_reg_0_ decrq1 $PINS D=copt_net_1103 ENN=HFSNET_6 CP=ZCTSNET_12
+ CDN=HFSNET_9 Q=psum_out[0] VDD=VDD VSS=VSS
Xpsum_out_reg_8_ decrq1 $PINS D=N_uc_48 ENN=HFSNET_6 CP=ZCTSNET_12 CDN=HFSNET_9
+ Q=psum_out[8] VDD=VDD VSS=VSS
Xpsum_out_reg_9_ decrq1 $PINS D=N_uc_49 ENN=HFSNET_6 CP=ZCTSNET_12 CDN=HFSNET_9
+ Q=psum_out[9] VDD=VDD VSS=VSS
Xpsum_out_reg_10_ decrq1 $PINS D=N_uc_50 ENN=HFSNET_6 CP=ZCTSNET_12
+ CDN=HFSNET_9 Q=psum_out[10] VDD=VDD VSS=VSS
Xweight_reg_reg_7_ decrq1 $PINS D=weight_in[7] ENN=n12 CP=ZCTSNET_0
+ CDN=HFSNET_8 Q=weight_reg[7] VDD=VDD VSS=VSS
Xweight_reg_reg_6_ decrq1 $PINS D=weight_in[6] ENN=n12 CP=ZCTSNET_0
+ CDN=HFSNET_8 Q=weight_reg[6] VDD=VDD VSS=VSS
Xweight_reg_reg_5_ decrq1 $PINS D=weight_in[5] ENN=n12 CP=ZCTSNET_0
+ CDN=HFSNET_9 Q=weight_reg[5] VDD=VDD VSS=VSS
Xweight_reg_reg_4_ decrq1 $PINS D=weight_in[4] ENN=n12 CP=ZCTSNET_0
+ CDN=HFSNET_8 Q=weight_reg[4] VDD=VDD VSS=VSS
Xweight_reg_reg_3_ decrq1 $PINS D=weight_in[3] ENN=n12 CP=ZCTSNET_1
+ CDN=HFSNET_9 Q=weight_reg[3] VDD=VDD VSS=VSS
Xweight_reg_reg_2_ decrq1 $PINS D=weight_in[2] ENN=n12 CP=ZCTSNET_0
+ CDN=HFSNET_8 Q=weight_reg[2] VDD=VDD VSS=VSS
Xweight_reg_reg_1_ decrq1 $PINS D=weight_in[1] ENN=n12 CP=ZCTSNET_13
+ CDN=HFSNET_8 Q=weight_reg[1] VDD=VDD VSS=VSS
Xweight_reg_reg_0_ decrq1 $PINS D=copt_gre_net_2957 ENN=n12 CP=ZCTSNET_0
+ CDN=HFSNET_8 Q=weight_reg[0] VDD=VDD VSS=VSS
Xpsum_out_reg_11_ decrq1 $PINS D=N_uc_51 ENN=HFSNET_6 CP=ZCTSNET_12
+ CDN=HFSNET_9 Q=psum_out[11] VDD=VDD VSS=VSS
Xpsum_out_reg_12_ decrq1 $PINS D=N_uc_52 ENN=HFSNET_6 CP=ZCTSNET_12
+ CDN=HFSNET_9 Q=psum_out[12] VDD=VDD VSS=VSS
Xpsum_out_reg_13_ decrq1 $PINS D=N_uc_53 ENN=HFSNET_6 CP=ZCTSNET_12
+ CDN=HFSNET_9 Q=psum_out[13] VDD=VDD VSS=VSS
Xpsum_out_reg_14_ decrq1 $PINS D=N_uc_54 ENN=HFSNET_6 CP=ZCTSNET_12
+ CDN=HFSNET_9 Q=psum_out[14] VDD=VDD VSS=VSS
Xpsum_out_reg_15_ decrq1 $PINS D=N_uc_55 ENN=HFSNET_6 CP=ZCTSNET_12
+ CDN=HFSNET_9 Q=psum_out[15] VDD=VDD VSS=VSS
Xpsum_out_reg_16_ decrq1 $PINS D=N_uc_56 ENN=HFSNET_6 CP=ZCTSNET_0 CDN=HFSNET_9
+ Q=psum_out[16] VDD=VDD VSS=VSS
Xpsum_out_reg_17_ decrq1 $PINS D=N_uc_57 ENN=HFSNET_6 CP=ZCTSNET_0 CDN=HFSNET_9
+ Q=psum_out[17] VDD=VDD VSS=VSS
Xpsum_out_reg_18_ decrq1 $PINS D=N_uc_58 ENN=HFSNET_6 CP=ZCTSNET_0 CDN=HFSNET_9
+ Q=psum_out[18] VDD=VDD VSS=VSS
Xpsum_out_reg_19_ decrq1 $PINS D=N_uc_59 ENN=HFSNET_6 CP=ZCTSNET_0 CDN=HFSNET_9
+ Q=psum_out[19] VDD=VDD VSS=VSS
Xpsum_out_reg_20_ decrq1 $PINS D=N_uc_60 ENN=array_en CP=ZCTSNET_2 CDN=HFSNET_8
+ Q=psum_out[20] VDD=VDD VSS=VSS
Xpsum_out_reg_21_ decrq1 $PINS D=N_uc_61 ENN=array_en CP=ZCTSNET_2 CDN=HFSNET_8
+ Q=psum_out[21] VDD=VDD VSS=VSS
Xpsum_out_reg_22_ decrq1 $PINS D=copt_net_2763 ENN=array_en CP=ZCTSNET_13
+ CDN=HFSNET_8 Q=psum_out[22] VDD=VDD VSS=VSS
Xpsum_out_reg_23_ decrq1 $PINS D=N_uc_63 ENN=array_en CP=ZCTSNET_2 CDN=HFSNET_8
+ Q=psum_out[23] VDD=VDD VSS=VSS
Xpsum_out_reg_24_ decrq1 $PINS D=copt_net_657 ENN=array_en CP=ZCTSNET_13
+ CDN=HFSNET_8 Q=psum_out[24] VDD=VDD VSS=VSS
Xpsum_out_reg_25_ decrq1 $PINS D=N_uc_65 ENN=array_en CP=ZCTSNET_13
+ CDN=HFSNET_8 Q=psum_out[25] VDD=VDD VSS=VSS
Xpsum_out_reg_26_ decrq1 $PINS D=N_uc_66 ENN=array_en CP=ZCTSNET_0 CDN=HFSNET_8
+ Q=psum_out[26] VDD=VDD VSS=VSS
Xpsum_out_reg_27_ decrq1 $PINS D=N_uc_67 ENN=array_en CP=ZCTSNET_13
+ CDN=HFSNET_8 Q=psum_out[27] VDD=VDD VSS=VSS
Xpsum_out_reg_28_ decrq1 $PINS D=N_uc_68 ENN=array_en CP=ZCTSNET_13
+ CDN=HFSNET_8 Q=psum_out[28] VDD=VDD VSS=VSS
Xpsum_out_reg_29_ decrq1 $PINS D=N_uc_69 ENN=array_en CP=ZCTSNET_13
+ CDN=HFSNET_8 Q=psum_out[29] VDD=VDD VSS=VSS
Xpsum_out_reg_30_ decrq1 $PINS D=N_uc_70 ENN=array_en CP=ZCTSNET_0 CDN=HFSNET_8
+ Q=psum_out[30] VDD=VDD VSS=VSS
Xpsum_out_reg_31_ decrq1 $PINS D=N_uc_71 ENN=HFSNET_6 CP=ZCTSNET_12
+ CDN=HFSNET_9 Q=psum_out[31] VDD=VDD VSS=VSS
XU19 inv0d2 $PINS I=n13 ZN=n2 VDD=VDD VSS=VSS
Xcopt_h_inst_3487 dl02d1 $PINS I=N_uc_64 Z=copt_net_657 VDD=VDD VSS=VSS
Xcopt_h_inst_3935 dl01d1 $PINS I=N_uc_40 Z=copt_net_1103 VDD=VDD VSS=VSS
XU22 nd02d1 $PINS A1=weight_load A2=HFSNET_7 ZN=n12 VDD=VDD VSS=VSS
Xcopt_h_inst_5288 dl01d1 $PINS I=N_uc_41 Z=copt_net_2455 VDD=VDD VSS=VSS
Xcopt_h_inst_5346 dl01d1 $PINS I=act_in[2] Z=copt_net_2513 VDD=VDD VSS=VSS
Xcopt_h_inst_5347 dl01d1 $PINS I=act_in[7] Z=copt_net_2514 VDD=VDD VSS=VSS
Xcopt_h_inst_5352 dl01d1 $PINS I=act_in[6] Z=copt_net_2519 VDD=VDD VSS=VSS
XU27 nd02d1 $PINS A1=N_uc_36 A2=HFSNET_2 ZN=n13 VDD=VDD VSS=VSS
Xcopt_h_inst_5353 dl01d1 $PINS I=act_in[4] Z=copt_net_2520 VDD=VDD VSS=VSS
Xcopt_h_inst_5359 dl01d1 $PINS I=act_in[3] Z=copt_net_2526 VDD=VDD VSS=VSS
Xcopt_h_inst_5360 dl01d1 $PINS I=act_in[5] Z=copt_net_2527 VDD=VDD VSS=VSS
Xcopt_h_inst_5596 dl01d1 $PINS I=N_uc_62 Z=copt_net_2763 VDD=VDD VSS=VSS
Xcopt_h_inst_5616 dl01d1 $PINS I=N_uc_42 Z=copt_net_2783 VDD=VDD VSS=VSS
Xcopt_h_inst_5663 dl01d1 $PINS I=act_in[1] Z=copt_net_2829 VDD=VDD VSS=VSS
Xcopt_h_inst_5667 dl01d1 $PINS I=act_in[0] Z=copt_net_2833 VDD=VDD VSS=VSS
Xcopt_gre_h_inst_5785 dl01d1 $PINS I=weight_in[0] Z=copt_gre_net_2957 VDD=VDD
+ VSS=VSS
Xgre_a_INV_1435_inst_5834 inv0d1 $PINS I=weight_reg[0] ZN=gre_a_INV_1435_3
+ VDD=VDD VSS=VSS
.ENDS

.SUBCKT unpu_pe_9_DW_mult_tc_0_DW_mult_tc_7 a[7] a[6] a[5] a[4] a[3] a[2] a[1]
+ a[0] b[7] b[6] b[5] b[4] b[3] b[2] b[1] b[0] product[15] product[14]
+ product[13] product[12] product[11] product[10] product[9] product[8]
+ product[7] product[6] product[5] product[4] product[3] product[2] product[1]
+ product[0] VDD VSS gre_a_INV_1808_2
XU2 ad01d0 $PINS A=n196 B=n61 CI=n2 CO=n1 S=product[14] VDD=VDD VSS=VSS
XU3 ad01d0 $PINS A=n17 B=n16 CI=n3 CO=n2 S=product[13] VDD=VDD VSS=VSS
XU4 ad01d0 $PINS A=n18 B=n19 CI=n4 CO=n3 S=product[12] VDD=VDD VSS=VSS
XU5 ad01d0 $PINS A=n20 B=n23 CI=n5 CO=n4 S=product[11] VDD=VDD VSS=VSS
XU6 ad01d0 $PINS A=n27 B=n24 CI=n6 CO=n5 S=product[10] VDD=VDD VSS=VSS
XU7 ad01d0 $PINS A=n33 B=n28 CI=n7 CO=n6 S=product[9] VDD=VDD VSS=VSS
XU8 ad01d0 $PINS A=n39 B=n34 CI=n8 CO=n7 S=product[8] VDD=VDD VSS=VSS
XU9 ad01d0 $PINS A=n45 B=n40 CI=n9 CO=n8 S=product[7] VDD=VDD VSS=VSS
XU10 ad01d0 $PINS A=n49 B=n46 CI=n10 CO=n9 S=product[6] VDD=VDD VSS=VSS
XU11 ad01d0 $PINS A=n53 B=n50 CI=n11 CO=n10 S=product[5] VDD=VDD VSS=VSS
XU12 ad01d0 $PINS A=n55 B=n54 CI=n12 CO=n11 S=product[4] VDD=VDD VSS=VSS
XU13 ad01d0 $PINS A=n59 B=n56 CI=n13 CO=n12 S=product[3] VDD=VDD VSS=VSS
XU14 ad01d0 $PINS A=n84 B=n91 CI=n14 CO=n13 S=product[2] VDD=VDD VSS=VSS
XctmTdsLR_1_2939 an02d1 $PINS A1=n58 A2=n75 Z=n51 VDD=VDD VSS=VSS
XU17 ad01d0 $PINS A=n195 B=n62 CI=n69 CO=n17 S=n18 VDD=VDD VSS=VSS
XU18 ad01d0 $PINS A=n63 B=n25 CI=n22 CO=n19 S=n20 VDD=VDD VSS=VSS
XU20 ad01d0 $PINS A=n64 B=n26 CI=n29 CO=n23 S=n24 VDD=VDD VSS=VSS
XU21 ad01d0 $PINS A=n194 B=n70 CI=n77 CO=n25 S=n26 VDD=VDD VSS=VSS
XU22 ad01d0 $PINS A=n32 B=n35 CI=n30 CO=n27 S=n28 VDD=VDD VSS=VSS
XU23 ad01d0 $PINS A=n71 B=n65 CI=n37 CO=n29 S=n30 VDD=VDD VSS=VSS
XU25 ad01d0 $PINS A=n38 B=n41 CI=n36 CO=n33 S=n34 VDD=VDD VSS=VSS
XU26 ad01d0 $PINS A=n72 B=n85 CI=n43 CO=n35 S=n36 VDD=VDD VSS=VSS
XU29 ad01d0 $PINS A=n44 B=n47 CI=n42 CO=n39 S=n40 VDD=VDD VSS=VSS
XU30 ad01d0 $PINS A=n86 B=n73 CI=n79 CO=n41 S=n42 VDD=VDD VSS=VSS
XU32 ad01d0 $PINS A=n74 B=n51 CI=n48 CO=n45 S=n46 VDD=VDD VSS=VSS
XU33 ad01d0 $PINS A=n68 B=n87 CI=n80 CO=n47 S=n48 VDD=VDD VSS=VSS
XU34 ad01d0 $PINS A=n88 B=n81 CI=n52 CO=n49 S=n50 VDD=VDD VSS=VSS
XU36 ad01d0 $PINS A=n76 B=n89 CI=n82 CO=n53 S=n54 VDD=VDD VSS=VSS
XU37 ah01d1 $PINS A=n83 B=n90 CO=n55 S=n56 VDD=VDD VSS=VSS
XU145 oai21d1 $PINS B1=n203 B2=n249 A=n222 ZN=n77 VDD=VDD VSS=VSS
XU146 oai21d1 $PINS B1=n201 B2=n250 A=n232 ZN=n69 VDD=VDD VSS=VSS
XU147 oai21d1 $PINS B1=n199 B2=n251 A=n242 ZN=n61 VDD=VDD VSS=VSS
XU148 inv0d0 $PINS I=n16 ZN=n196 VDD=VDD VSS=VSS
XU149 inv0d0 $PINS I=n223 ZN=n201 VDD=VDD VSS=VSS
XU150 inv0d0 $PINS I=n214 ZN=n203 VDD=VDD VSS=VSS
XU151 inv0d0 $PINS I=n233 ZN=n199 VDD=VDD VSS=VSS
XU152 inv0d0 $PINS I=n32 ZN=n194 VDD=VDD VSS=VSS
XU153 inv0d0 $PINS I=n22 ZN=n195 VDD=VDD VSS=VSS
XU154 nd02d1 $PINS A1=n214 A2=n249 ZN=n216 VDD=VDD VSS=VSS
XU155 xr02d1 $PINS A1=a[2] A2=n204 Z=n214 VDD=VDD VSS=VSS
XU156 inv0d1 $PINS I=a[1] ZN=n204 VDD=VDD VSS=VSS
XU157 nd02d1 $PINS A1=n223 A2=n250 ZN=n225 VDD=VDD VSS=VSS
XU158 xr02d1 $PINS A1=a[4] A2=n202 Z=n223 VDD=VDD VSS=VSS
XU159 inv0d1 $PINS I=a[3] ZN=n202 VDD=VDD VSS=VSS
XU160 nd02d1 $PINS A1=a[1] A2=a[0] ZN=n206 VDD=VDD VSS=VSS
XU162 inv0d0 $PINS I=b[0] ZN=n197 VDD=VDD VSS=VSS
XU163 xr02d1 $PINS A1=a[6] A2=n200 Z=n233 VDD=VDD VSS=VSS
XU164 inv0d1 $PINS I=a[5] ZN=n200 VDD=VDD VSS=VSS
XU165 nd02d1 $PINS A1=n233 A2=n251 ZN=n235 VDD=VDD VSS=VSS
XU167 inv0d0 $PINS I=n1 ZN=product[15] VDD=VDD VSS=VSS
XU168 nr02d0 $PINS A1=a[0] A2=n197 ZN=product[0] VDD=VDD VSS=VSS
XU169 oai22d1 $PINS A1=b[0] A2=n206 B1=n207 B2=a[0] ZN=n92 VDD=VDD VSS=VSS
XU170 oai22d1 $PINS A1=n207 A2=n206 B1=n208 B2=a[0] ZN=n91 VDD=VDD VSS=VSS
XU171 xr02d1 $PINS A1=b[1] A2=n204 Z=n207 VDD=VDD VSS=VSS
XU172 oai22d1 $PINS A1=n208 A2=n206 B1=n209 B2=a[0] ZN=n90 VDD=VDD VSS=VSS
XU173 xr02d1 $PINS A1=b[2] A2=n204 Z=n208 VDD=VDD VSS=VSS
XU174 oai22d1 $PINS A1=n209 A2=n206 B1=n210 B2=a[0] ZN=n89 VDD=VDD VSS=VSS
XU175 xr02d1 $PINS A1=b[3] A2=n204 Z=n209 VDD=VDD VSS=VSS
XU176 oai22d1 $PINS A1=n210 A2=n206 B1=n211 B2=a[0] ZN=n88 VDD=VDD VSS=VSS
XU177 xr02d1 $PINS A1=b[4] A2=n204 Z=n210 VDD=VDD VSS=VSS
XU178 oai22d1 $PINS A1=n211 A2=n206 B1=n212 B2=a[0] ZN=n87 VDD=VDD VSS=VSS
XU179 xr02d1 $PINS A1=b[5] A2=n204 Z=n211 VDD=VDD VSS=VSS
XU180 oai22d1 $PINS A1=n212 A2=n206 B1=n213 B2=a[0] ZN=n86 VDD=VDD VSS=VSS
XU181 xr02d1 $PINS A1=b[6] A2=n204 Z=n212 VDD=VDD VSS=VSS
XU182 aor21d1 $PINS B1=a[0] B2=n206 A=n213 Z=n85 VDD=VDD VSS=VSS
XU183 xr02d1 $PINS A1=b[7] A2=n204 Z=n213 VDD=VDD VSS=VSS
XU184 nr02d0 $PINS A1=n214 A2=n197 ZN=n84 VDD=VDD VSS=VSS
XU185 oai22d1 $PINS A1=n216 A2=n215 B1=n214 B2=n217 ZN=n83 VDD=VDD VSS=VSS
XctmTdsLR_1_2919 an02d1 $PINS A1=n60 A2=n92 Z=n14 VDD=VDD VSS=VSS
XU187 oai22d1 $PINS A1=n217 A2=n216 B1=n214 B2=n218 ZN=n82 VDD=VDD VSS=VSS
XU188 xr02d1 $PINS A1=b[1] A2=n202 Z=n217 VDD=VDD VSS=VSS
XU189 oai22d1 $PINS A1=n218 A2=n216 B1=n214 B2=n219 ZN=n81 VDD=VDD VSS=VSS
XU190 xr02d1 $PINS A1=b[2] A2=n202 Z=n218 VDD=VDD VSS=VSS
XU191 oai22d1 $PINS A1=n219 A2=n216 B1=n214 B2=n220 ZN=n80 VDD=VDD VSS=VSS
XU192 xr02d1 $PINS A1=b[3] A2=n202 Z=n219 VDD=VDD VSS=VSS
XU193 oai22d1 $PINS A1=n220 A2=n216 B1=n214 B2=n221 ZN=n79 VDD=VDD VSS=VSS
XU194 xr02d1 $PINS A1=b[4] A2=n202 Z=n220 VDD=VDD VSS=VSS
XU195 nr02d0 $PINS A1=n223 A2=n197 ZN=n76 VDD=VDD VSS=VSS
XU196 oai22d1 $PINS A1=n225 A2=n224 B1=n223 B2=n226 ZN=n75 VDD=VDD VSS=VSS
XctmTdsLR_2_2920 aoim21d1 $PINS B1=n92 B2=n60 A=n14 ZN=product[1] VDD=VDD
+ VSS=VSS
XU198 oai22d1 $PINS A1=n226 A2=n225 B1=n223 B2=n227 ZN=n74 VDD=VDD VSS=VSS
XU199 xr02d1 $PINS A1=b[1] A2=n200 Z=n226 VDD=VDD VSS=VSS
XU200 oai22d1 $PINS A1=n227 A2=n225 B1=n223 B2=n228 ZN=n73 VDD=VDD VSS=VSS
XU201 xr02d1 $PINS A1=b[2] A2=n200 Z=n227 VDD=VDD VSS=VSS
XU202 oai22d1 $PINS A1=n228 A2=n225 B1=n223 B2=n229 ZN=n72 VDD=VDD VSS=VSS
XU203 xr02d1 $PINS A1=b[3] A2=n200 Z=n228 VDD=VDD VSS=VSS
XU204 oai22d1 $PINS A1=n229 A2=n225 B1=n223 B2=n230 ZN=n71 VDD=VDD VSS=VSS
XU205 xr02d1 $PINS A1=b[4] A2=n200 Z=n229 VDD=VDD VSS=VSS
XU206 oai22d1 $PINS A1=n230 A2=n225 B1=n223 B2=n231 ZN=n70 VDD=VDD VSS=VSS
XU207 xr02d1 $PINS A1=b[5] A2=n200 Z=n230 VDD=VDD VSS=VSS
XU208 nr02d0 $PINS A1=n233 A2=n197 ZN=n68 VDD=VDD VSS=VSS
XU209 oai22d1 $PINS A1=n235 A2=n234 B1=n233 B2=n236 ZN=n67 VDD=VDD VSS=VSS
XctmTdsLR_2_2940 aoim21d1 $PINS B1=n58 B2=n75 A=n51 ZN=n52 VDD=VDD VSS=VSS
XU211 oai22d1 $PINS A1=n237 A2=n235 B1=n233 B2=n238 ZN=n65 VDD=VDD VSS=VSS
XU212 oai22d1 $PINS A1=n238 A2=n235 B1=n233 B2=n239 ZN=n64 VDD=VDD VSS=VSS
XU213 xr02d1 $PINS A1=b[3] A2=gre_a_INV_1808_2 Z=n238 VDD=VDD VSS=VSS
XU214 oai22d1 $PINS A1=n239 A2=n235 B1=n233 B2=n240 ZN=n63 VDD=VDD VSS=VSS
XU215 xr02d1 $PINS A1=b[4] A2=gre_a_INV_1808_2 Z=n239 VDD=VDD VSS=VSS
XU216 oai22d1 $PINS A1=n240 A2=n235 B1=n233 B2=n241 ZN=n62 VDD=VDD VSS=VSS
XU217 xr02d1 $PINS A1=b[5] A2=gre_a_INV_1808_2 Z=n240 VDD=VDD VSS=VSS
XU218 oai21d1 $PINS B1=n204 B2=b[0] A=n206 ZN=n60 VDD=VDD VSS=VSS
XU219 oai21d1 $PINS B1=n202 B2=n216 A=n243 ZN=n59 VDD=VDD VSS=VSS
XU220 nd03d0 $PINS A1=n203 A2=n197 A3=a[3] ZN=n243 VDD=VDD VSS=VSS
XU221 oai21d1 $PINS B1=n200 B2=n225 A=n244 ZN=n58 VDD=VDD VSS=VSS
XU222 nd03d0 $PINS A1=n201 A2=n197 A3=a[5] ZN=n244 VDD=VDD VSS=VSS
XU223 oai21d1 $PINS B1=gre_a_INV_1808_2 B2=n235 A=n245 ZN=n57 VDD=VDD VSS=VSS
XU224 nd03d0 $PINS A1=n199 A2=n197 A3=a[7] ZN=n245 VDD=VDD VSS=VSS
XU225 xn02d1 $PINS A1=n246 A2=n247 ZN=n38 VDD=VDD VSS=VSS
XU226 or02d0 $PINS A1=n247 A2=n246 Z=n37 VDD=VDD VSS=VSS
XU227 oai22d1 $PINS A1=n236 A2=n235 B1=n233 B2=n237 ZN=n246 VDD=VDD VSS=VSS
XU228 xr02d1 $PINS A1=b[2] A2=gre_a_INV_1808_2 Z=n237 VDD=VDD VSS=VSS
XU229 xr02d1 $PINS A1=b[1] A2=gre_a_INV_1808_2 Z=n236 VDD=VDD VSS=VSS
XU230 oai22d1 $PINS A1=n221 A2=n216 B1=n214 B2=n248 ZN=n247 VDD=VDD VSS=VSS
XU231 xr02d1 $PINS A1=b[5] A2=n202 Z=n221 VDD=VDD VSS=VSS
XU232 aoim22d1 $PINS A1=n203 A2=n222 B1=n248 B2=n216 Z=n32 VDD=VDD VSS=VSS
XU233 xr02d1 $PINS A1=a[3] A2=a[2] Z=n249 VDD=VDD VSS=VSS
XU234 xr02d1 $PINS A1=b[6] A2=n202 Z=n248 VDD=VDD VSS=VSS
XU235 xr02d1 $PINS A1=b[7] A2=a[3] Z=n222 VDD=VDD VSS=VSS
XU236 aoim22d1 $PINS A1=n201 A2=n232 B1=n231 B2=n225 Z=n22 VDD=VDD VSS=VSS
XU237 xr02d1 $PINS A1=a[5] A2=a[4] Z=n250 VDD=VDD VSS=VSS
XU238 xr02d1 $PINS A1=b[6] A2=n200 Z=n231 VDD=VDD VSS=VSS
XU239 xr02d1 $PINS A1=b[7] A2=a[5] Z=n232 VDD=VDD VSS=VSS
XU240 aoim22d1 $PINS A1=n199 A2=n242 B1=n241 B2=n235 Z=n16 VDD=VDD VSS=VSS
XU241 xr02d1 $PINS A1=a[7] A2=a[6] Z=n251 VDD=VDD VSS=VSS
XU242 xr02d1 $PINS A1=b[6] A2=gre_a_INV_1808_2 Z=n241 VDD=VDD VSS=VSS
XU243 xr02d1 $PINS A1=b[7] A2=a[7] Z=n242 VDD=VDD VSS=VSS
XctmTdsLR_1_1327 aoim22d1 $PINS A1=n202 A2=b[0] B1=n202 B2=b[0] Z=n215 VDD=VDD
+ VSS=VSS
XctmTdsLR_1_1328 aoim22d1 $PINS A1=n200 A2=b[0] B1=n200 B2=b[0] Z=n224 VDD=VDD
+ VSS=VSS
XctmTdsLR_1_1329 aoim22d1 $PINS A1=gre_a_INV_1808_2 A2=b[0] B1=gre_a_INV_1808_2
+ B2=b[0] Z=n234 VDD=VDD VSS=VSS
XctmTdsLR_1_2941 an02d1 $PINS A1=n57 A2=n67 Z=n43 VDD=VDD VSS=VSS
XctmTdsLR_2_2942 aoim21d1 $PINS B1=n57 B2=n67 A=n43 ZN=n44 VDD=VDD VSS=VSS
.ENDS

.SUBCKT unpu_pe_9_DW_mult_uns_0_DW_mult_uns_8 a[7] a[6] a[5] a[4] a[3] a[2]
+ a[1] a[0] b[7] b[6] b[5] b[4] b[3] b[2] b[1] b[0] product[15] product[14]
+ product[13] product[12] product[11] product[10] product[9] product[8]
+ product[7] product[6] product[5] product[4] product[3] product[2] product[1]
+ product[0] VDD VSS
XU2 ad01d0 $PINS A=n99 B=n15 CI=n2 CO=product[15] S=product[14] VDD=VDD VSS=VSS
XU3 ad01d0 $PINS A=n16 B=n17 CI=n3 CO=n2 S=product[13] VDD=VDD VSS=VSS
XU4 ad01d0 $PINS A=n18 B=n21 CI=n4 CO=n3 S=product[12] VDD=VDD VSS=VSS
XU5 ad01d0 $PINS A=n27 B=n22 CI=n5 CO=n4 S=product[11] VDD=VDD VSS=VSS
XU6 ad01d0 $PINS A=n35 B=n28 CI=n6 CO=n5 S=product[10] VDD=VDD VSS=VSS
XU7 ad01d0 $PINS A=n45 B=n36 CI=n7 CO=n6 S=product[9] VDD=VDD VSS=VSS
XU8 ad01d0 $PINS A=n57 B=n46 CI=n8 CO=n7 S=product[8] VDD=VDD VSS=VSS
XU9 ad01d0 $PINS A=n69 B=n58 CI=n9 CO=n8 S=product[7] VDD=VDD VSS=VSS
XU10 ad01d0 $PINS A=n79 B=n70 CI=n10 CO=n9 S=product[6] VDD=VDD VSS=VSS
XU11 ad01d0 $PINS A=n87 B=n80 CI=n11 CO=n10 S=product[5] VDD=VDD VSS=VSS
XU12 ad01d0 $PINS A=n93 B=n88 CI=n12 CO=n11 S=product[4] VDD=VDD VSS=VSS
XU13 ad01d0 $PINS A=n96 B=n13 CI=n94 CO=n12 S=product[3] VDD=VDD VSS=VSS
XU14 ad01d0 $PINS A=n146 B=n14 CI=n98 CO=n13 S=product[2] VDD=VDD VSS=VSS
XU15 ah01d1 $PINS A=n161 B=n154 CO=n14 S=product[1] VDD=VDD VSS=VSS
XU16 ad01d0 $PINS A=n107 B=n100 CI=n19 CO=n15 S=n16 VDD=VDD VSS=VSS
XU17 ad01d0 $PINS A=n25 B=n20 CI=n23 CO=n17 S=n18 VDD=VDD VSS=VSS
XU18 ad01d0 $PINS A=n115 B=n101 CI=n108 CO=n19 S=n20 VDD=VDD VSS=VSS
XU19 ad01d0 $PINS A=n31 B=n24 CI=n29 CO=n21 S=n22 VDD=VDD VSS=VSS
XU20 ad01d0 $PINS A=n116 B=n33 CI=n26 CO=n23 S=n24 VDD=VDD VSS=VSS
XU21 ad01d0 $PINS A=n123 B=n102 CI=n109 CO=n25 S=n26 VDD=VDD VSS=VSS
XU22 ad01d0 $PINS A=n32 B=n37 CI=n30 CO=n27 S=n28 VDD=VDD VSS=VSS
XU23 ad01d0 $PINS A=n41 B=n34 CI=n39 CO=n29 S=n30 VDD=VDD VSS=VSS
XU24 ad01d0 $PINS A=n124 B=n117 CI=n43 CO=n31 S=n32 VDD=VDD VSS=VSS
XU25 ad01d0 $PINS A=n131 B=n103 CI=n110 CO=n33 S=n34 VDD=VDD VSS=VSS
XU26 ad01d0 $PINS A=n40 B=n47 CI=n38 CO=n35 S=n36 VDD=VDD VSS=VSS
XU27 ad01d0 $PINS A=n44 B=n51 CI=n49 CO=n37 S=n38 VDD=VDD VSS=VSS
XU28 ad01d0 $PINS A=n55 B=n53 CI=n42 CO=n39 S=n40 VDD=VDD VSS=VSS
XU29 ad01d0 $PINS A=n118 B=n125 CI=n132 CO=n41 S=n42 VDD=VDD VSS=VSS
XU30 ad01d0 $PINS A=n139 B=n104 CI=n111 CO=n43 S=n44 VDD=VDD VSS=VSS
XU31 ad01d0 $PINS A=n50 B=n59 CI=n48 CO=n45 S=n46 VDD=VDD VSS=VSS
XU32 ad01d0 $PINS A=n54 B=n52 CI=n61 CO=n47 S=n48 VDD=VDD VSS=VSS
XU33 ad01d0 $PINS A=n56 B=n65 CI=n63 CO=n49 S=n50 VDD=VDD VSS=VSS
XU34 ad01d0 $PINS A=n140 B=n133 CI=n67 CO=n51 S=n52 VDD=VDD VSS=VSS
XU35 ad01d0 $PINS A=n126 B=n119 CI=n147 CO=n53 S=n54 VDD=VDD VSS=VSS
XU36 ah01d1 $PINS A=n105 B=n112 CO=n55 S=n56 VDD=VDD VSS=VSS
XU37 ad01d0 $PINS A=n71 B=n62 CI=n60 CO=n57 S=n58 VDD=VDD VSS=VSS
XU38 ad01d0 $PINS A=n64 B=n66 CI=n73 CO=n59 S=n60 VDD=VDD VSS=VSS
XU39 ad01d0 $PINS A=n77 B=n68 CI=n75 CO=n61 S=n62 VDD=VDD VSS=VSS
XU40 ad01d0 $PINS A=n141 B=n127 CI=n134 CO=n63 S=n64 VDD=VDD VSS=VSS
XU41 ad01d0 $PINS A=n155 B=n120 CI=n148 CO=n65 S=n66 VDD=VDD VSS=VSS
XU42 ah01d1 $PINS A=n106 B=n113 CO=n67 S=n68 VDD=VDD VSS=VSS
XU43 ad01d0 $PINS A=n81 B=n74 CI=n72 CO=n69 S=n70 VDD=VDD VSS=VSS
XU44 ad01d0 $PINS A=n78 B=n83 CI=n76 CO=n71 S=n72 VDD=VDD VSS=VSS
XU45 ad01d0 $PINS A=n142 B=n135 CI=n85 CO=n73 S=n74 VDD=VDD VSS=VSS
XU46 ad01d0 $PINS A=n156 B=n128 CI=n149 CO=n75 S=n76 VDD=VDD VSS=VSS
XU47 ah01d1 $PINS A=n114 B=n121 CO=n77 S=n78 VDD=VDD VSS=VSS
XU48 ad01d0 $PINS A=n89 B=n84 CI=n82 CO=n79 S=n80 VDD=VDD VSS=VSS
XU49 ad01d0 $PINS A=n150 B=n91 CI=n86 CO=n81 S=n82 VDD=VDD VSS=VSS
XU50 ad01d0 $PINS A=n157 B=n136 CI=n143 CO=n83 S=n84 VDD=VDD VSS=VSS
XU51 ah01d1 $PINS A=n122 B=n129 CO=n85 S=n86 VDD=VDD VSS=VSS
XU52 ad01d0 $PINS A=n95 B=n92 CI=n90 CO=n87 S=n88 VDD=VDD VSS=VSS
XU53 ad01d0 $PINS A=n158 B=n144 CI=n151 CO=n89 S=n90 VDD=VDD VSS=VSS
XU54 ah01d1 $PINS A=n130 B=n137 CO=n91 S=n92 VDD=VDD VSS=VSS
XU55 ad01d0 $PINS A=n159 B=n152 CI=n97 CO=n93 S=n94 VDD=VDD VSS=VSS
XU56 ah01d1 $PINS A=n138 B=n145 CO=n95 S=n96 VDD=VDD VSS=VSS
XU57 ah01d1 $PINS A=n153 B=n160 CO=n97 S=n98 VDD=VDD VSS=VSS
XU140 inv0d0 $PINS I=b[4] ZN=n217 VDD=VDD VSS=VSS
XU141 inv0d0 $PINS I=a[1] ZN=n228 VDD=VDD VSS=VSS
XU142 inv0d0 $PINS I=b[2] ZN=n219 VDD=VDD VSS=VSS
XU144 inv0d0 $PINS I=a[2] ZN=n227 VDD=VDD VSS=VSS
XU145 inv0d0 $PINS I=b[3] ZN=n218 VDD=VDD VSS=VSS
XU146 inv0d0 $PINS I=a[5] ZN=n224 VDD=VDD VSS=VSS
XU147 inv0d0 $PINS I=b[1] ZN=n220 VDD=VDD VSS=VSS
XU148 inv0d0 $PINS I=b[0] ZN=n221 VDD=VDD VSS=VSS
XU149 inv0d0 $PINS I=a[4] ZN=n225 VDD=VDD VSS=VSS
XU150 inv0d0 $PINS I=b[6] ZN=n215 VDD=VDD VSS=VSS
XU151 inv0d0 $PINS I=a[3] ZN=n226 VDD=VDD VSS=VSS
XU152 inv0d0 $PINS I=b[5] ZN=n216 VDD=VDD VSS=VSS
XU153 inv0d0 $PINS I=b[7] ZN=n214 VDD=VDD VSS=VSS
XU154 inv0d0 $PINS I=a[6] ZN=n223 VDD=VDD VSS=VSS
XU156 nr02d0 $PINS A1=a[0] A2=n221 ZN=product[0] VDD=VDD VSS=VSS
XU157 nr02d0 $PINS A1=a[7] A2=n214 ZN=n99 VDD=VDD VSS=VSS
XU158 nr02d0 $PINS A1=a[0] A2=n220 ZN=n161 VDD=VDD VSS=VSS
XU159 nr02d0 $PINS A1=a[0] A2=n219 ZN=n160 VDD=VDD VSS=VSS
XU160 nr02d0 $PINS A1=a[0] A2=n218 ZN=n159 VDD=VDD VSS=VSS
XU161 nr02d0 $PINS A1=a[0] A2=n217 ZN=n158 VDD=VDD VSS=VSS
XU162 nr02d0 $PINS A1=a[0] A2=n216 ZN=n157 VDD=VDD VSS=VSS
XU163 nr02d0 $PINS A1=a[0] A2=n215 ZN=n156 VDD=VDD VSS=VSS
XU164 nr02d0 $PINS A1=a[0] A2=n214 ZN=n155 VDD=VDD VSS=VSS
XU165 nr02d0 $PINS A1=n221 A2=n228 ZN=n154 VDD=VDD VSS=VSS
XU166 nr02d0 $PINS A1=n220 A2=n228 ZN=n153 VDD=VDD VSS=VSS
XU167 nr02d0 $PINS A1=n219 A2=n228 ZN=n152 VDD=VDD VSS=VSS
XU168 nr02d0 $PINS A1=n218 A2=n228 ZN=n151 VDD=VDD VSS=VSS
XU169 nr02d0 $PINS A1=n217 A2=n228 ZN=n150 VDD=VDD VSS=VSS
XU170 nr02d0 $PINS A1=n216 A2=n228 ZN=n149 VDD=VDD VSS=VSS
XU171 nr02d0 $PINS A1=n215 A2=n228 ZN=n148 VDD=VDD VSS=VSS
XU172 nr02d0 $PINS A1=n214 A2=n228 ZN=n147 VDD=VDD VSS=VSS
XU173 nr02d0 $PINS A1=n221 A2=n227 ZN=n146 VDD=VDD VSS=VSS
XU174 nr02d0 $PINS A1=n220 A2=n227 ZN=n145 VDD=VDD VSS=VSS
XU175 nr02d0 $PINS A1=n219 A2=n227 ZN=n144 VDD=VDD VSS=VSS
XU176 nr02d0 $PINS A1=n218 A2=n227 ZN=n143 VDD=VDD VSS=VSS
XU177 nr02d0 $PINS A1=n217 A2=n227 ZN=n142 VDD=VDD VSS=VSS
XU178 nr02d0 $PINS A1=n216 A2=n227 ZN=n141 VDD=VDD VSS=VSS
XU179 nr02d0 $PINS A1=n215 A2=n227 ZN=n140 VDD=VDD VSS=VSS
XU180 nr02d0 $PINS A1=n214 A2=n227 ZN=n139 VDD=VDD VSS=VSS
XU181 nr02d0 $PINS A1=n221 A2=n226 ZN=n138 VDD=VDD VSS=VSS
XU182 nr02d0 $PINS A1=n220 A2=n226 ZN=n137 VDD=VDD VSS=VSS
XU183 nr02d0 $PINS A1=n219 A2=n226 ZN=n136 VDD=VDD VSS=VSS
XU184 nr02d0 $PINS A1=n218 A2=n226 ZN=n135 VDD=VDD VSS=VSS
XU185 nr02d0 $PINS A1=n217 A2=n226 ZN=n134 VDD=VDD VSS=VSS
XU186 nr02d0 $PINS A1=n216 A2=n226 ZN=n133 VDD=VDD VSS=VSS
XU187 nr02d0 $PINS A1=n215 A2=n226 ZN=n132 VDD=VDD VSS=VSS
XU188 nr02d0 $PINS A1=n214 A2=n226 ZN=n131 VDD=VDD VSS=VSS
XU189 nr02d0 $PINS A1=n221 A2=n225 ZN=n130 VDD=VDD VSS=VSS
XU190 nr02d0 $PINS A1=n220 A2=n225 ZN=n129 VDD=VDD VSS=VSS
XU191 nr02d0 $PINS A1=n219 A2=n225 ZN=n128 VDD=VDD VSS=VSS
XU192 nr02d0 $PINS A1=n218 A2=n225 ZN=n127 VDD=VDD VSS=VSS
XU193 nr02d0 $PINS A1=n217 A2=n225 ZN=n126 VDD=VDD VSS=VSS
XU194 nr02d0 $PINS A1=n216 A2=n225 ZN=n125 VDD=VDD VSS=VSS
XU195 nr02d0 $PINS A1=n215 A2=n225 ZN=n124 VDD=VDD VSS=VSS
XU196 nr02d0 $PINS A1=n214 A2=n225 ZN=n123 VDD=VDD VSS=VSS
XU197 nr02d0 $PINS A1=n221 A2=n224 ZN=n122 VDD=VDD VSS=VSS
XU198 nr02d0 $PINS A1=n220 A2=n224 ZN=n121 VDD=VDD VSS=VSS
XU199 nr02d0 $PINS A1=n219 A2=n224 ZN=n120 VDD=VDD VSS=VSS
XU200 nr02d0 $PINS A1=n218 A2=n224 ZN=n119 VDD=VDD VSS=VSS
XU201 nr02d0 $PINS A1=n217 A2=n224 ZN=n118 VDD=VDD VSS=VSS
XU202 nr02d0 $PINS A1=n216 A2=n224 ZN=n117 VDD=VDD VSS=VSS
XU203 nr02d0 $PINS A1=n215 A2=n224 ZN=n116 VDD=VDD VSS=VSS
XU204 nr02d0 $PINS A1=n214 A2=n224 ZN=n115 VDD=VDD VSS=VSS
XU205 nr02d0 $PINS A1=n221 A2=n223 ZN=n114 VDD=VDD VSS=VSS
XU206 nr02d0 $PINS A1=n220 A2=n223 ZN=n113 VDD=VDD VSS=VSS
XU207 nr02d0 $PINS A1=n219 A2=n223 ZN=n112 VDD=VDD VSS=VSS
XU208 nr02d0 $PINS A1=n218 A2=n223 ZN=n111 VDD=VDD VSS=VSS
XU209 nr02d0 $PINS A1=n217 A2=n223 ZN=n110 VDD=VDD VSS=VSS
XU210 nr02d0 $PINS A1=n216 A2=n223 ZN=n109 VDD=VDD VSS=VSS
XU211 nr02d0 $PINS A1=n215 A2=n223 ZN=n108 VDD=VDD VSS=VSS
XU212 nr02d0 $PINS A1=n214 A2=n223 ZN=n107 VDD=VDD VSS=VSS
XU213 nr02d0 $PINS A1=n221 A2=a[7] ZN=n106 VDD=VDD VSS=VSS
XU214 nr02d0 $PINS A1=a[7] A2=n220 ZN=n105 VDD=VDD VSS=VSS
XU215 nr02d0 $PINS A1=a[7] A2=n219 ZN=n104 VDD=VDD VSS=VSS
XU216 nr02d0 $PINS A1=a[7] A2=n218 ZN=n103 VDD=VDD VSS=VSS
XU217 nr02d0 $PINS A1=a[7] A2=n217 ZN=n102 VDD=VDD VSS=VSS
XU218 nr02d0 $PINS A1=a[7] A2=n216 ZN=n101 VDD=VDD VSS=VSS
XU219 nr02d0 $PINS A1=a[7] A2=n215 ZN=n100 VDD=VDD VSS=VSS
.ENDS

.SUBCKT unpu_pe_9_DW01_add_0_DW01_add_10 A[31] A[30] A[29] A[28] A[27] A[26]
+ A[25] A[24] A[23] A[22] A[21] A[20] A[19] A[18] A[17] A[16] A[15] A[14] A[13]
+ A[12] A[11] A[10] A[9] A[8] A[7] A[6] A[5] A[4] A[3] A[2] A[1] A[0] B[31]
+ B[30] B[29] B[28] B[27] B[26] B[25] B[24] B[23] B[22] B[21] B[20] B[19] B[18]
+ B[17] B[16] B[15] B[14] B[13] B[12] B[11] B[10] B[9] B[8] B[7] B[6] B[5] B[4]
+ B[3] B[2] B[1] B[0] CI SUM[31] SUM[30] SUM[29] SUM[28] SUM[27] SUM[26]
+ SUM[25] SUM[24] SUM[23] SUM[22] SUM[21] SUM[20] SUM[19] SUM[18] SUM[17]
+ SUM[16] SUM[15] SUM[14] SUM[13] SUM[12] SUM[11] SUM[10] SUM[9] SUM[8] SUM[7]
+ SUM[6] SUM[5] SUM[4] SUM[3] SUM[2] SUM[1] SUM[0] CO VDD VSS
XU1_31 ad01d0 $PINS A=copt_net_1757 B=B[31] CI=carry[31] S=SUM[31] VDD=VDD
+ VSS=VSS
XU1_30 ad01d0 $PINS A=copt_net_1762 B=B[30] CI=carry[30] CO=carry[31] S=SUM[30]
+ VDD=VDD VSS=VSS
XU1_29 ad01d0 $PINS A=copt_net_1874 B=B[29] CI=carry[29] CO=carry[30] S=SUM[29]
+ VDD=VDD VSS=VSS
XU1_28 ad01d0 $PINS A=copt_net_1845 B=B[28] CI=carry[28] CO=carry[29] S=SUM[28]
+ VDD=VDD VSS=VSS
XU1_27 ad01d0 $PINS A=copt_net_1811 B=B[27] CI=carry[27] CO=carry[28] S=SUM[27]
+ VDD=VDD VSS=VSS
XU1_26 ad01d0 $PINS A=copt_net_1830 B=B[26] CI=carry[26] CO=carry[27] S=SUM[26]
+ VDD=VDD VSS=VSS
XU1_25 ad01d0 $PINS A=copt_net_1746 B=B[25] CI=carry[25] CO=carry[26] S=SUM[25]
+ VDD=VDD VSS=VSS
XU1_24 ad01d0 $PINS A=copt_net_1730 B=B[24] CI=carry[24] CO=carry[25] S=SUM[24]
+ VDD=VDD VSS=VSS
XU1_23 ad01d0 $PINS A=copt_net_1756 B=B[23] CI=carry[23] CO=carry[24] S=SUM[23]
+ VDD=VDD VSS=VSS
XU1_22 ad01d0 $PINS A=copt_net_1623 B=B[22] CI=carry[22] CO=carry[23] S=SUM[22]
+ VDD=VDD VSS=VSS
XU1_21 ad01d0 $PINS A=copt_net_1695 B=B[21] CI=carry[21] CO=carry[22] S=SUM[21]
+ VDD=VDD VSS=VSS
XU1_20 ad01d0 $PINS A=copt_net_1767 B=B[20] CI=carry[20] CO=carry[21] S=SUM[20]
+ VDD=VDD VSS=VSS
XU1_19 ad01d0 $PINS A=copt_net_1809 B=B[19] CI=carry[19] CO=carry[20] S=SUM[19]
+ VDD=VDD VSS=VSS
XU1_18 ad01d0 $PINS A=copt_net_1776 B=B[18] CI=carry[18] CO=carry[19] S=SUM[18]
+ VDD=VDD VSS=VSS
XU1_17 ad01d0 $PINS A=copt_net_1807 B=B[17] CI=carry[17] CO=carry[18] S=SUM[17]
+ VDD=VDD VSS=VSS
XU1_16 ad01d0 $PINS A=copt_net_1810 B=B[16] CI=carry[16] CO=carry[17] S=SUM[16]
+ VDD=VDD VSS=VSS
XU1_15 ad01d0 $PINS A=copt_net_2033 B=B[15] CI=carry[15] CO=carry[16] S=SUM[15]
+ VDD=VDD VSS=VSS
XU1_14 ad01d0 $PINS A=copt_net_1980 B=B[14] CI=carry[14] CO=carry[15] S=SUM[14]
+ VDD=VDD VSS=VSS
XU1_13 ad01d0 $PINS A=copt_net_2023 B=B[13] CI=carry[13] CO=carry[14] S=SUM[13]
+ VDD=VDD VSS=VSS
XU1_12 ad01d0 $PINS A=copt_net_2045 B=B[12] CI=carry[12] CO=carry[13] S=SUM[12]
+ VDD=VDD VSS=VSS
XU1_11 ad01d0 $PINS A=copt_net_1963 B=B[11] CI=carry[11] CO=carry[12] S=SUM[11]
+ VDD=VDD VSS=VSS
XU1_10 ad01d0 $PINS A=copt_net_2022 B=B[10] CI=carry[10] CO=carry[11] S=SUM[10]
+ VDD=VDD VSS=VSS
XU1_9 ad01d0 $PINS A=copt_net_1791 B=B[9] CI=carry[9] CO=carry[10] S=SUM[9]
+ VDD=VDD VSS=VSS
XU1_8 ad01d0 $PINS A=copt_net_1842 B=B[8] CI=carry[8] CO=carry[9] S=SUM[8]
+ VDD=VDD VSS=VSS
XU1_7 ad01d0 $PINS A=copt_net_1721 B=B[7] CI=carry[7] CO=carry[8] S=SUM[7]
+ VDD=VDD VSS=VSS
XU1_6 ad01d0 $PINS A=copt_net_1814 B=B[6] CI=carry[6] CO=carry[7] S=SUM[6]
+ VDD=VDD VSS=VSS
XU1_5 ad01d0 $PINS A=copt_net_1968 B=B[5] CI=carry[5] CO=carry[6] S=SUM[5]
+ VDD=VDD VSS=VSS
XU1_4 ad01d0 $PINS A=copt_net_2043 B=B[4] CI=carry[4] CO=carry[5] S=SUM[4]
+ VDD=VDD VSS=VSS
XU1_3 ad01d0 $PINS A=copt_net_1750 B=B[3] CI=carry[3] CO=carry[4] S=SUM[3]
+ VDD=VDD VSS=VSS
XU1_2 ad01d0 $PINS A=copt_net_1901 B=B[2] CI=carry[2] CO=carry[3] S=SUM[2]
+ VDD=VDD VSS=VSS
XU1_1 ad01d0 $PINS A=copt_net_1912 B=B[1] CI=n1 CO=carry[2] S=SUM[1] VDD=VDD
+ VSS=VSS
XU1 an02d1 $PINS A1=B[0] A2=copt_net_1531 Z=n1 VDD=VDD VSS=VSS
XU2 xr02d1 $PINS A1=copt_net_1531 A2=B[0] Z=SUM[0] VDD=VDD VSS=VSS
Xcopt_h_inst_4363 dl01d1 $PINS I=A[0] Z=copt_net_1531 VDD=VDD VSS=VSS
Xcopt_h_inst_4455 dl01d1 $PINS I=A[22] Z=copt_net_1623 VDD=VDD VSS=VSS
Xcopt_h_inst_4527 dl01d1 $PINS I=A[21] Z=copt_net_1695 VDD=VDD VSS=VSS
Xcopt_h_inst_4553 dl01d1 $PINS I=A[7] Z=copt_net_1721 VDD=VDD VSS=VSS
Xcopt_h_inst_4562 dl01d1 $PINS I=A[24] Z=copt_net_1730 VDD=VDD VSS=VSS
Xcopt_h_inst_4578 dl01d1 $PINS I=A[25] Z=copt_net_1746 VDD=VDD VSS=VSS
Xcopt_h_inst_4582 dl01d1 $PINS I=A[3] Z=copt_net_1750 VDD=VDD VSS=VSS
Xcopt_h_inst_4588 dl01d1 $PINS I=A[23] Z=copt_net_1756 VDD=VDD VSS=VSS
Xcopt_h_inst_4589 dl01d1 $PINS I=A[31] Z=copt_net_1757 VDD=VDD VSS=VSS
Xcopt_h_inst_4594 dl01d1 $PINS I=A[30] Z=copt_net_1762 VDD=VDD VSS=VSS
Xcopt_h_inst_4599 dl01d1 $PINS I=A[20] Z=copt_net_1767 VDD=VDD VSS=VSS
Xcopt_h_inst_4608 dl01d1 $PINS I=A[18] Z=copt_net_1776 VDD=VDD VSS=VSS
Xcopt_h_inst_4623 dl01d1 $PINS I=A[9] Z=copt_net_1791 VDD=VDD VSS=VSS
Xcopt_h_inst_4639 dl01d1 $PINS I=A[17] Z=copt_net_1807 VDD=VDD VSS=VSS
Xcopt_h_inst_4641 dl01d1 $PINS I=A[19] Z=copt_net_1809 VDD=VDD VSS=VSS
Xcopt_h_inst_4642 dl01d1 $PINS I=A[16] Z=copt_net_1810 VDD=VDD VSS=VSS
Xcopt_h_inst_4643 dl01d1 $PINS I=A[27] Z=copt_net_1811 VDD=VDD VSS=VSS
Xcopt_h_inst_4646 dl01d1 $PINS I=A[6] Z=copt_net_1814 VDD=VDD VSS=VSS
Xcopt_h_inst_4662 dl01d1 $PINS I=A[26] Z=copt_net_1830 VDD=VDD VSS=VSS
Xcopt_h_inst_4674 dl01d1 $PINS I=A[8] Z=copt_net_1842 VDD=VDD VSS=VSS
Xcopt_h_inst_4677 dl01d1 $PINS I=A[28] Z=copt_net_1845 VDD=VDD VSS=VSS
Xcopt_h_inst_4706 dl01d1 $PINS I=A[29] Z=copt_net_1874 VDD=VDD VSS=VSS
Xcopt_h_inst_4733 dl01d1 $PINS I=A[2] Z=copt_net_1901 VDD=VDD VSS=VSS
Xcopt_h_inst_4744 dl01d1 $PINS I=A[1] Z=copt_net_1912 VDD=VDD VSS=VSS
Xcopt_h_inst_4796 dl01d1 $PINS I=A[11] Z=copt_net_1963 VDD=VDD VSS=VSS
Xcopt_h_inst_4801 dl01d1 $PINS I=A[5] Z=copt_net_1968 VDD=VDD VSS=VSS
Xcopt_h_inst_4813 dl01d1 $PINS I=A[14] Z=copt_net_1980 VDD=VDD VSS=VSS
Xcopt_h_inst_4855 dl01d1 $PINS I=A[10] Z=copt_net_2022 VDD=VDD VSS=VSS
Xcopt_h_inst_4856 dl01d1 $PINS I=A[13] Z=copt_net_2023 VDD=VDD VSS=VSS
Xcopt_h_inst_4866 dl01d1 $PINS I=A[15] Z=copt_net_2033 VDD=VDD VSS=VSS
Xcopt_h_inst_4876 dl01d1 $PINS I=A[4] Z=copt_net_2043 VDD=VDD VSS=VSS
Xcopt_h_inst_4878 dl01d1 $PINS I=A[12] Z=copt_net_2045 VDD=VDD VSS=VSS
.ENDS

.SUBCKT unpu_pe_9 ZCTSNET_11 rst_n array_en weight_load mode_unsigned
+ weight_in[7] weight_in[6] weight_in[5] weight_in[4] weight_in[3] weight_in[2]
+ weight_in[1] weight_in[0] act_in[7] act_in[6] act_in[5] act_in[4] act_in[3]
+ act_in[2] act_in[1] act_in[0] psum_in[31] psum_in[30] psum_in[29] psum_in[28]
+ psum_in[27] psum_in[26] psum_in[25] psum_in[24] psum_in[23] psum_in[22]
+ psum_in[21] psum_in[20] psum_in[19] psum_in[18] psum_in[17] psum_in[16]
+ psum_in[15] psum_in[14] psum_in[13] psum_in[12] psum_in[11] psum_in[10]
+ psum_in[9] psum_in[8] psum_in[7] psum_in[6] psum_in[5] psum_in[4] psum_in[3]
+ psum_in[2] psum_in[1] psum_in[0] act_out[7] act_out[6] act_out[5] act_out[4]
+ act_out[3] act_out[2] act_out[1] act_out[0] psum_out[31] psum_out[30]
+ psum_out[29] psum_out[28] psum_out[27] psum_out[26] psum_out[25] psum_out[24]
+ psum_out[23] psum_out[22] psum_out[21] psum_out[20] psum_out[19] psum_out[18]
+ psum_out[17] psum_out[16] psum_out[15] psum_out[14] psum_out[13] psum_out[12]
+ psum_out[11] psum_out[10] psum_out[9] psum_out[8] psum_out[7] psum_out[6]
+ psum_out[5] psum_out[4] psum_out[3] psum_out[2] psum_out[1] psum_out[0] VDD
+ VSS ZCTSNET_2 HFSNET_3 HFSNET_4 HFSNET_5 HFSNET_6 HFSNET_8 HFSNET_9
XU2 aor22d1 $PINS A1=N_uc_30 A2=HFSNET_3 B1=mode_unsigned B2=N_uc_14
+ Z=product[9] VDD=VDD VSS=VSS
XU3 aor22d1 $PINS A1=N_uc_29 A2=HFSNET_3 B1=N_uc_13 B2=mode_unsigned
+ Z=product[8] VDD=VDD VSS=VSS
XU5 aor22d1 $PINS A1=N_uc_28 A2=HFSNET_4 B1=N_uc_12 B2=HFSNET_5 Z=product[7]
+ VDD=VDD VSS=VSS
XU6 aor22d1 $PINS A1=N_uc_27 A2=HFSNET_4 B1=N_uc_11 B2=HFSNET_5 Z=product[6]
+ VDD=VDD VSS=VSS
XU7 aor22d1 $PINS A1=N_uc_26 A2=HFSNET_4 B1=N_uc_10 B2=HFSNET_5 Z=product[5]
+ VDD=VDD VSS=VSS
XU8 aor22d1 $PINS A1=N_uc_9 A2=HFSNET_5 B1=N_uc_25 B2=HFSNET_4 Z=product[4]
+ VDD=VDD VSS=VSS
XU9 aor22d1 $PINS A1=N_uc_8 A2=HFSNET_5 B1=N_uc_24 B2=HFSNET_4 Z=product[3]
+ VDD=VDD VSS=VSS
XU10 aor22d1 $PINS A1=N_uc_7 A2=HFSNET_5 B1=N_uc_23 B2=HFSNET_4 Z=product[2]
+ VDD=VDD VSS=VSS
XU11 aor22d1 $PINS A1=N_uc_6 A2=HFSNET_5 B1=N_uc_22 B2=HFSNET_4 Z=product[1]
+ VDD=VDD VSS=VSS
XU12 oaim21d1 $PINS B1=N_uc_20 B2=mode_unsigned A=n16 ZN=product[15] VDD=VDD
+ VSS=VSS
XU13 aor22d1 $PINS A1=N_uc_35 A2=HFSNET_3 B1=N_uc_19 B2=mode_unsigned
+ Z=product[14] VDD=VDD VSS=VSS
XU14 aor22d1 $PINS A1=N_uc_34 A2=HFSNET_3 B1=N_uc_18 B2=mode_unsigned
+ Z=product[13] VDD=VDD VSS=VSS
XU15 aor22d1 $PINS A1=N_uc_33 A2=HFSNET_3 B1=N_uc_17 B2=mode_unsigned
+ Z=product[12] VDD=VDD VSS=VSS
XU16 aor22d1 $PINS A1=N_uc_32 A2=HFSNET_3 B1=N_uc_16 B2=mode_unsigned
+ Z=product[11] VDD=VDD VSS=VSS
XU17 aor22d1 $PINS A1=N_uc_31 A2=HFSNET_3 B1=N_uc_15 B2=mode_unsigned
+ Z=product[10] VDD=VDD VSS=VSS
XU18 aor22d1 $PINS A1=N_uc_5 A2=HFSNET_5 B1=N_uc_21 B2=HFSNET_4 Z=product[0]
+ VDD=VDD VSS=VSS
Xadd_42 unpu_pe_9_DW01_add_0_DW01_add_10 $PINS A[31]=psum_in[31]
+ A[30]=psum_in[30] A[29]=psum_in[29] A[28]=psum_in[28] A[27]=psum_in[27]
+ A[26]=psum_in[26] A[25]=psum_in[25] A[24]=psum_in[24] A[23]=psum_in[23]
+ A[22]=psum_in[22] A[21]=psum_in[21] A[20]=psum_in[20] A[19]=psum_in[19]
+ A[18]=psum_in[18] A[17]=psum_in[17] A[16]=psum_in[16] A[15]=psum_in[15]
+ A[14]=psum_in[14] A[13]=psum_in[13] A[12]=psum_in[12] A[11]=psum_in[11]
+ A[10]=psum_in[10] A[9]=psum_in[9] A[8]=psum_in[8] A[7]=psum_in[7]
+ A[6]=psum_in[6] A[5]=psum_in[5] A[4]=psum_in[4] A[3]=psum_in[3] A[2]=psum_in[2]
+ A[1]=psum_in[1] A[0]=psum_in[0] B[31]=n2 B[30]=n2 B[29]=n2 B[28]=n2 B[27]=n2
+ B[26]=n2 B[25]=n2 B[24]=n2 B[23]=n2 B[22]=n2 B[21]=n2 B[20]=n2 B[19]=n2
+ B[18]=n2 B[17]=n2 B[16]=n2 B[15]=product[15] B[14]=product[14]
+ B[13]=product[13] B[12]=product[12] B[11]=product[11] B[10]=product[10]
+ B[9]=product[9] B[8]=product[8] B[7]=product[7] B[6]=product[6] B[5]=product[5]
+ B[4]=product[4] B[3]=product[3] B[2]=product[2] B[1]=product[1] B[0]=product[0]
+ CI=VSS SUM[31]=N_uc_71 SUM[30]=N_uc_70 SUM[29]=N_uc_69 SUM[28]=N_uc_68
+ SUM[27]=N_uc_67 SUM[26]=N_uc_66 SUM[25]=N_uc_65 SUM[24]=N_uc_64 SUM[23]=N_uc_63
+ SUM[22]=N_uc_62 SUM[21]=N_uc_61 SUM[20]=N_uc_60 SUM[19]=N_uc_59 SUM[18]=N_uc_58
+ SUM[17]=N_uc_57 SUM[16]=N_uc_56 SUM[15]=N_uc_55 SUM[14]=N_uc_54 SUM[13]=N_uc_53
+ SUM[12]=N_uc_52 SUM[11]=N_uc_51 SUM[10]=N_uc_50 SUM[9]=N_uc_49 SUM[8]=N_uc_48
+ SUM[7]=N_uc_47 SUM[6]=N_uc_46 SUM[5]=N_uc_45 SUM[4]=N_uc_44 SUM[3]=N_uc_43
+ SUM[2]=N_uc_42 SUM[1]=N_uc_41 SUM[0]=N_uc_40 VDD=VDD VSS=VSS
Xmult_28 unpu_pe_9_DW_mult_uns_0_DW_mult_uns_8 $PINS a[7]=gre_a_INV_1808_3
+ a[6]=weight_reg[6] a[5]=weight_reg[5] a[4]=weight_reg[4] a[3]=weight_reg[3]
+ a[2]=weight_reg[2] a[1]=weight_reg[1] a[0]=gre_a_INV_2231_3 b[7]=act_in[7]
+ b[6]=act_in[6] b[5]=act_in[5] b[4]=act_in[4] b[3]=act_in[3] b[2]=act_in[2]
+ b[1]=act_in[1] b[0]=act_in[0] product[15]=N_uc_20 product[14]=N_uc_19
+ product[13]=N_uc_18 product[12]=N_uc_17 product[11]=N_uc_16 product[10]=N_uc_15
+ product[9]=N_uc_14 product[8]=N_uc_13 product[7]=N_uc_12 product[6]=N_uc_11
+ product[5]=N_uc_10 product[4]=N_uc_9 product[3]=N_uc_8 product[2]=N_uc_7
+ product[1]=N_uc_6 product[0]=N_uc_5 VDD=VDD VSS=VSS
Xmult_30 unpu_pe_9_DW_mult_tc_0_DW_mult_tc_7 $PINS a[7]=weight_reg[7]
+ a[6]=weight_reg[6] a[5]=weight_reg[5] a[4]=weight_reg[4] a[3]=weight_reg[3]
+ a[2]=weight_reg[2] a[1]=weight_reg[1] a[0]=gre_a_INV_2231_3 b[7]=act_in[7]
+ b[6]=act_in[6] b[5]=act_in[5] b[4]=act_in[4] b[3]=act_in[3] b[2]=act_in[2]
+ b[1]=act_in[1] b[0]=act_in[0] product[15]=N_uc_36 product[14]=N_uc_35
+ product[13]=N_uc_34 product[12]=N_uc_33 product[11]=N_uc_32 product[10]=N_uc_31
+ product[9]=N_uc_30 product[8]=N_uc_29 product[7]=N_uc_28 product[6]=N_uc_27
+ product[5]=N_uc_26 product[4]=N_uc_25 product[3]=N_uc_24 product[2]=N_uc_23
+ product[1]=N_uc_22 product[0]=N_uc_21 VDD=VDD VSS=VSS
+ gre_a_INV_1808_2=gre_a_INV_1808_3
Xact_out_reg_3_ decrq1 $PINS D=copt_net_1869 ENN=HFSNET_7 CP=ZCTSNET_2
+ CDN=HFSNET_10 Q=act_out[3] VDD=VDD VSS=VSS
Xact_out_reg_2_ decrq1 $PINS D=copt_net_1085 ENN=HFSNET_7 CP=ZCTSNET_2
+ CDN=HFSNET_10 Q=act_out[2] VDD=VDD VSS=VSS
Xact_out_reg_1_ decrq1 $PINS D=copt_net_1087 ENN=HFSNET_7 CP=ZCTSNET_2
+ CDN=HFSNET_10 Q=act_out[1] VDD=VDD VSS=VSS
Xact_out_reg_7_ decrq1 $PINS D=copt_net_1906 ENN=HFSNET_7 CP=ZCTSNET_2
+ CDN=HFSNET_10 Q=act_out[7] VDD=VDD VSS=VSS
Xact_out_reg_6_ decrq1 $PINS D=copt_net_1863 ENN=HFSNET_7 CP=ZCTSNET_2
+ CDN=HFSNET_10 Q=act_out[6] VDD=VDD VSS=VSS
Xact_out_reg_5_ decrq1 $PINS D=copt_net_1086 ENN=HFSNET_7 CP=ZCTSNET_2
+ CDN=HFSNET_10 Q=act_out[5] VDD=VDD VSS=VSS
Xact_out_reg_4_ decrq1 $PINS D=copt_net_1844 ENN=HFSNET_7 CP=ZCTSNET_2
+ CDN=HFSNET_10 Q=act_out[4] VDD=VDD VSS=VSS
Xact_out_reg_0_ decrq1 $PINS D=copt_net_1173 ENN=HFSNET_7 CP=ZCTSNET_2
+ CDN=HFSNET_10 Q=act_out[0] VDD=VDD VSS=VSS
Xpsum_out_reg_7_ decrq1 $PINS D=N_uc_47 ENN=HFSNET_7 CP=ZCTSNET_2 CDN=HFSNET_8
+ Q=psum_out[7] VDD=VDD VSS=VSS
Xpsum_out_reg_6_ decrq1 $PINS D=N_uc_46 ENN=HFSNET_7 CP=ZCTSNET_2 CDN=HFSNET_10
+ Q=psum_out[6] VDD=VDD VSS=VSS
Xpsum_out_reg_5_ decrq1 $PINS D=N_uc_45 ENN=HFSNET_7 CP=ZCTSNET_2 CDN=HFSNET_10
+ Q=psum_out[5] VDD=VDD VSS=VSS
Xpsum_out_reg_4_ decrq1 $PINS D=N_uc_44 ENN=HFSNET_7 CP=ZCTSNET_2 CDN=HFSNET_8
+ Q=psum_out[4] VDD=VDD VSS=VSS
Xpsum_out_reg_3_ decrq1 $PINS D=N_uc_43 ENN=HFSNET_7 CP=ZCTSNET_2 CDN=HFSNET_10
+ Q=psum_out[3] VDD=VDD VSS=VSS
Xpsum_out_reg_2_ decrq1 $PINS D=N_uc_42 ENN=HFSNET_7 CP=ZCTSNET_2 CDN=HFSNET_10
+ Q=psum_out[2] VDD=VDD VSS=VSS
Xpsum_out_reg_1_ decrq1 $PINS D=N_uc_41 ENN=HFSNET_7 CP=ZCTSNET_2 CDN=HFSNET_8
+ Q=psum_out[1] VDD=VDD VSS=VSS
Xpsum_out_reg_0_ decrq1 $PINS D=N_uc_40 ENN=HFSNET_7 CP=ZCTSNET_2 CDN=HFSNET_8
+ Q=psum_out[0] VDD=VDD VSS=VSS
Xpsum_out_reg_8_ decrq1 $PINS D=N_uc_48 ENN=HFSNET_7 CP=ZCTSNET_2 CDN=HFSNET_10
+ Q=psum_out[8] VDD=VDD VSS=VSS
Xpsum_out_reg_9_ decrq1 $PINS D=N_uc_49 ENN=HFSNET_7 CP=ZCTSNET_2 CDN=HFSNET_8
+ Q=psum_out[9] VDD=VDD VSS=VSS
Xpsum_out_reg_10_ decrq1 $PINS D=N_uc_50 ENN=HFSNET_7 CP=ZCTSNET_2
+ CDN=HFSNET_10 Q=psum_out[10] VDD=VDD VSS=VSS
Xweight_reg_reg_7_ decrq1 $PINS D=weight_in[7] ENN=n15 CP=ZCTSNET_2
+ CDN=HFSNET_8 Q=weight_reg[7] VDD=VDD VSS=VSS
Xweight_reg_reg_6_ decrq1 $PINS D=weight_in[6] ENN=n15 CP=ZCTSNET_2
+ CDN=HFSNET_8 Q=weight_reg[6] VDD=VDD VSS=VSS
Xweight_reg_reg_5_ decrq1 $PINS D=weight_in[5] ENN=n15 CP=ZCTSNET_2
+ CDN=HFSNET_8 Q=weight_reg[5] VDD=VDD VSS=VSS
Xweight_reg_reg_4_ decrq1 $PINS D=weight_in[4] ENN=n15 CP=ZCTSNET_11
+ CDN=HFSNET_8 Q=weight_reg[4] VDD=VDD VSS=VSS
Xweight_reg_reg_3_ decrq1 $PINS D=weight_in[3] ENN=n15 CP=ZCTSNET_2
+ CDN=HFSNET_8 Q=weight_reg[3] VDD=VDD VSS=VSS
Xweight_reg_reg_2_ decrq1 $PINS D=weight_in[2] ENN=n15 CP=ZCTSNET_11
+ CDN=HFSNET_8 Q=weight_reg[2] VDD=VDD VSS=VSS
Xweight_reg_reg_1_ decrq1 $PINS D=weight_in[1] ENN=n15 CP=ZCTSNET_11
+ CDN=HFSNET_8 Q=weight_reg[1] VDD=VDD VSS=VSS
Xweight_reg_reg_0_ decrq1 $PINS D=weight_in[0] ENN=n15 CP=ZCTSNET_2
+ CDN=HFSNET_10 Q=weight_reg[0] VDD=VDD VSS=VSS
Xpsum_out_reg_11_ decrq1 $PINS D=N_uc_51 ENN=HFSNET_7 CP=ZCTSNET_2
+ CDN=HFSNET_10 Q=psum_out[11] VDD=VDD VSS=VSS
Xpsum_out_reg_12_ decrq1 $PINS D=N_uc_52 ENN=HFSNET_7 CP=ZCTSNET_2
+ CDN=HFSNET_10 Q=psum_out[12] VDD=VDD VSS=VSS
Xpsum_out_reg_13_ decrq1 $PINS D=N_uc_53 ENN=HFSNET_7 CP=ZCTSNET_2
+ CDN=HFSNET_10 Q=psum_out[13] VDD=VDD VSS=VSS
Xpsum_out_reg_14_ decrq1 $PINS D=N_uc_54 ENN=HFSNET_7 CP=ZCTSNET_2
+ CDN=HFSNET_10 Q=psum_out[14] VDD=VDD VSS=VSS
Xpsum_out_reg_15_ decrq1 $PINS D=N_uc_55 ENN=HFSNET_7 CP=ZCTSNET_2
+ CDN=HFSNET_10 Q=psum_out[15] VDD=VDD VSS=VSS
Xpsum_out_reg_16_ decrq1 $PINS D=N_uc_56 ENN=HFSNET_7 CP=ZCTSNET_2
+ CDN=HFSNET_10 Q=psum_out[16] VDD=VDD VSS=VSS
Xpsum_out_reg_17_ decrq1 $PINS D=N_uc_57 ENN=HFSNET_7 CP=ZCTSNET_2
+ CDN=HFSNET_10 Q=psum_out[17] VDD=VDD VSS=VSS
Xpsum_out_reg_18_ decrq1 $PINS D=N_uc_58 ENN=HFSNET_7 CP=ZCTSNET_2
+ CDN=HFSNET_10 Q=psum_out[18] VDD=VDD VSS=VSS
Xpsum_out_reg_19_ decrq1 $PINS D=N_uc_59 ENN=HFSNET_7 CP=ZCTSNET_2
+ CDN=HFSNET_10 Q=psum_out[19] VDD=VDD VSS=VSS
Xpsum_out_reg_20_ decrq1 $PINS D=N_uc_60 ENN=HFSNET_7 CP=ZCTSNET_2 CDN=HFSNET_8
+ Q=psum_out[20] VDD=VDD VSS=VSS
Xpsum_out_reg_21_ decrq1 $PINS D=N_uc_61 ENN=HFSNET_7 CP=ZCTSNET_2 CDN=HFSNET_8
+ Q=psum_out[21] VDD=VDD VSS=VSS
Xpsum_out_reg_22_ decrq1 $PINS D=N_uc_62 ENN=HFSNET_7 CP=ZCTSNET_2 CDN=HFSNET_8
+ Q=psum_out[22] VDD=VDD VSS=VSS
Xpsum_out_reg_23_ decrq1 $PINS D=N_uc_63 ENN=HFSNET_7 CP=ZCTSNET_2 CDN=rst_n
+ Q=psum_out[23] VDD=VDD VSS=VSS
Xpsum_out_reg_24_ decrq1 $PINS D=N_uc_64 ENN=HFSNET_7 CP=ZCTSNET_2 CDN=HFSNET_8
+ Q=psum_out[24] VDD=VDD VSS=VSS
Xpsum_out_reg_25_ decrq1 $PINS D=N_uc_65 ENN=HFSNET_7 CP=ZCTSNET_2 CDN=HFSNET_8
+ Q=psum_out[25] VDD=VDD VSS=VSS
Xpsum_out_reg_26_ decrq1 $PINS D=N_uc_66 ENN=HFSNET_7 CP=ZCTSNET_2 CDN=HFSNET_8
+ Q=psum_out[26] VDD=VDD VSS=VSS
Xpsum_out_reg_27_ decrq1 $PINS D=N_uc_67 ENN=HFSNET_7 CP=ZCTSNET_2 CDN=HFSNET_8
+ Q=psum_out[27] VDD=VDD VSS=VSS
Xpsum_out_reg_28_ decrq1 $PINS D=N_uc_68 ENN=HFSNET_7 CP=ZCTSNET_2
+ CDN=HFSNET_10 Q=psum_out[28] VDD=VDD VSS=VSS
Xpsum_out_reg_29_ decrq1 $PINS D=N_uc_69 ENN=HFSNET_7 CP=ZCTSNET_2 CDN=HFSNET_8
+ Q=psum_out[29] VDD=VDD VSS=VSS
Xpsum_out_reg_30_ decrq1 $PINS D=N_uc_70 ENN=HFSNET_7 CP=ZCTSNET_2 CDN=HFSNET_8
+ Q=psum_out[30] VDD=VDD VSS=VSS
Xpsum_out_reg_31_ decrq1 $PINS D=N_uc_71 ENN=HFSNET_7 CP=ZCTSNET_2 CDN=HFSNET_8
+ Q=psum_out[31] VDD=VDD VSS=VSS
XU19 inv0d2 $PINS I=n16 ZN=n2 VDD=VDD VSS=VSS
XHFSBUF_49785_566 buffd1 $PINS I=HFSNET_6 Z=HFSNET_7 VDD=VDD VSS=VSS
XHFSINV_912_678 inv0d2 $PINS I=HFSNET_9 ZN=HFSNET_10 VDD=VDD VSS=VSS
Xcopt_h_inst_3917 dl02d1 $PINS I=act_in[2] Z=copt_net_1085 VDD=VDD VSS=VSS
Xcopt_h_inst_3918 dl02d1 $PINS I=act_in[5] Z=copt_net_1086 VDD=VDD VSS=VSS
Xcopt_h_inst_3919 dl02d1 $PINS I=act_in[1] Z=copt_net_1087 VDD=VDD VSS=VSS
XU25 nd02d1 $PINS A1=weight_load A2=array_en ZN=n15 VDD=VDD VSS=VSS
Xcopt_h_inst_4005 dl02d1 $PINS I=act_in[0] Z=copt_net_1173 VDD=VDD VSS=VSS
Xcopt_h_inst_4676 dl01d1 $PINS I=act_in[4] Z=copt_net_1844 VDD=VDD VSS=VSS
Xcopt_h_inst_4695 dl01d1 $PINS I=act_in[6] Z=copt_net_1863 VDD=VDD VSS=VSS
XU29 nd02d1 $PINS A1=N_uc_36 A2=HFSNET_3 ZN=n16 VDD=VDD VSS=VSS
Xcopt_h_inst_4701 dl01d1 $PINS I=act_in[3] Z=copt_net_1869 VDD=VDD VSS=VSS
Xcopt_h_inst_4738 dl01d1 $PINS I=act_in[7] Z=copt_net_1906 VDD=VDD VSS=VSS
Xgre_a_INV_1808_inst_5806 inv0d1 $PINS I=weight_reg[7] ZN=gre_a_INV_1808_3
+ VDD=VDD VSS=VSS
Xgre_a_INV_2231_inst_5807 inv0d1 $PINS I=weight_reg[0] ZN=gre_a_INV_2231_3
+ VDD=VDD VSS=VSS
.ENDS

.SUBCKT unpu_pe_10_DW_mult_tc_0_DW_mult_tc_8 a[7] a[6] a[5] a[4] a[3] a[2] a[1]
+ a[0] b[7] b[6] b[5] b[4] b[3] b[2] b[1] b[0] product[15] product[14]
+ product[13] product[12] product[11] product[10] product[9] product[8]
+ product[7] product[6] product[5] product[4] product[3] product[2] product[1]
+ product[0] VDD VSS
XU2 ad01d0 $PINS A=n196 B=n61 CI=n2 CO=n1 S=product[14] VDD=VDD VSS=VSS
XU3 ad01d0 $PINS A=n17 B=n16 CI=n3 CO=n2 S=product[13] VDD=VDD VSS=VSS
XU4 ad01d0 $PINS A=n18 B=n19 CI=n4 CO=n3 S=product[12] VDD=VDD VSS=VSS
XU5 ad01d0 $PINS A=n20 B=n23 CI=n5 CO=n4 S=product[11] VDD=VDD VSS=VSS
XU6 ad01d0 $PINS A=n27 B=n24 CI=n6 CO=n5 S=product[10] VDD=VDD VSS=VSS
XU7 ad01d0 $PINS A=n33 B=n28 CI=n7 CO=n6 S=product[9] VDD=VDD VSS=VSS
XU8 ad01d0 $PINS A=n39 B=n34 CI=n8 CO=n7 S=product[8] VDD=VDD VSS=VSS
XU9 ad01d0 $PINS A=n45 B=n40 CI=n9 CO=n8 S=product[7] VDD=VDD VSS=VSS
XU10 ad01d0 $PINS A=n49 B=n46 CI=n10 CO=n9 S=product[6] VDD=VDD VSS=VSS
XU11 ad01d0 $PINS A=n53 B=n50 CI=n11 CO=n10 S=product[5] VDD=VDD VSS=VSS
XU12 ad01d0 $PINS A=n55 B=n54 CI=n12 CO=n11 S=product[4] VDD=VDD VSS=VSS
XU13 ad01d0 $PINS A=n59 B=n56 CI=n13 CO=n12 S=product[3] VDD=VDD VSS=VSS
XU14 ad01d0 $PINS A=n84 B=n91 CI=n14 CO=n13 S=product[2] VDD=VDD VSS=VSS
XctmTdsLR_1_2927 an02d1 $PINS A1=n58 A2=n75 Z=n51 VDD=VDD VSS=VSS
XU17 ad01d0 $PINS A=n195 B=n62 CI=n69 CO=n17 S=n18 VDD=VDD VSS=VSS
XU18 ad01d0 $PINS A=n63 B=n25 CI=n22 CO=n19 S=n20 VDD=VDD VSS=VSS
XU20 ad01d0 $PINS A=n64 B=n26 CI=n29 CO=n23 S=n24 VDD=VDD VSS=VSS
XU21 ad01d0 $PINS A=n194 B=n70 CI=n77 CO=n25 S=n26 VDD=VDD VSS=VSS
XU22 ad01d0 $PINS A=n32 B=n35 CI=n30 CO=n27 S=n28 VDD=VDD VSS=VSS
XU23 ad01d0 $PINS A=n71 B=n65 CI=n37 CO=n29 S=n30 VDD=VDD VSS=VSS
XU25 ad01d0 $PINS A=n38 B=n41 CI=n36 CO=n33 S=n34 VDD=VDD VSS=VSS
XU26 ad01d0 $PINS A=n72 B=n85 CI=n43 CO=n35 S=n36 VDD=VDD VSS=VSS
XU29 ad01d0 $PINS A=n44 B=n47 CI=n42 CO=n39 S=n40 VDD=VDD VSS=VSS
XU30 ad01d0 $PINS A=n86 B=n73 CI=n79 CO=n41 S=n42 VDD=VDD VSS=VSS
XU32 ad01d0 $PINS A=n74 B=n51 CI=n48 CO=n45 S=n46 VDD=VDD VSS=VSS
XU33 ad01d0 $PINS A=n68 B=n87 CI=n80 CO=n47 S=n48 VDD=VDD VSS=VSS
XU34 ad01d0 $PINS A=n88 B=n81 CI=n52 CO=n49 S=n50 VDD=VDD VSS=VSS
XU36 ad01d0 $PINS A=n76 B=n89 CI=n82 CO=n53 S=n54 VDD=VDD VSS=VSS
XU37 ah01d1 $PINS A=n83 B=n90 CO=n55 S=n56 VDD=VDD VSS=VSS
XU145 oai21d1 $PINS B1=n203 B2=n249 A=n222 ZN=n77 VDD=VDD VSS=VSS
XU146 oai21d1 $PINS B1=n201 B2=n250 A=n232 ZN=n69 VDD=VDD VSS=VSS
XU147 oai21d1 $PINS B1=n199 B2=n251 A=n242 ZN=n61 VDD=VDD VSS=VSS
XU148 inv0d0 $PINS I=n16 ZN=n196 VDD=VDD VSS=VSS
XU149 inv0d0 $PINS I=n223 ZN=n201 VDD=VDD VSS=VSS
XU150 inv0d0 $PINS I=n214 ZN=n203 VDD=VDD VSS=VSS
XU151 inv0d0 $PINS I=n233 ZN=n199 VDD=VDD VSS=VSS
XU152 inv0d0 $PINS I=n32 ZN=n194 VDD=VDD VSS=VSS
XU153 inv0d0 $PINS I=n22 ZN=n195 VDD=VDD VSS=VSS
XU154 nd02d1 $PINS A1=n214 A2=n249 ZN=n216 VDD=VDD VSS=VSS
XU155 xr02d1 $PINS A1=a[2] A2=n204 Z=n214 VDD=VDD VSS=VSS
XU156 inv0d1 $PINS I=a[1] ZN=n204 VDD=VDD VSS=VSS
XU157 nd02d1 $PINS A1=n223 A2=n250 ZN=n225 VDD=VDD VSS=VSS
XU158 xr02d1 $PINS A1=a[4] A2=n202 Z=n223 VDD=VDD VSS=VSS
XU159 inv0d1 $PINS I=a[3] ZN=n202 VDD=VDD VSS=VSS
XU160 nd02d1 $PINS A1=a[1] A2=n205 ZN=n206 VDD=VDD VSS=VSS
XU161 inv0d1 $PINS I=a[0] ZN=n205 VDD=VDD VSS=VSS
XU162 inv0d0 $PINS I=b[0] ZN=n197 VDD=VDD VSS=VSS
XU163 xr02d1 $PINS A1=a[6] A2=n200 Z=n233 VDD=VDD VSS=VSS
XU164 inv0d1 $PINS I=a[5] ZN=n200 VDD=VDD VSS=VSS
XU165 nd02d1 $PINS A1=n233 A2=n251 ZN=n235 VDD=VDD VSS=VSS
XU166 inv0d1 $PINS I=a[7] ZN=n198 VDD=VDD VSS=VSS
XU167 inv0d0 $PINS I=n1 ZN=product[15] VDD=VDD VSS=VSS
XU168 nr02d0 $PINS A1=n205 A2=n197 ZN=product[0] VDD=VDD VSS=VSS
XU169 oai22d1 $PINS A1=b[0] A2=n206 B1=n207 B2=n205 ZN=n92 VDD=VDD VSS=VSS
XU170 oai22d1 $PINS A1=n207 A2=n206 B1=n208 B2=n205 ZN=n91 VDD=VDD VSS=VSS
XU171 xr02d1 $PINS A1=b[1] A2=n204 Z=n207 VDD=VDD VSS=VSS
XU172 oai22d1 $PINS A1=n208 A2=n206 B1=n209 B2=n205 ZN=n90 VDD=VDD VSS=VSS
XU173 xr02d1 $PINS A1=b[2] A2=n204 Z=n208 VDD=VDD VSS=VSS
XU174 oai22d1 $PINS A1=n209 A2=n206 B1=n210 B2=n205 ZN=n89 VDD=VDD VSS=VSS
XU175 xr02d1 $PINS A1=b[3] A2=n204 Z=n209 VDD=VDD VSS=VSS
XU176 oai22d1 $PINS A1=n210 A2=n206 B1=n211 B2=n205 ZN=n88 VDD=VDD VSS=VSS
XU177 xr02d1 $PINS A1=b[4] A2=n204 Z=n210 VDD=VDD VSS=VSS
XU178 oai22d1 $PINS A1=n211 A2=n206 B1=n212 B2=n205 ZN=n87 VDD=VDD VSS=VSS
XU179 xr02d1 $PINS A1=b[5] A2=n204 Z=n211 VDD=VDD VSS=VSS
XU180 oai22d1 $PINS A1=n212 A2=n206 B1=n213 B2=n205 ZN=n86 VDD=VDD VSS=VSS
XU181 xr02d1 $PINS A1=b[6] A2=n204 Z=n212 VDD=VDD VSS=VSS
XU182 aor21d1 $PINS B1=n205 B2=n206 A=n213 Z=n85 VDD=VDD VSS=VSS
XU183 xr02d1 $PINS A1=b[7] A2=n204 Z=n213 VDD=VDD VSS=VSS
XU184 nr02d0 $PINS A1=n214 A2=n197 ZN=n84 VDD=VDD VSS=VSS
XU185 oai22d1 $PINS A1=n216 A2=n215 B1=n214 B2=n217 ZN=n83 VDD=VDD VSS=VSS
XctmTdsLR_1_2909 an02d1 $PINS A1=n60 A2=n92 Z=n14 VDD=VDD VSS=VSS
XU187 oai22d1 $PINS A1=n217 A2=n216 B1=n214 B2=n218 ZN=n82 VDD=VDD VSS=VSS
XU188 xr02d1 $PINS A1=b[1] A2=n202 Z=n217 VDD=VDD VSS=VSS
XU189 oai22d1 $PINS A1=n218 A2=n216 B1=n214 B2=n219 ZN=n81 VDD=VDD VSS=VSS
XU190 xr02d1 $PINS A1=b[2] A2=n202 Z=n218 VDD=VDD VSS=VSS
XU191 oai22d1 $PINS A1=n219 A2=n216 B1=n214 B2=n220 ZN=n80 VDD=VDD VSS=VSS
XU192 xr02d1 $PINS A1=b[3] A2=n202 Z=n219 VDD=VDD VSS=VSS
XU193 oai22d1 $PINS A1=n220 A2=n216 B1=n214 B2=n221 ZN=n79 VDD=VDD VSS=VSS
XU194 xr02d1 $PINS A1=b[4] A2=n202 Z=n220 VDD=VDD VSS=VSS
XU195 nr02d0 $PINS A1=n223 A2=n197 ZN=n76 VDD=VDD VSS=VSS
XU196 oai22d1 $PINS A1=n225 A2=n224 B1=n223 B2=n226 ZN=n75 VDD=VDD VSS=VSS
XctmTdsLR_2_2910 aoim21d1 $PINS B1=n92 B2=n60 A=n14 ZN=product[1] VDD=VDD
+ VSS=VSS
XU198 oai22d1 $PINS A1=n226 A2=n225 B1=n223 B2=n227 ZN=n74 VDD=VDD VSS=VSS
XU199 xr02d1 $PINS A1=b[1] A2=n200 Z=n226 VDD=VDD VSS=VSS
XU200 oai22d1 $PINS A1=n227 A2=n225 B1=n223 B2=n228 ZN=n73 VDD=VDD VSS=VSS
XU201 xr02d1 $PINS A1=b[2] A2=n200 Z=n227 VDD=VDD VSS=VSS
XU202 oai22d1 $PINS A1=n228 A2=n225 B1=n223 B2=n229 ZN=n72 VDD=VDD VSS=VSS
XU203 xr02d1 $PINS A1=b[3] A2=n200 Z=n228 VDD=VDD VSS=VSS
XU204 oai22d1 $PINS A1=n229 A2=n225 B1=n223 B2=n230 ZN=n71 VDD=VDD VSS=VSS
XU205 xr02d1 $PINS A1=b[4] A2=n200 Z=n229 VDD=VDD VSS=VSS
XU206 oai22d1 $PINS A1=n230 A2=n225 B1=n223 B2=n231 ZN=n70 VDD=VDD VSS=VSS
XU207 xr02d1 $PINS A1=b[5] A2=n200 Z=n230 VDD=VDD VSS=VSS
XU208 nr02d0 $PINS A1=n233 A2=n197 ZN=n68 VDD=VDD VSS=VSS
XU209 oai22d1 $PINS A1=n235 A2=n234 B1=n233 B2=n236 ZN=n67 VDD=VDD VSS=VSS
XctmTdsLR_2_2928 aoim21d1 $PINS B1=n58 B2=n75 A=n51 ZN=n52 VDD=VDD VSS=VSS
XU211 oai22d1 $PINS A1=n237 A2=n235 B1=n233 B2=n238 ZN=n65 VDD=VDD VSS=VSS
XU212 oai22d1 $PINS A1=n238 A2=n235 B1=n233 B2=n239 ZN=n64 VDD=VDD VSS=VSS
XU213 xr02d1 $PINS A1=b[3] A2=n198 Z=n238 VDD=VDD VSS=VSS
XU214 oai22d1 $PINS A1=n239 A2=n235 B1=n233 B2=n240 ZN=n63 VDD=VDD VSS=VSS
XU215 xr02d1 $PINS A1=b[4] A2=n198 Z=n239 VDD=VDD VSS=VSS
XU216 oai22d1 $PINS A1=n240 A2=n235 B1=n233 B2=n241 ZN=n62 VDD=VDD VSS=VSS
XU217 xr02d1 $PINS A1=b[5] A2=n198 Z=n240 VDD=VDD VSS=VSS
XU218 oai21d1 $PINS B1=n204 B2=b[0] A=n206 ZN=n60 VDD=VDD VSS=VSS
XU219 oai21d1 $PINS B1=n202 B2=n216 A=n243 ZN=n59 VDD=VDD VSS=VSS
XU220 nd03d0 $PINS A1=n203 A2=n197 A3=a[3] ZN=n243 VDD=VDD VSS=VSS
XU221 oai21d1 $PINS B1=n200 B2=n225 A=n244 ZN=n58 VDD=VDD VSS=VSS
XU222 nd03d0 $PINS A1=n201 A2=n197 A3=a[5] ZN=n244 VDD=VDD VSS=VSS
XU223 oai21d1 $PINS B1=n198 B2=n235 A=n245 ZN=n57 VDD=VDD VSS=VSS
XU224 nd03d0 $PINS A1=n199 A2=n197 A3=a[7] ZN=n245 VDD=VDD VSS=VSS
XU225 xn02d1 $PINS A1=n246 A2=n247 ZN=n38 VDD=VDD VSS=VSS
XU226 or02d0 $PINS A1=n247 A2=n246 Z=n37 VDD=VDD VSS=VSS
XU227 oai22d1 $PINS A1=n236 A2=n235 B1=n233 B2=n237 ZN=n246 VDD=VDD VSS=VSS
XU228 xr02d1 $PINS A1=b[2] A2=n198 Z=n237 VDD=VDD VSS=VSS
XU229 xr02d1 $PINS A1=b[1] A2=n198 Z=n236 VDD=VDD VSS=VSS
XU230 oai22d1 $PINS A1=n221 A2=n216 B1=n214 B2=n248 ZN=n247 VDD=VDD VSS=VSS
XU231 xr02d1 $PINS A1=b[5] A2=n202 Z=n221 VDD=VDD VSS=VSS
XU232 aoim22d1 $PINS A1=n203 A2=n222 B1=n248 B2=n216 Z=n32 VDD=VDD VSS=VSS
XU233 xr02d1 $PINS A1=a[3] A2=a[2] Z=n249 VDD=VDD VSS=VSS
XU234 xr02d1 $PINS A1=b[6] A2=n202 Z=n248 VDD=VDD VSS=VSS
XU235 xr02d1 $PINS A1=b[7] A2=a[3] Z=n222 VDD=VDD VSS=VSS
XU236 aoim22d1 $PINS A1=n201 A2=n232 B1=n231 B2=n225 Z=n22 VDD=VDD VSS=VSS
XU237 xr02d1 $PINS A1=a[5] A2=a[4] Z=n250 VDD=VDD VSS=VSS
XU238 xr02d1 $PINS A1=b[6] A2=n200 Z=n231 VDD=VDD VSS=VSS
XU239 xr02d1 $PINS A1=b[7] A2=a[5] Z=n232 VDD=VDD VSS=VSS
XU240 aoim22d1 $PINS A1=n199 A2=n242 B1=n241 B2=n235 Z=n16 VDD=VDD VSS=VSS
XU241 xr02d1 $PINS A1=a[7] A2=a[6] Z=n251 VDD=VDD VSS=VSS
XU242 xr02d1 $PINS A1=b[6] A2=n198 Z=n241 VDD=VDD VSS=VSS
XU243 xr02d1 $PINS A1=b[7] A2=a[7] Z=n242 VDD=VDD VSS=VSS
XctmTdsLR_1_1303 aoim22d1 $PINS A1=n202 A2=b[0] B1=n202 B2=b[0] Z=n215 VDD=VDD
+ VSS=VSS
XctmTdsLR_1_1304 aoim22d1 $PINS A1=n200 A2=b[0] B1=n200 B2=b[0] Z=n224 VDD=VDD
+ VSS=VSS
XctmTdsLR_1_1305 aoim22d1 $PINS A1=n198 A2=b[0] B1=n198 B2=b[0] Z=n234 VDD=VDD
+ VSS=VSS
XctmTdsLR_1_2929 an02d1 $PINS A1=n57 A2=n67 Z=n43 VDD=VDD VSS=VSS
XctmTdsLR_2_2930 aoim21d1 $PINS B1=n57 B2=n67 A=n43 ZN=n44 VDD=VDD VSS=VSS
.ENDS

.SUBCKT unpu_pe_10_DW_mult_uns_0_DW_mult_uns_9 a[7] a[6] a[5] a[4] a[3] a[2]
+ a[1] a[0] b[7] b[6] b[5] b[4] b[3] b[2] b[1] b[0] product[15] product[14]
+ product[13] product[12] product[11] product[10] product[9] product[8]
+ product[7] product[6] product[5] product[4] product[3] product[2] product[1]
+ product[0] VDD VSS
XU2 ad01d0 $PINS A=n99 B=n15 CI=n2 CO=product[15] S=product[14] VDD=VDD VSS=VSS
XU3 ad01d0 $PINS A=n16 B=n17 CI=n3 CO=n2 S=product[13] VDD=VDD VSS=VSS
XU4 ad01d0 $PINS A=n18 B=n21 CI=n4 CO=n3 S=product[12] VDD=VDD VSS=VSS
XU5 ad01d0 $PINS A=n27 B=n22 CI=n5 CO=n4 S=product[11] VDD=VDD VSS=VSS
XU6 ad01d0 $PINS A=n35 B=n28 CI=n6 CO=n5 S=product[10] VDD=VDD VSS=VSS
XU7 ad01d0 $PINS A=n45 B=n36 CI=n7 CO=n6 S=product[9] VDD=VDD VSS=VSS
XU8 ad01d0 $PINS A=n57 B=n46 CI=n8 CO=n7 S=product[8] VDD=VDD VSS=VSS
XU9 ad01d0 $PINS A=n69 B=n58 CI=n9 CO=n8 S=product[7] VDD=VDD VSS=VSS
XU10 ad01d0 $PINS A=n79 B=n70 CI=n10 CO=n9 S=product[6] VDD=VDD VSS=VSS
XU11 ad01d0 $PINS A=n87 B=n80 CI=n11 CO=n10 S=product[5] VDD=VDD VSS=VSS
XU12 ad01d0 $PINS A=n93 B=n88 CI=n12 CO=n11 S=product[4] VDD=VDD VSS=VSS
XU13 ad01d0 $PINS A=n96 B=n13 CI=n94 CO=n12 S=product[3] VDD=VDD VSS=VSS
XU14 ad01d0 $PINS A=n146 B=n14 CI=n98 CO=n13 S=product[2] VDD=VDD VSS=VSS
XU15 ah01d1 $PINS A=n161 B=n154 CO=n14 S=product[1] VDD=VDD VSS=VSS
XU16 ad01d0 $PINS A=n107 B=n100 CI=n19 CO=n15 S=n16 VDD=VDD VSS=VSS
XU17 ad01d0 $PINS A=n25 B=n20 CI=n23 CO=n17 S=n18 VDD=VDD VSS=VSS
XU18 ad01d0 $PINS A=n115 B=n101 CI=n108 CO=n19 S=n20 VDD=VDD VSS=VSS
XU19 ad01d0 $PINS A=n31 B=n24 CI=n29 CO=n21 S=n22 VDD=VDD VSS=VSS
XU20 ad01d0 $PINS A=n116 B=n33 CI=n26 CO=n23 S=n24 VDD=VDD VSS=VSS
XU21 ad01d0 $PINS A=n123 B=n102 CI=n109 CO=n25 S=n26 VDD=VDD VSS=VSS
XU22 ad01d0 $PINS A=n32 B=n37 CI=n30 CO=n27 S=n28 VDD=VDD VSS=VSS
XU23 ad01d0 $PINS A=n41 B=n34 CI=n39 CO=n29 S=n30 VDD=VDD VSS=VSS
XU24 ad01d0 $PINS A=n124 B=n117 CI=n43 CO=n31 S=n32 VDD=VDD VSS=VSS
XU25 ad01d0 $PINS A=n131 B=n103 CI=n110 CO=n33 S=n34 VDD=VDD VSS=VSS
XU26 ad01d0 $PINS A=n40 B=n47 CI=n38 CO=n35 S=n36 VDD=VDD VSS=VSS
XU27 ad01d0 $PINS A=n44 B=n51 CI=n49 CO=n37 S=n38 VDD=VDD VSS=VSS
XU28 ad01d0 $PINS A=n55 B=n53 CI=n42 CO=n39 S=n40 VDD=VDD VSS=VSS
XU29 ad01d0 $PINS A=n118 B=n125 CI=n132 CO=n41 S=n42 VDD=VDD VSS=VSS
XU30 ad01d0 $PINS A=n139 B=n104 CI=n111 CO=n43 S=n44 VDD=VDD VSS=VSS
XU31 ad01d0 $PINS A=n50 B=n59 CI=n48 CO=n45 S=n46 VDD=VDD VSS=VSS
XU32 ad01d0 $PINS A=n54 B=n52 CI=n61 CO=n47 S=n48 VDD=VDD VSS=VSS
XU33 ad01d0 $PINS A=n56 B=n65 CI=n63 CO=n49 S=n50 VDD=VDD VSS=VSS
XU34 ad01d0 $PINS A=n140 B=n133 CI=n67 CO=n51 S=n52 VDD=VDD VSS=VSS
XU35 ad01d0 $PINS A=n126 B=n119 CI=n147 CO=n53 S=n54 VDD=VDD VSS=VSS
XU36 ah01d1 $PINS A=n105 B=n112 CO=n55 S=n56 VDD=VDD VSS=VSS
XU37 ad01d0 $PINS A=n71 B=n62 CI=n60 CO=n57 S=n58 VDD=VDD VSS=VSS
XU38 ad01d0 $PINS A=n64 B=n66 CI=n73 CO=n59 S=n60 VDD=VDD VSS=VSS
XU39 ad01d0 $PINS A=n77 B=n68 CI=n75 CO=n61 S=n62 VDD=VDD VSS=VSS
XU40 ad01d0 $PINS A=n141 B=n127 CI=n134 CO=n63 S=n64 VDD=VDD VSS=VSS
XU41 ad01d0 $PINS A=n155 B=n120 CI=n148 CO=n65 S=n66 VDD=VDD VSS=VSS
XU42 ah01d1 $PINS A=n106 B=n113 CO=n67 S=n68 VDD=VDD VSS=VSS
XU43 ad01d0 $PINS A=n81 B=n74 CI=n72 CO=n69 S=n70 VDD=VDD VSS=VSS
XU44 ad01d0 $PINS A=n78 B=n83 CI=n76 CO=n71 S=n72 VDD=VDD VSS=VSS
XU45 ad01d0 $PINS A=n142 B=n135 CI=n85 CO=n73 S=n74 VDD=VDD VSS=VSS
XU46 ad01d0 $PINS A=n156 B=n128 CI=n149 CO=n75 S=n76 VDD=VDD VSS=VSS
XU47 ah01d1 $PINS A=n114 B=n121 CO=n77 S=n78 VDD=VDD VSS=VSS
XU48 ad01d0 $PINS A=n89 B=n84 CI=n82 CO=n79 S=n80 VDD=VDD VSS=VSS
XU49 ad01d0 $PINS A=n150 B=n91 CI=n86 CO=n81 S=n82 VDD=VDD VSS=VSS
XU50 ad01d0 $PINS A=n157 B=n136 CI=n143 CO=n83 S=n84 VDD=VDD VSS=VSS
XU51 ah01d1 $PINS A=n122 B=n129 CO=n85 S=n86 VDD=VDD VSS=VSS
XU52 ad01d0 $PINS A=n95 B=n92 CI=n90 CO=n87 S=n88 VDD=VDD VSS=VSS
XU53 ad01d0 $PINS A=n158 B=n144 CI=n151 CO=n89 S=n90 VDD=VDD VSS=VSS
XU54 ah01d1 $PINS A=n130 B=n137 CO=n91 S=n92 VDD=VDD VSS=VSS
XU55 ad01d0 $PINS A=n159 B=n152 CI=n97 CO=n93 S=n94 VDD=VDD VSS=VSS
XU56 ah01d1 $PINS A=n138 B=n145 CO=n95 S=n96 VDD=VDD VSS=VSS
XU57 ah01d1 $PINS A=n153 B=n160 CO=n97 S=n98 VDD=VDD VSS=VSS
XU140 inv0d0 $PINS I=b[4] ZN=n217 VDD=VDD VSS=VSS
XU141 inv0d0 $PINS I=a[1] ZN=n228 VDD=VDD VSS=VSS
XU142 inv0d0 $PINS I=b[2] ZN=n219 VDD=VDD VSS=VSS
XU143 inv0d0 $PINS I=a[0] ZN=n229 VDD=VDD VSS=VSS
XU144 inv0d0 $PINS I=a[2] ZN=n227 VDD=VDD VSS=VSS
XU145 inv0d0 $PINS I=b[3] ZN=n218 VDD=VDD VSS=VSS
XU146 inv0d0 $PINS I=a[5] ZN=n224 VDD=VDD VSS=VSS
XU147 inv0d0 $PINS I=b[1] ZN=n220 VDD=VDD VSS=VSS
XU148 inv0d0 $PINS I=b[0] ZN=n221 VDD=VDD VSS=VSS
XU149 inv0d0 $PINS I=a[4] ZN=n225 VDD=VDD VSS=VSS
XU150 inv0d0 $PINS I=b[6] ZN=n215 VDD=VDD VSS=VSS
XU151 inv0d0 $PINS I=a[3] ZN=n226 VDD=VDD VSS=VSS
XU152 inv0d0 $PINS I=b[5] ZN=n216 VDD=VDD VSS=VSS
XU153 inv0d0 $PINS I=b[7] ZN=n214 VDD=VDD VSS=VSS
XU154 inv0d0 $PINS I=a[6] ZN=n223 VDD=VDD VSS=VSS
XU155 inv0d0 $PINS I=a[7] ZN=n222 VDD=VDD VSS=VSS
XU156 nr02d0 $PINS A1=n229 A2=n221 ZN=product[0] VDD=VDD VSS=VSS
XU157 nr02d0 $PINS A1=n222 A2=n214 ZN=n99 VDD=VDD VSS=VSS
XU158 nr02d0 $PINS A1=n229 A2=n220 ZN=n161 VDD=VDD VSS=VSS
XU159 nr02d0 $PINS A1=n229 A2=n219 ZN=n160 VDD=VDD VSS=VSS
XU160 nr02d0 $PINS A1=n229 A2=n218 ZN=n159 VDD=VDD VSS=VSS
XU161 nr02d0 $PINS A1=n229 A2=n217 ZN=n158 VDD=VDD VSS=VSS
XU162 nr02d0 $PINS A1=n229 A2=n216 ZN=n157 VDD=VDD VSS=VSS
XU163 nr02d0 $PINS A1=n229 A2=n215 ZN=n156 VDD=VDD VSS=VSS
XU164 nr02d0 $PINS A1=n229 A2=n214 ZN=n155 VDD=VDD VSS=VSS
XU165 nr02d0 $PINS A1=n221 A2=n228 ZN=n154 VDD=VDD VSS=VSS
XU166 nr02d0 $PINS A1=n220 A2=n228 ZN=n153 VDD=VDD VSS=VSS
XU167 nr02d0 $PINS A1=n219 A2=n228 ZN=n152 VDD=VDD VSS=VSS
XU168 nr02d0 $PINS A1=n218 A2=n228 ZN=n151 VDD=VDD VSS=VSS
XU169 nr02d0 $PINS A1=n217 A2=n228 ZN=n150 VDD=VDD VSS=VSS
XU170 nr02d0 $PINS A1=n216 A2=n228 ZN=n149 VDD=VDD VSS=VSS
XU171 nr02d0 $PINS A1=n215 A2=n228 ZN=n148 VDD=VDD VSS=VSS
XU172 nr02d0 $PINS A1=n214 A2=n228 ZN=n147 VDD=VDD VSS=VSS
XU173 nr02d0 $PINS A1=n221 A2=n227 ZN=n146 VDD=VDD VSS=VSS
XU174 nr02d0 $PINS A1=n220 A2=n227 ZN=n145 VDD=VDD VSS=VSS
XU175 nr02d0 $PINS A1=n219 A2=n227 ZN=n144 VDD=VDD VSS=VSS
XU176 nr02d0 $PINS A1=n218 A2=n227 ZN=n143 VDD=VDD VSS=VSS
XU177 nr02d0 $PINS A1=n217 A2=n227 ZN=n142 VDD=VDD VSS=VSS
XU178 nr02d0 $PINS A1=n216 A2=n227 ZN=n141 VDD=VDD VSS=VSS
XU179 nr02d0 $PINS A1=n215 A2=n227 ZN=n140 VDD=VDD VSS=VSS
XU180 nr02d0 $PINS A1=n214 A2=n227 ZN=n139 VDD=VDD VSS=VSS
XU181 nr02d0 $PINS A1=n221 A2=n226 ZN=n138 VDD=VDD VSS=VSS
XU182 nr02d0 $PINS A1=n220 A2=n226 ZN=n137 VDD=VDD VSS=VSS
XU183 nr02d0 $PINS A1=n219 A2=n226 ZN=n136 VDD=VDD VSS=VSS
XU184 nr02d0 $PINS A1=n218 A2=n226 ZN=n135 VDD=VDD VSS=VSS
XU185 nr02d0 $PINS A1=n217 A2=n226 ZN=n134 VDD=VDD VSS=VSS
XU186 nr02d0 $PINS A1=n216 A2=n226 ZN=n133 VDD=VDD VSS=VSS
XU187 nr02d0 $PINS A1=n215 A2=n226 ZN=n132 VDD=VDD VSS=VSS
XU188 nr02d0 $PINS A1=n214 A2=n226 ZN=n131 VDD=VDD VSS=VSS
XU189 nr02d0 $PINS A1=n221 A2=n225 ZN=n130 VDD=VDD VSS=VSS
XU190 nr02d0 $PINS A1=n220 A2=n225 ZN=n129 VDD=VDD VSS=VSS
XU191 nr02d0 $PINS A1=n219 A2=n225 ZN=n128 VDD=VDD VSS=VSS
XU192 nr02d0 $PINS A1=n218 A2=n225 ZN=n127 VDD=VDD VSS=VSS
XU193 nr02d0 $PINS A1=n217 A2=n225 ZN=n126 VDD=VDD VSS=VSS
XU194 nr02d0 $PINS A1=n216 A2=n225 ZN=n125 VDD=VDD VSS=VSS
XU195 nr02d0 $PINS A1=n215 A2=n225 ZN=n124 VDD=VDD VSS=VSS
XU196 nr02d0 $PINS A1=n214 A2=n225 ZN=n123 VDD=VDD VSS=VSS
XU197 nr02d0 $PINS A1=n221 A2=n224 ZN=n122 VDD=VDD VSS=VSS
XU198 nr02d0 $PINS A1=n220 A2=n224 ZN=n121 VDD=VDD VSS=VSS
XU199 nr02d0 $PINS A1=n219 A2=n224 ZN=n120 VDD=VDD VSS=VSS
XU200 nr02d0 $PINS A1=n218 A2=n224 ZN=n119 VDD=VDD VSS=VSS
XU201 nr02d0 $PINS A1=n217 A2=n224 ZN=n118 VDD=VDD VSS=VSS
XU202 nr02d0 $PINS A1=n216 A2=n224 ZN=n117 VDD=VDD VSS=VSS
XU203 nr02d0 $PINS A1=n215 A2=n224 ZN=n116 VDD=VDD VSS=VSS
XU204 nr02d0 $PINS A1=n214 A2=n224 ZN=n115 VDD=VDD VSS=VSS
XU205 nr02d0 $PINS A1=n221 A2=n223 ZN=n114 VDD=VDD VSS=VSS
XU206 nr02d0 $PINS A1=n220 A2=n223 ZN=n113 VDD=VDD VSS=VSS
XU207 nr02d0 $PINS A1=n219 A2=n223 ZN=n112 VDD=VDD VSS=VSS
XU208 nr02d0 $PINS A1=n218 A2=n223 ZN=n111 VDD=VDD VSS=VSS
XU209 nr02d0 $PINS A1=n217 A2=n223 ZN=n110 VDD=VDD VSS=VSS
XU210 nr02d0 $PINS A1=n216 A2=n223 ZN=n109 VDD=VDD VSS=VSS
XU211 nr02d0 $PINS A1=n215 A2=n223 ZN=n108 VDD=VDD VSS=VSS
XU212 nr02d0 $PINS A1=n214 A2=n223 ZN=n107 VDD=VDD VSS=VSS
XU213 nr02d0 $PINS A1=n221 A2=n222 ZN=n106 VDD=VDD VSS=VSS
XU214 nr02d0 $PINS A1=n222 A2=n220 ZN=n105 VDD=VDD VSS=VSS
XU215 nr02d0 $PINS A1=n222 A2=n219 ZN=n104 VDD=VDD VSS=VSS
XU216 nr02d0 $PINS A1=n222 A2=n218 ZN=n103 VDD=VDD VSS=VSS
XU217 nr02d0 $PINS A1=n222 A2=n217 ZN=n102 VDD=VDD VSS=VSS
XU218 nr02d0 $PINS A1=n222 A2=n216 ZN=n101 VDD=VDD VSS=VSS
XU219 nr02d0 $PINS A1=n222 A2=n215 ZN=n100 VDD=VDD VSS=VSS
.ENDS

.SUBCKT unpu_pe_10_DW01_add_0_DW01_add_11 A[31] A[30] A[29] A[28] A[27] A[26]
+ A[25] A[24] A[23] A[22] A[21] A[20] A[19] A[18] A[17] A[16] A[15] A[14] A[13]
+ A[12] A[11] A[10] A[9] A[8] A[7] A[6] A[5] A[4] A[3] A[2] A[1] A[0] B[31]
+ B[30] B[29] B[28] B[27] B[26] B[25] B[24] B[23] B[22] B[21] B[20] B[19] B[18]
+ B[17] B[16] B[15] B[14] B[13] B[12] B[11] B[10] B[9] B[8] B[7] B[6] B[5] B[4]
+ B[3] B[2] B[1] B[0] CI SUM[31] SUM[30] SUM[29] SUM[28] SUM[27] SUM[26]
+ SUM[25] SUM[24] SUM[23] SUM[22] SUM[21] SUM[20] SUM[19] SUM[18] SUM[17]
+ SUM[16] SUM[15] SUM[14] SUM[13] SUM[12] SUM[11] SUM[10] SUM[9] SUM[8] SUM[7]
+ SUM[6] SUM[5] SUM[4] SUM[3] SUM[2] SUM[1] SUM[0] CO VDD VSS
XU1_31 ad01d0 $PINS A=copt_net_1685 B=B[31] CI=carry[31] S=SUM[31] VDD=VDD
+ VSS=VSS
XU1_30 ad01d0 $PINS A=copt_net_1161 B=B[30] CI=carry[30] CO=carry[31] S=SUM[30]
+ VDD=VDD VSS=VSS
XU1_29 ad01d0 $PINS A=copt_net_1590 B=B[29] CI=carry[29] CO=carry[30] S=SUM[29]
+ VDD=VDD VSS=VSS
XU1_28 ad01d0 $PINS A=copt_net_2044 B=B[28] CI=carry[28] CO=carry[29] S=SUM[28]
+ VDD=VDD VSS=VSS
XU1_27 ad01d0 $PINS A=copt_net_2658 B=B[27] CI=carry[27] CO=carry[28] S=SUM[27]
+ VDD=VDD VSS=VSS
XU1_26 ad01d0 $PINS A=copt_net_1372 B=B[26] CI=carry[26] CO=carry[27] S=SUM[26]
+ VDD=VDD VSS=VSS
XU1_25 ad01d0 $PINS A=copt_net_1464 B=B[25] CI=carry[25] CO=carry[26] S=SUM[25]
+ VDD=VDD VSS=VSS
XU1_24 ad01d0 $PINS A=copt_net_1522 B=B[24] CI=carry[24] CO=carry[25] S=SUM[24]
+ VDD=VDD VSS=VSS
XU1_23 ad01d0 $PINS A=copt_net_1857 B=B[23] CI=carry[23] CO=carry[24] S=SUM[23]
+ VDD=VDD VSS=VSS
XU1_22 ad01d0 $PINS A=copt_net_1669 B=B[22] CI=carry[22] CO=carry[23] S=SUM[22]
+ VDD=VDD VSS=VSS
XU1_21 ad01d0 $PINS A=copt_net_2540 B=B[21] CI=carry[21] CO=carry[22] S=SUM[21]
+ VDD=VDD VSS=VSS
XU1_20 ad01d0 $PINS A=copt_net_2648 B=B[20] CI=carry[20] CO=carry[21] S=SUM[20]
+ VDD=VDD VSS=VSS
XU1_19 ad01d0 $PINS A=copt_net_2559 B=B[19] CI=carry[19] CO=carry[20] S=SUM[19]
+ VDD=VDD VSS=VSS
XU1_18 ad01d0 $PINS A=copt_net_2668 B=B[18] CI=carry[18] CO=carry[19] S=SUM[18]
+ VDD=VDD VSS=VSS
XU1_17 ad01d0 $PINS A=copt_net_2657 B=B[17] CI=carry[17] CO=carry[18] S=SUM[17]
+ VDD=VDD VSS=VSS
XU1_16 ad01d0 $PINS A=copt_net_2659 B=B[16] CI=carry[16] CO=carry[17] S=SUM[16]
+ VDD=VDD VSS=VSS
XU1_15 ad01d0 $PINS A=copt_net_2655 B=B[15] CI=carry[15] CO=carry[16] S=SUM[15]
+ VDD=VDD VSS=VSS
XU1_14 ad01d0 $PINS A=copt_net_2672 B=B[14] CI=carry[14] CO=carry[15] S=SUM[14]
+ VDD=VDD VSS=VSS
XU1_13 ad01d0 $PINS A=copt_net_2680 B=B[13] CI=carry[13] CO=carry[14] S=SUM[13]
+ VDD=VDD VSS=VSS
XU1_12 ad01d0 $PINS A=copt_net_2579 B=B[12] CI=carry[12] CO=carry[13] S=SUM[12]
+ VDD=VDD VSS=VSS
XU1_11 ad01d0 $PINS A=copt_net_2702 B=B[11] CI=carry[11] CO=carry[12] S=SUM[11]
+ VDD=VDD VSS=VSS
XU1_10 ad01d0 $PINS A=copt_net_2597 B=B[10] CI=carry[10] CO=carry[11] S=SUM[10]
+ VDD=VDD VSS=VSS
XU1_9 ad01d0 $PINS A=copt_net_2604 B=B[9] CI=carry[9] CO=carry[10] S=SUM[9]
+ VDD=VDD VSS=VSS
XU1_8 ad01d0 $PINS A=copt_net_2583 B=B[8] CI=carry[8] CO=carry[9] S=SUM[8]
+ VDD=VDD VSS=VSS
XU1_7 ad01d0 $PINS A=copt_net_2577 B=B[7] CI=carry[7] CO=carry[8] S=SUM[7]
+ VDD=VDD VSS=VSS
XU1_6 ad01d0 $PINS A=copt_net_2582 B=B[6] CI=carry[6] CO=carry[7] S=SUM[6]
+ VDD=VDD VSS=VSS
XU1_5 ad01d0 $PINS A=copt_net_2556 B=B[5] CI=carry[5] CO=carry[6] S=SUM[5]
+ VDD=VDD VSS=VSS
XU1_4 ad01d1 $PINS A=copt_net_2600 B=B[4] CI=carry[4] CO=carry[5] S=SUM[4]
+ VDD=VDD VSS=VSS
XU1_3 ad01d4 $PINS A=copt_net_2591 B=B[3] CI=carry[3] CO=carry[4] S=SUM[3]
+ VDD=VDD VSS=VSS
XU1_2 ad01d0 $PINS A=copt_net_2784 B=B[2] CI=carry[2] CO=carry[3] S=SUM[2]
+ VDD=VDD VSS=VSS
XU1_1 ad01d1 $PINS A=A[1] B=B[1] CI=n1 CO=carry[2] S=SUM[1] VDD=VDD VSS=VSS
XU1 an02d0 $PINS A1=B[0] A2=A[0] Z=n1 VDD=VDD VSS=VSS
XU2 xr02d1 $PINS A1=A[0] A2=B[0] Z=SUM[0] VDD=VDD VSS=VSS
Xcopt_h_inst_3993 dl01d1 $PINS I=A[30] Z=copt_net_1161 VDD=VDD VSS=VSS
Xcopt_h_inst_4204 dl01d1 $PINS I=A[26] Z=copt_net_1372 VDD=VDD VSS=VSS
Xcopt_h_inst_4296 dl01d1 $PINS I=A[25] Z=copt_net_1464 VDD=VDD VSS=VSS
Xcopt_h_inst_4354 dl02d1 $PINS I=A[24] Z=copt_net_1522 VDD=VDD VSS=VSS
Xcopt_h_inst_4422 dl01d1 $PINS I=A[29] Z=copt_net_1590 VDD=VDD VSS=VSS
Xcopt_h_inst_4501 dl02d1 $PINS I=A[22] Z=copt_net_1669 VDD=VDD VSS=VSS
Xcopt_h_inst_4517 dl02d1 $PINS I=A[31] Z=copt_net_1685 VDD=VDD VSS=VSS
Xcopt_h_inst_4689 dl01d1 $PINS I=A[23] Z=copt_net_1857 VDD=VDD VSS=VSS
Xcopt_h_inst_4877 dl01d1 $PINS I=A[28] Z=copt_net_2044 VDD=VDD VSS=VSS
Xcopt_h_inst_5373 dl01d1 $PINS I=A[21] Z=copt_net_2540 VDD=VDD VSS=VSS
Xcopt_h_inst_5389 dl01d1 $PINS I=A[5] Z=copt_net_2556 VDD=VDD VSS=VSS
Xcopt_h_inst_5392 dl01d1 $PINS I=A[19] Z=copt_net_2559 VDD=VDD VSS=VSS
Xcopt_h_inst_5410 dl01d1 $PINS I=A[7] Z=copt_net_2577 VDD=VDD VSS=VSS
Xcopt_h_inst_5412 dl01d1 $PINS I=A[12] Z=copt_net_2579 VDD=VDD VSS=VSS
Xcopt_h_inst_5415 dl01d1 $PINS I=A[6] Z=copt_net_2582 VDD=VDD VSS=VSS
Xcopt_h_inst_5416 dl01d1 $PINS I=A[8] Z=copt_net_2583 VDD=VDD VSS=VSS
Xcopt_h_inst_5424 dl01d1 $PINS I=A[3] Z=copt_net_2591 VDD=VDD VSS=VSS
Xcopt_h_inst_5430 dl01d1 $PINS I=A[10] Z=copt_net_2597 VDD=VDD VSS=VSS
Xcopt_h_inst_5433 dl01d1 $PINS I=A[4] Z=copt_net_2600 VDD=VDD VSS=VSS
Xcopt_h_inst_5437 dl01d1 $PINS I=A[9] Z=copt_net_2604 VDD=VDD VSS=VSS
Xcopt_h_inst_5481 dl01d1 $PINS I=A[20] Z=copt_net_2648 VDD=VDD VSS=VSS
Xcopt_h_inst_5488 dl01d1 $PINS I=A[15] Z=copt_net_2655 VDD=VDD VSS=VSS
Xcopt_h_inst_5490 dl01d1 $PINS I=A[17] Z=copt_net_2657 VDD=VDD VSS=VSS
Xcopt_h_inst_5491 dl01d1 $PINS I=A[27] Z=copt_net_2658 VDD=VDD VSS=VSS
Xcopt_h_inst_5492 dl01d1 $PINS I=A[16] Z=copt_net_2659 VDD=VDD VSS=VSS
Xcopt_h_inst_5501 dl01d1 $PINS I=A[18] Z=copt_net_2668 VDD=VDD VSS=VSS
Xcopt_h_inst_5505 dl01d1 $PINS I=A[14] Z=copt_net_2672 VDD=VDD VSS=VSS
Xcopt_h_inst_5513 dl01d1 $PINS I=A[13] Z=copt_net_2680 VDD=VDD VSS=VSS
Xcopt_h_inst_5535 dl01d1 $PINS I=A[11] Z=copt_net_2702 VDD=VDD VSS=VSS
Xcopt_h_inst_5617 dl01d1 $PINS I=A[2] Z=copt_net_2784 VDD=VDD VSS=VSS
.ENDS

.SUBCKT unpu_pe_10 ZCTSNET_10 rst_n array_en weight_load mode_unsigned
+ weight_in[7] weight_in[6] weight_in[5] weight_in[4] weight_in[3] weight_in[2]
+ weight_in[1] weight_in[0] act_in[7] act_in[6] act_in[5] act_in[4] act_in[3]
+ act_in[2] act_in[1] act_in[0] psum_in[31] psum_in[30] psum_in[29] psum_in[28]
+ psum_in[27] psum_in[26] psum_in[25] psum_in[24] psum_in[23] psum_in[22]
+ psum_in[21] psum_in[20] psum_in[19] psum_in[18] psum_in[17] psum_in[16]
+ psum_in[15] psum_in[14] psum_in[13] psum_in[12] psum_in[11] psum_in[10]
+ psum_in[9] psum_in[8] psum_in[7] psum_in[6] psum_in[5] psum_in[4] psum_in[3]
+ psum_in[2] psum_in[1] psum_in[0] act_out[7] act_out[6] act_out[5] act_out[4]
+ act_out[3] act_out[2] act_out[1] act_out[0] psum_out[31] psum_out[30]
+ psum_out[29] psum_out[28] psum_out[27] psum_out[26] psum_out[25] psum_out[24]
+ psum_out[23] psum_out[22] psum_out[21] psum_out[20] psum_out[19] psum_out[18]
+ psum_out[17] psum_out[16] psum_out[15] psum_out[14] psum_out[13] psum_out[12]
+ psum_out[11] psum_out[10] psum_out[9] psum_out[8] psum_out[7] psum_out[6]
+ psum_out[5] psum_out[4] psum_out[3] psum_out[2] psum_out[1] psum_out[0] VDD
+ VSS ZCTSNET_11 HFSNET_2 HFSNET_3 HFSNET_4 HFSNET_5 HFSNET_7 HFSNET_8 HFSNET_9
+ ZCTSNET_0
XU2 aor22d1 $PINS A1=N_uc_30 A2=HFSNET_2 B1=mode_unsigned B2=N_uc_14
+ Z=product[9] VDD=VDD VSS=VSS
XU3 aor22d1 $PINS A1=N_uc_29 A2=HFSNET_2 B1=N_uc_13 B2=mode_unsigned
+ Z=product[8] VDD=VDD VSS=VSS
XU5 aor22d1 $PINS A1=N_uc_28 A2=HFSNET_2 B1=N_uc_12 B2=mode_unsigned
+ Z=product[7] VDD=VDD VSS=VSS
XU6 aor22d1 $PINS A1=N_uc_27 A2=HFSNET_2 B1=N_uc_11 B2=mode_unsigned
+ Z=product[6] VDD=VDD VSS=VSS
XU7 aor22d1 $PINS A1=N_uc_26 A2=HFSNET_2 B1=N_uc_10 B2=mode_unsigned
+ Z=product[5] VDD=VDD VSS=VSS
XU8 aor22d1 $PINS A1=N_uc_9 A2=mode_unsigned B1=N_uc_25 B2=HFSNET_2
+ Z=product[4] VDD=VDD VSS=VSS
XU9 aor22d1 $PINS A1=N_uc_8 A2=mode_unsigned B1=N_uc_24 B2=HFSNET_2
+ Z=product[3] VDD=VDD VSS=VSS
XU10 aor22d1 $PINS A1=N_uc_7 A2=mode_unsigned B1=N_uc_23 B2=HFSNET_2
+ Z=product[2] VDD=VDD VSS=VSS
XU11 aor22d1 $PINS A1=N_uc_6 A2=mode_unsigned B1=N_uc_22 B2=HFSNET_2
+ Z=product[1] VDD=VDD VSS=VSS
XU12 oaim21d1 $PINS B1=N_uc_20 B2=mode_unsigned A=n16 ZN=product[15] VDD=VDD
+ VSS=VSS
XU13 aor22d1 $PINS A1=N_uc_35 A2=HFSNET_2 B1=N_uc_19 B2=mode_unsigned
+ Z=product[14] VDD=VDD VSS=VSS
XU14 aor22d1 $PINS A1=N_uc_34 A2=HFSNET_2 B1=N_uc_18 B2=mode_unsigned
+ Z=product[13] VDD=VDD VSS=VSS
XU15 aor22d1 $PINS A1=N_uc_33 A2=HFSNET_2 B1=N_uc_17 B2=mode_unsigned
+ Z=product[12] VDD=VDD VSS=VSS
XU16 aor22d1 $PINS A1=N_uc_32 A2=HFSNET_2 B1=N_uc_16 B2=mode_unsigned
+ Z=product[11] VDD=VDD VSS=VSS
XU17 aor22d1 $PINS A1=N_uc_31 A2=HFSNET_2 B1=N_uc_15 B2=mode_unsigned
+ Z=product[10] VDD=VDD VSS=VSS
XU18 aor22d1 $PINS A1=N_uc_5 A2=mode_unsigned B1=N_uc_21 B2=HFSNET_2
+ Z=product[0] VDD=VDD VSS=VSS
Xadd_42 unpu_pe_10_DW01_add_0_DW01_add_11 $PINS A[31]=psum_in[31]
+ A[30]=psum_in[30] A[29]=psum_in[29] A[28]=psum_in[28] A[27]=psum_in[27]
+ A[26]=psum_in[26] A[25]=psum_in[25] A[24]=psum_in[24] A[23]=psum_in[23]
+ A[22]=psum_in[22] A[21]=psum_in[21] A[20]=psum_in[20] A[19]=psum_in[19]
+ A[18]=psum_in[18] A[17]=psum_in[17] A[16]=psum_in[16] A[15]=psum_in[15]
+ A[14]=psum_in[14] A[13]=psum_in[13] A[12]=psum_in[12] A[11]=psum_in[11]
+ A[10]=psum_in[10] A[9]=psum_in[9] A[8]=psum_in[8] A[7]=psum_in[7]
+ A[6]=psum_in[6] A[5]=psum_in[5] A[4]=psum_in[4] A[3]=psum_in[3] A[2]=psum_in[2]
+ A[1]=psum_in[1] A[0]=psum_in[0] B[31]=n2 B[30]=n2 B[29]=n2 B[28]=n2 B[27]=n2
+ B[26]=n2 B[25]=n2 B[24]=n2 B[23]=n2 B[22]=n2 B[21]=n2 B[20]=n2 B[19]=n2
+ B[18]=n2 B[17]=n2 B[16]=n2 B[15]=product[15] B[14]=product[14]
+ B[13]=product[13] B[12]=product[12] B[11]=product[11] B[10]=product[10]
+ B[9]=product[9] B[8]=product[8] B[7]=product[7] B[6]=product[6] B[5]=product[5]
+ B[4]=product[4] B[3]=product[3] B[2]=product[2] B[1]=product[1] B[0]=product[0]
+ CI=VSS SUM[31]=N_uc_71 SUM[30]=N_uc_70 SUM[29]=N_uc_69 SUM[28]=N_uc_68
+ SUM[27]=N_uc_67 SUM[26]=N_uc_66 SUM[25]=N_uc_65 SUM[24]=N_uc_64 SUM[23]=N_uc_63
+ SUM[22]=N_uc_62 SUM[21]=N_uc_61 SUM[20]=N_uc_60 SUM[19]=N_uc_59 SUM[18]=N_uc_58
+ SUM[17]=N_uc_57 SUM[16]=N_uc_56 SUM[15]=N_uc_55 SUM[14]=N_uc_54 SUM[13]=N_uc_53
+ SUM[12]=N_uc_52 SUM[11]=N_uc_51 SUM[10]=N_uc_50 SUM[9]=N_uc_49 SUM[8]=N_uc_48
+ SUM[7]=N_uc_47 SUM[6]=N_uc_46 SUM[5]=N_uc_45 SUM[4]=N_uc_44 SUM[3]=N_uc_43
+ SUM[2]=N_uc_42 SUM[1]=N_uc_41 SUM[0]=N_uc_40 VDD=VDD VSS=VSS
Xmult_28 unpu_pe_10_DW_mult_uns_0_DW_mult_uns_9 $PINS a[7]=weight_reg[7]
+ a[6]=weight_reg[6] a[5]=weight_reg[5] a[4]=weight_reg[4] a[3]=weight_reg[3]
+ a[2]=weight_reg[2] a[1]=weight_reg[1] a[0]=weight_reg[0] b[7]=act_in[7]
+ b[6]=act_in[6] b[5]=act_in[5] b[4]=act_in[4] b[3]=act_in[3] b[2]=act_in[2]
+ b[1]=act_in[1] b[0]=act_in[0] product[15]=N_uc_20 product[14]=N_uc_19
+ product[13]=N_uc_18 product[12]=N_uc_17 product[11]=N_uc_16 product[10]=N_uc_15
+ product[9]=N_uc_14 product[8]=N_uc_13 product[7]=N_uc_12 product[6]=N_uc_11
+ product[5]=N_uc_10 product[4]=N_uc_9 product[3]=N_uc_8 product[2]=N_uc_7
+ product[1]=N_uc_6 product[0]=N_uc_5 VDD=VDD VSS=VSS
Xmult_30 unpu_pe_10_DW_mult_tc_0_DW_mult_tc_8 $PINS a[7]=weight_reg[7]
+ a[6]=weight_reg[6] a[5]=weight_reg[5] a[4]=weight_reg[4] a[3]=weight_reg[3]
+ a[2]=weight_reg[2] a[1]=weight_reg[1] a[0]=weight_reg[0] b[7]=act_in[7]
+ b[6]=act_in[6] b[5]=act_in[5] b[4]=act_in[4] b[3]=act_in[3] b[2]=act_in[2]
+ b[1]=act_in[1] b[0]=act_in[0] product[15]=N_uc_36 product[14]=N_uc_35
+ product[13]=N_uc_34 product[12]=N_uc_33 product[11]=N_uc_32 product[10]=N_uc_31
+ product[9]=N_uc_30 product[8]=N_uc_29 product[7]=N_uc_28 product[6]=N_uc_27
+ product[5]=N_uc_26 product[4]=N_uc_25 product[3]=N_uc_24 product[2]=N_uc_23
+ product[1]=N_uc_22 product[0]=N_uc_21 VDD=VDD VSS=VSS
Xact_out_reg_3_ decrq1 $PINS D=copt_net_2393 ENN=HFSNET_6 CP=ZCTSNET_11
+ CDN=rst_n Q=act_out[3] VDD=VDD VSS=VSS
Xact_out_reg_2_ decrq1 $PINS D=copt_net_2777 ENN=HFSNET_6 CP=ZCTSNET_0
+ CDN=HFSNET_8 Q=act_out[2] VDD=VDD VSS=VSS
Xact_out_reg_1_ decrq1 $PINS D=copt_net_2775 ENN=HFSNET_6 CP=ZCTSNET_0
+ CDN=HFSNET_8 Q=act_out[1] VDD=VDD VSS=VSS
Xact_out_reg_7_ decrq1 $PINS D=copt_net_2378 ENN=HFSNET_6 CP=ZCTSNET_11
+ CDN=rst_n Q=act_out[7] VDD=VDD VSS=VSS
Xact_out_reg_6_ decrq1 $PINS D=copt_net_2388 ENN=HFSNET_6 CP=ZCTSNET_11
+ CDN=rst_n Q=act_out[6] VDD=VDD VSS=VSS
Xact_out_reg_5_ decrq1 $PINS D=copt_net_2568 ENN=HFSNET_6 CP=ZCTSNET_0
+ CDN=rst_n Q=act_out[5] VDD=VDD VSS=VSS
Xact_out_reg_4_ decrq1 $PINS D=copt_net_2397 ENN=HFSNET_6 CP=ZCTSNET_11
+ CDN=HFSNET_8 Q=act_out[4] VDD=VDD VSS=VSS
Xact_out_reg_0_ decrq1 $PINS D=copt_net_2781 ENN=HFSNET_6 CP=ZCTSNET_0
+ CDN=HFSNET_8 Q=act_out[0] VDD=VDD VSS=VSS
Xpsum_out_reg_7_ decrq1 $PINS D=N_uc_47 ENN=HFSNET_4 CP=ZCTSNET_10 CDN=rst_n
+ Q=psum_out[7] VDD=VDD VSS=VSS
Xpsum_out_reg_6_ decrq1 $PINS D=N_uc_46 ENN=HFSNET_6 CP=ZCTSNET_11 CDN=rst_n
+ Q=psum_out[6] VDD=VDD VSS=VSS
Xpsum_out_reg_5_ decrq1 $PINS D=N_uc_45 ENN=HFSNET_6 CP=ZCTSNET_11 CDN=rst_n
+ Q=psum_out[5] VDD=VDD VSS=VSS
Xpsum_out_reg_4_ decrq1 $PINS D=N_uc_44 ENN=HFSNET_6 CP=ZCTSNET_11 CDN=rst_n
+ Q=psum_out[4] VDD=VDD VSS=VSS
Xpsum_out_reg_3_ decrq1 $PINS D=N_uc_43 ENN=HFSNET_6 CP=ZCTSNET_11 CDN=rst_n
+ Q=psum_out[3] VDD=VDD VSS=VSS
Xpsum_out_reg_2_ decrq1 $PINS D=copt_net_2468 ENN=HFSNET_6 CP=ZCTSNET_11
+ CDN=rst_n Q=psum_out[2] VDD=VDD VSS=VSS
Xpsum_out_reg_1_ decrq1 $PINS D=copt_net_1056 ENN=HFSNET_6 CP=ZCTSNET_11
+ CDN=HFSNET_8 Q=psum_out[1] VDD=VDD VSS=VSS
Xpsum_out_reg_0_ decrq1 $PINS D=copt_net_1236 ENN=HFSNET_6 CP=ZCTSNET_0
+ CDN=HFSNET_8 Q=psum_out[0] VDD=VDD VSS=VSS
Xpsum_out_reg_8_ decrq1 $PINS D=N_uc_48 ENN=HFSNET_6 CP=ZCTSNET_11 CDN=rst_n
+ Q=psum_out[8] VDD=VDD VSS=VSS
Xpsum_out_reg_9_ decrq1 $PINS D=N_uc_49 ENN=HFSNET_6 CP=ZCTSNET_11 CDN=rst_n
+ Q=psum_out[9] VDD=VDD VSS=VSS
Xpsum_out_reg_10_ decrq1 $PINS D=N_uc_50 ENN=HFSNET_6 CP=ZCTSNET_11 CDN=rst_n
+ Q=psum_out[10] VDD=VDD VSS=VSS
Xweight_reg_reg_7_ decrq1 $PINS D=weight_in[7] ENN=n15 CP=ZCTSNET_11
+ CDN=HFSNET_8 Q=weight_reg[7] VDD=VDD VSS=VSS
Xweight_reg_reg_6_ decrq1 $PINS D=weight_in[6] ENN=n15 CP=ZCTSNET_0
+ CDN=HFSNET_8 Q=weight_reg[6] VDD=VDD VSS=VSS
Xweight_reg_reg_5_ decrq1 $PINS D=weight_in[5] ENN=n15 CP=ZCTSNET_11
+ CDN=HFSNET_8 Q=weight_reg[5] VDD=VDD VSS=VSS
Xweight_reg_reg_4_ decrq1 $PINS D=weight_in[4] ENN=n15 CP=ZCTSNET_0
+ CDN=HFSNET_8 Q=weight_reg[4] VDD=VDD VSS=VSS
Xweight_reg_reg_3_ decrq1 $PINS D=weight_in[3] ENN=n15 CP=ZCTSNET_11
+ CDN=HFSNET_8 Q=weight_reg[3] VDD=VDD VSS=VSS
Xweight_reg_reg_2_ decrq1 $PINS D=weight_in[2] ENN=n15 CP=ZCTSNET_11
+ CDN=HFSNET_8 Q=weight_reg[2] VDD=VDD VSS=VSS
Xweight_reg_reg_1_ decrq1 $PINS D=weight_in[1] ENN=n15 CP=ZCTSNET_11
+ CDN=HFSNET_8 Q=weight_reg[1] VDD=VDD VSS=VSS
Xweight_reg_reg_0_ decrq1 $PINS D=weight_in[0] ENN=n15 CP=ZCTSNET_11
+ CDN=HFSNET_8 Q=weight_reg[0] VDD=VDD VSS=VSS
Xpsum_out_reg_11_ decrq1 $PINS D=N_uc_51 ENN=HFSNET_6 CP=ZCTSNET_0 CDN=HFSNET_8
+ Q=psum_out[11] VDD=VDD VSS=VSS
Xpsum_out_reg_12_ decrq1 $PINS D=N_uc_52 ENN=HFSNET_6 CP=ZCTSNET_11 CDN=rst_n
+ Q=psum_out[12] VDD=VDD VSS=VSS
Xpsum_out_reg_13_ decrq1 $PINS D=N_uc_53 ENN=HFSNET_6 CP=ZCTSNET_0 CDN=HFSNET_8
+ Q=psum_out[13] VDD=VDD VSS=VSS
Xpsum_out_reg_14_ decrq1 $PINS D=N_uc_54 ENN=HFSNET_6 CP=ZCTSNET_0 CDN=HFSNET_8
+ Q=psum_out[14] VDD=VDD VSS=VSS
Xpsum_out_reg_15_ decrq1 $PINS D=N_uc_55 ENN=HFSNET_6 CP=ZCTSNET_0 CDN=HFSNET_8
+ Q=psum_out[15] VDD=VDD VSS=VSS
Xpsum_out_reg_16_ decrq1 $PINS D=N_uc_56 ENN=HFSNET_6 CP=ZCTSNET_0 CDN=rst_n
+ Q=psum_out[16] VDD=VDD VSS=VSS
Xpsum_out_reg_17_ decrq1 $PINS D=N_uc_57 ENN=HFSNET_6 CP=ZCTSNET_0 CDN=HFSNET_9
+ Q=psum_out[17] VDD=VDD VSS=VSS
Xpsum_out_reg_18_ decrq1 $PINS D=N_uc_58 ENN=HFSNET_7 CP=ZCTSNET_0 CDN=HFSNET_9
+ Q=psum_out[18] VDD=VDD VSS=VSS
Xpsum_out_reg_19_ decrq1 $PINS D=N_uc_59 ENN=HFSNET_6 CP=ZCTSNET_11 CDN=rst_n
+ Q=psum_out[19] VDD=VDD VSS=VSS
Xpsum_out_reg_20_ decrq1 $PINS D=N_uc_60 ENN=HFSNET_6 CP=ZCTSNET_0 CDN=HFSNET_8
+ Q=psum_out[20] VDD=VDD VSS=VSS
Xpsum_out_reg_21_ decrq1 $PINS D=copt_net_357 ENN=HFSNET_4 CP=ZCTSNET_11
+ CDN=rst_n Q=psum_out[21] VDD=VDD VSS=VSS
Xpsum_out_reg_22_ decrq1 $PINS D=N_uc_62 ENN=HFSNET_5 CP=ZCTSNET_11
+ CDN=HFSNET_8 Q=psum_out[22] VDD=VDD VSS=VSS
Xpsum_out_reg_23_ decrq1 $PINS D=N_uc_63 ENN=HFSNET_6 CP=ZCTSNET_0 CDN=HFSNET_8
+ Q=psum_out[23] VDD=VDD VSS=VSS
Xpsum_out_reg_24_ decrq1 $PINS D=N_uc_64 ENN=HFSNET_6 CP=ZCTSNET_11 CDN=rst_n
+ Q=psum_out[24] VDD=VDD VSS=VSS
Xpsum_out_reg_25_ decrq1 $PINS D=N_uc_65 ENN=HFSNET_6 CP=ZCTSNET_0 CDN=HFSNET_9
+ Q=psum_out[25] VDD=VDD VSS=VSS
Xpsum_out_reg_26_ decrq1 $PINS D=N_uc_66 ENN=HFSNET_3 CP=ZCTSNET_0 CDN=HFSNET_9
+ Q=psum_out[26] VDD=VDD VSS=VSS
Xpsum_out_reg_27_ decrq1 $PINS D=N_uc_67 ENN=HFSNET_6 CP=ZCTSNET_0 CDN=HFSNET_9
+ Q=psum_out[27] VDD=VDD VSS=VSS
Xpsum_out_reg_28_ decrq1 $PINS D=N_uc_68 ENN=HFSNET_7 CP=ZCTSNET_0 CDN=HFSNET_9
+ Q=psum_out[28] VDD=VDD VSS=VSS
Xpsum_out_reg_29_ decrq1 $PINS D=N_uc_69 ENN=HFSNET_4 CP=ZCTSNET_11 CDN=rst_n
+ Q=psum_out[29] VDD=VDD VSS=VSS
Xpsum_out_reg_30_ decrq1 $PINS D=N_uc_70 ENN=HFSNET_6 CP=ZCTSNET_0 CDN=HFSNET_9
+ Q=psum_out[30] VDD=VDD VSS=VSS
Xpsum_out_reg_31_ decrq1 $PINS D=N_uc_71 ENN=HFSNET_6 CP=ZCTSNET_11 CDN=rst_n
+ Q=psum_out[31] VDD=VDD VSS=VSS
XU19 inv0d2 $PINS I=n16 ZN=n2 VDD=VDD VSS=VSS
XHFSBUF_47204_564 buffd1 $PINS I=HFSNET_7 Z=HFSNET_6 VDD=VDD VSS=VSS
Xcopt_h_inst_3187 dl02d1 $PINS I=N_uc_61 Z=copt_net_357 VDD=VDD VSS=VSS
Xcopt_h_inst_3888 dl02d1 $PINS I=N_uc_41 Z=copt_net_1056 VDD=VDD VSS=VSS
Xcopt_h_inst_4068 dl01d1 $PINS I=N_uc_40 Z=copt_net_1236 VDD=VDD VSS=VSS
Xcopt_h_inst_5211 dl02d1 $PINS I=act_in[7] Z=copt_net_2378 VDD=VDD VSS=VSS
XU25 nd02d1 $PINS A1=weight_load A2=array_en ZN=n15 VDD=VDD VSS=VSS
Xcopt_h_inst_5221 dl02d1 $PINS I=act_in[6] Z=copt_net_2388 VDD=VDD VSS=VSS
Xcopt_h_inst_5226 dl02d1 $PINS I=act_in[3] Z=copt_net_2393 VDD=VDD VSS=VSS
Xcopt_h_inst_5230 dl02d1 $PINS I=act_in[4] Z=copt_net_2397 VDD=VDD VSS=VSS
Xcopt_h_inst_5301 dl01d1 $PINS I=N_uc_42 Z=copt_net_2468 VDD=VDD VSS=VSS
XU30 nd02d1 $PINS A1=N_uc_36 A2=HFSNET_2 ZN=n16 VDD=VDD VSS=VSS
Xcopt_h_inst_5401 dl01d1 $PINS I=act_in[5] Z=copt_net_2568 VDD=VDD VSS=VSS
Xcopt_h_inst_5608 dl01d1 $PINS I=act_in[1] Z=copt_net_2775 VDD=VDD VSS=VSS
Xcopt_h_inst_5610 dl01d1 $PINS I=act_in[2] Z=copt_net_2777 VDD=VDD VSS=VSS
Xcopt_h_inst_5614 dl01d1 $PINS I=act_in[0] Z=copt_net_2781 VDD=VDD VSS=VSS
.ENDS

.SUBCKT unpu_pe_11_DW_mult_tc_0_DW_mult_tc_14 a[7] a[6] a[5] a[4] a[3] a[2]
+ a[1] a[0] b[7] b[6] b[5] b[4] b[3] b[2] b[1] b[0] product[15] product[14]
+ product[13] product[12] product[11] product[10] product[9] product[8]
+ product[7] product[6] product[5] product[4] product[3] product[2] product[1]
+ product[0] VDD VSS gre_a_INV_1877_2 gre_a_INV_1821_2 gre_a_INV_1950_2
XU2 ad01d0 $PINS A=n194 B=n61 CI=n2 CO=n1 S=product[14] VDD=VDD VSS=VSS
XU3 ad01d0 $PINS A=n17 B=n16 CI=n3 CO=n2 S=product[13] VDD=VDD VSS=VSS
XU4 ad01d0 $PINS A=n18 B=n19 CI=n4 CO=n3 S=product[12] VDD=VDD VSS=VSS
XU5 ad01d0 $PINS A=n20 B=n23 CI=n5 CO=n4 S=product[11] VDD=VDD VSS=VSS
XU6 ad01d0 $PINS A=n27 B=n24 CI=n6 CO=n5 S=product[10] VDD=VDD VSS=VSS
XU7 ad01d0 $PINS A=n33 B=n28 CI=n7 CO=n6 S=product[9] VDD=VDD VSS=VSS
XU8 ad01d0 $PINS A=n39 B=n34 CI=n8 CO=n7 S=product[8] VDD=VDD VSS=VSS
XU9 ad01d0 $PINS A=n45 B=n40 CI=n9 CO=n8 S=product[7] VDD=VDD VSS=VSS
XU10 ad01d0 $PINS A=n49 B=n46 CI=n10 CO=n9 S=product[6] VDD=VDD VSS=VSS
XU11 ad01d0 $PINS A=n53 B=n50 CI=n11 CO=n10 S=product[5] VDD=VDD VSS=VSS
XU12 ad01d0 $PINS A=n55 B=n54 CI=n12 CO=n11 S=product[4] VDD=VDD VSS=VSS
XU13 ad01d0 $PINS A=n59 B=n56 CI=n13 CO=n12 S=product[3] VDD=VDD VSS=VSS
XU14 ad01d0 $PINS A=n84 B=n91 CI=n14 CO=n13 S=product[2] VDD=VDD VSS=VSS
XctmTdsLR_1_2917 an02d1 $PINS A1=n57 A2=n67 Z=n43 VDD=VDD VSS=VSS
XU17 ad01d0 $PINS A=n197 B=n62 CI=n69 CO=n17 S=n18 VDD=VDD VSS=VSS
XU18 ad01d0 $PINS A=n63 B=n25 CI=n22 CO=n19 S=n20 VDD=VDD VSS=VSS
XU20 ad01d0 $PINS A=n64 B=n26 CI=n29 CO=n23 S=n24 VDD=VDD VSS=VSS
XU21 ad01d0 $PINS A=n200 B=n70 CI=n77 CO=n25 S=n26 VDD=VDD VSS=VSS
XU22 ad01d0 $PINS A=n32 B=n35 CI=n30 CO=n27 S=n28 VDD=VDD VSS=VSS
XU23 ad01d0 $PINS A=n71 B=n65 CI=n37 CO=n29 S=n30 VDD=VDD VSS=VSS
XU25 ad01d0 $PINS A=n38 B=n41 CI=n36 CO=n33 S=n34 VDD=VDD VSS=VSS
XU26 ad01d0 $PINS A=n72 B=n85 CI=n43 CO=n35 S=n36 VDD=VDD VSS=VSS
XU29 ad01d0 $PINS A=n44 B=n47 CI=n42 CO=n39 S=n40 VDD=VDD VSS=VSS
XU30 ad01d0 $PINS A=n86 B=n73 CI=n79 CO=n41 S=n42 VDD=VDD VSS=VSS
XU32 ad01d0 $PINS A=n74 B=n51 CI=n48 CO=n45 S=n46 VDD=VDD VSS=VSS
XU33 ad01d0 $PINS A=n68 B=n87 CI=n80 CO=n47 S=n48 VDD=VDD VSS=VSS
XU34 ad01d0 $PINS A=n88 B=n81 CI=n52 CO=n49 S=n50 VDD=VDD VSS=VSS
XU35 ah01d1 $PINS A=n58 B=n75 CO=n51 S=n52 VDD=VDD VSS=VSS
XU36 ad01d0 $PINS A=n76 B=n89 CI=n82 CO=n53 S=n54 VDD=VDD VSS=VSS
XU37 ah01d1 $PINS A=n83 B=n90 CO=n55 S=n56 VDD=VDD VSS=VSS
XU145 oai21d1 $PINS B1=n202 B2=n249 A=n222 ZN=n77 VDD=VDD VSS=VSS
XU146 oai21d1 $PINS B1=n199 B2=n250 A=n232 ZN=n69 VDD=VDD VSS=VSS
XU147 oai21d1 $PINS B1=n196 B2=n251 A=n242 ZN=n61 VDD=VDD VSS=VSS
XU148 inv0d0 $PINS I=n16 ZN=n194 VDD=VDD VSS=VSS
XU149 inv0d0 $PINS I=n223 ZN=n199 VDD=VDD VSS=VSS
XU150 inv0d0 $PINS I=n214 ZN=n202 VDD=VDD VSS=VSS
XU151 inv0d0 $PINS I=n233 ZN=n196 VDD=VDD VSS=VSS
XU152 inv0d0 $PINS I=n32 ZN=n200 VDD=VDD VSS=VSS
XU153 inv0d0 $PINS I=n22 ZN=n197 VDD=VDD VSS=VSS
XU154 nd02d1 $PINS A1=n214 A2=n249 ZN=n216 VDD=VDD VSS=VSS
XU155 xr02d1 $PINS A1=a[2] A2=gre_a_INV_1950_2 Z=n214 VDD=VDD VSS=VSS
XU157 nd02d1 $PINS A1=n223 A2=n250 ZN=n225 VDD=VDD VSS=VSS
XU158 xr02d1 $PINS A1=a[4] A2=gre_a_INV_1821_2 Z=n223 VDD=VDD VSS=VSS
XU160 nd02d1 $PINS A1=a[1] A2=a[0] ZN=n206 VDD=VDD VSS=VSS
XU162 inv0d0 $PINS I=b[0] ZN=n205 VDD=VDD VSS=VSS
XU163 xr02d1 $PINS A1=a[6] A2=n198 Z=n233 VDD=VDD VSS=VSS
XU164 inv0d1 $PINS I=a[5] ZN=n198 VDD=VDD VSS=VSS
XU165 nd02d1 $PINS A1=n233 A2=n251 ZN=n235 VDD=VDD VSS=VSS
XU167 inv0d0 $PINS I=n1 ZN=product[15] VDD=VDD VSS=VSS
XU168 nr02d0 $PINS A1=a[0] A2=n205 ZN=product[0] VDD=VDD VSS=VSS
XU169 oai22d1 $PINS A1=b[0] A2=n206 B1=n207 B2=a[0] ZN=n92 VDD=VDD VSS=VSS
XU170 oai22d1 $PINS A1=n207 A2=n206 B1=n208 B2=a[0] ZN=n91 VDD=VDD VSS=VSS
XU171 xr02d1 $PINS A1=b[1] A2=gre_a_INV_1950_2 Z=n207 VDD=VDD VSS=VSS
XU172 oai22d1 $PINS A1=n208 A2=n206 B1=n209 B2=a[0] ZN=n90 VDD=VDD VSS=VSS
XU173 xr02d1 $PINS A1=b[2] A2=gre_a_INV_1950_2 Z=n208 VDD=VDD VSS=VSS
XU174 oai22d1 $PINS A1=n209 A2=n206 B1=n210 B2=a[0] ZN=n89 VDD=VDD VSS=VSS
XU175 xr02d1 $PINS A1=b[3] A2=gre_a_INV_1950_2 Z=n209 VDD=VDD VSS=VSS
XU176 oai22d1 $PINS A1=n210 A2=n206 B1=n211 B2=a[0] ZN=n88 VDD=VDD VSS=VSS
XU177 xr02d1 $PINS A1=b[4] A2=gre_a_INV_1950_2 Z=n210 VDD=VDD VSS=VSS
XU178 oai22d1 $PINS A1=n211 A2=n206 B1=n212 B2=a[0] ZN=n87 VDD=VDD VSS=VSS
XU179 xr02d1 $PINS A1=b[5] A2=gre_a_INV_1950_2 Z=n211 VDD=VDD VSS=VSS
XU180 oai22d1 $PINS A1=n212 A2=n206 B1=n213 B2=a[0] ZN=n86 VDD=VDD VSS=VSS
XU181 xr02d1 $PINS A1=b[6] A2=gre_a_INV_1950_2 Z=n212 VDD=VDD VSS=VSS
XU182 aor21d1 $PINS B1=a[0] B2=n206 A=n213 Z=n85 VDD=VDD VSS=VSS
XU183 xr02d1 $PINS A1=b[7] A2=gre_a_INV_1950_2 Z=n213 VDD=VDD VSS=VSS
XU184 nr02d0 $PINS A1=n214 A2=n205 ZN=n84 VDD=VDD VSS=VSS
XU185 oai22d1 $PINS A1=n216 A2=n215 B1=n214 B2=n217 ZN=n83 VDD=VDD VSS=VSS
XctmTdsLR_1_2905 an02d1 $PINS A1=n60 A2=n92 Z=n14 VDD=VDD VSS=VSS
XU187 oai22d1 $PINS A1=n217 A2=n216 B1=n214 B2=n218 ZN=n82 VDD=VDD VSS=VSS
XU188 xr02d1 $PINS A1=b[1] A2=gre_a_INV_1821_2 Z=n217 VDD=VDD VSS=VSS
XU189 oai22d1 $PINS A1=n218 A2=n216 B1=n214 B2=n219 ZN=n81 VDD=VDD VSS=VSS
XU190 xr02d1 $PINS A1=b[2] A2=gre_a_INV_1821_2 Z=n218 VDD=VDD VSS=VSS
XU191 oai22d1 $PINS A1=n219 A2=n216 B1=n214 B2=n220 ZN=n80 VDD=VDD VSS=VSS
XU192 xr02d1 $PINS A1=b[3] A2=gre_a_INV_1821_2 Z=n219 VDD=VDD VSS=VSS
XU193 oai22d1 $PINS A1=n220 A2=n216 B1=n214 B2=n221 ZN=n79 VDD=VDD VSS=VSS
XU194 xr02d1 $PINS A1=b[4] A2=gre_a_INV_1821_2 Z=n220 VDD=VDD VSS=VSS
XU195 nr02d0 $PINS A1=n223 A2=n205 ZN=n76 VDD=VDD VSS=VSS
XU196 oai22d1 $PINS A1=n225 A2=n224 B1=n223 B2=n226 ZN=n75 VDD=VDD VSS=VSS
XctmTdsLR_2_2906 aoim21d1 $PINS B1=n92 B2=n60 A=n14 ZN=product[1] VDD=VDD
+ VSS=VSS
XU198 oai22d1 $PINS A1=n226 A2=n225 B1=n223 B2=n227 ZN=n74 VDD=VDD VSS=VSS
XU199 xr02d1 $PINS A1=b[1] A2=n198 Z=n226 VDD=VDD VSS=VSS
XU200 oai22d1 $PINS A1=n227 A2=n225 B1=n223 B2=n228 ZN=n73 VDD=VDD VSS=VSS
XU201 xr02d1 $PINS A1=b[2] A2=n198 Z=n227 VDD=VDD VSS=VSS
XU202 oai22d1 $PINS A1=n228 A2=n225 B1=n223 B2=n229 ZN=n72 VDD=VDD VSS=VSS
XU203 xr02d1 $PINS A1=b[3] A2=n198 Z=n228 VDD=VDD VSS=VSS
XU204 oai22d1 $PINS A1=n229 A2=n225 B1=n223 B2=n230 ZN=n71 VDD=VDD VSS=VSS
XU205 xr02d1 $PINS A1=b[4] A2=n198 Z=n229 VDD=VDD VSS=VSS
XU206 oai22d1 $PINS A1=n230 A2=n225 B1=n223 B2=n231 ZN=n70 VDD=VDD VSS=VSS
XU207 xr02d1 $PINS A1=b[5] A2=n198 Z=n230 VDD=VDD VSS=VSS
XU208 nr02d0 $PINS A1=n233 A2=n205 ZN=n68 VDD=VDD VSS=VSS
XU209 oai22d1 $PINS A1=n235 A2=n234 B1=n233 B2=n236 ZN=n67 VDD=VDD VSS=VSS
XctmTdsLR_2_2918 aoim21d1 $PINS B1=n57 B2=n67 A=n43 ZN=n44 VDD=VDD VSS=VSS
XU211 oai22d1 $PINS A1=n237 A2=n235 B1=n233 B2=n238 ZN=n65 VDD=VDD VSS=VSS
XU212 oai22d1 $PINS A1=n238 A2=n235 B1=n233 B2=n239 ZN=n64 VDD=VDD VSS=VSS
XU213 xr02d1 $PINS A1=b[3] A2=gre_a_INV_1877_2 Z=n238 VDD=VDD VSS=VSS
XU214 oai22d1 $PINS A1=n239 A2=n235 B1=n233 B2=n240 ZN=n63 VDD=VDD VSS=VSS
XU215 xr02d1 $PINS A1=b[4] A2=gre_a_INV_1877_2 Z=n239 VDD=VDD VSS=VSS
XU216 oai22d1 $PINS A1=n240 A2=n235 B1=n233 B2=n241 ZN=n62 VDD=VDD VSS=VSS
XU217 xr02d1 $PINS A1=b[5] A2=gre_a_INV_1877_2 Z=n240 VDD=VDD VSS=VSS
XU218 oai21d1 $PINS B1=gre_a_INV_1950_2 B2=b[0] A=n206 ZN=n60 VDD=VDD VSS=VSS
XU219 oai21d1 $PINS B1=gre_a_INV_1821_2 B2=n216 A=n243 ZN=n59 VDD=VDD VSS=VSS
XU220 nd03d0 $PINS A1=n202 A2=n205 A3=a[3] ZN=n243 VDD=VDD VSS=VSS
XU221 oai21d1 $PINS B1=n198 B2=n225 A=n244 ZN=n58 VDD=VDD VSS=VSS
XU222 nd03d0 $PINS A1=n199 A2=n205 A3=a[5] ZN=n244 VDD=VDD VSS=VSS
XU223 oai21d1 $PINS B1=gre_a_INV_1877_2 B2=n235 A=n245 ZN=n57 VDD=VDD VSS=VSS
XU224 nd03d0 $PINS A1=n196 A2=n205 A3=a[7] ZN=n245 VDD=VDD VSS=VSS
XU225 xn02d1 $PINS A1=n246 A2=n247 ZN=n38 VDD=VDD VSS=VSS
XU226 or02d0 $PINS A1=n247 A2=n246 Z=n37 VDD=VDD VSS=VSS
XU227 oai22d1 $PINS A1=n236 A2=n235 B1=n233 B2=n237 ZN=n246 VDD=VDD VSS=VSS
XU228 xr02d1 $PINS A1=b[2] A2=gre_a_INV_1877_2 Z=n237 VDD=VDD VSS=VSS
XU229 xr02d1 $PINS A1=b[1] A2=gre_a_INV_1877_2 Z=n236 VDD=VDD VSS=VSS
XU230 oai22d1 $PINS A1=n221 A2=n216 B1=n214 B2=n248 ZN=n247 VDD=VDD VSS=VSS
XU231 xr02d1 $PINS A1=b[5] A2=gre_a_INV_1821_2 Z=n221 VDD=VDD VSS=VSS
XU232 aoim22d1 $PINS A1=n202 A2=n222 B1=n248 B2=n216 Z=n32 VDD=VDD VSS=VSS
XU233 xr02d1 $PINS A1=a[3] A2=a[2] Z=n249 VDD=VDD VSS=VSS
XU234 xr02d1 $PINS A1=b[6] A2=gre_a_INV_1821_2 Z=n248 VDD=VDD VSS=VSS
XU235 xr02d1 $PINS A1=b[7] A2=a[3] Z=n222 VDD=VDD VSS=VSS
XU236 aoim22d1 $PINS A1=n199 A2=n232 B1=n231 B2=n225 Z=n22 VDD=VDD VSS=VSS
XU237 xr02d1 $PINS A1=a[5] A2=a[4] Z=n250 VDD=VDD VSS=VSS
XU238 xr02d1 $PINS A1=b[6] A2=n198 Z=n231 VDD=VDD VSS=VSS
XU239 xr02d1 $PINS A1=b[7] A2=a[5] Z=n232 VDD=VDD VSS=VSS
XU240 aoim22d1 $PINS A1=n196 A2=n242 B1=n241 B2=n235 Z=n16 VDD=VDD VSS=VSS
XU241 xr02d1 $PINS A1=a[7] A2=a[6] Z=n251 VDD=VDD VSS=VSS
XU242 xr02d1 $PINS A1=b[6] A2=gre_a_INV_1877_2 Z=n241 VDD=VDD VSS=VSS
XU243 xr02d1 $PINS A1=b[7] A2=a[7] Z=n242 VDD=VDD VSS=VSS
XctmTdsLR_1_1280 aoim22d1 $PINS A1=gre_a_INV_1821_2 A2=b[0] B1=gre_a_INV_1821_2
+ B2=b[0] Z=n215 VDD=VDD VSS=VSS
XctmTdsLR_1_1281 aoim22d1 $PINS A1=n198 A2=b[0] B1=n198 B2=b[0] Z=n224 VDD=VDD
+ VSS=VSS
XctmTdsLR_1_1282 aoim22d1 $PINS A1=gre_a_INV_1877_2 A2=b[0] B1=gre_a_INV_1877_2
+ B2=b[0] Z=n234 VDD=VDD VSS=VSS
.ENDS

.SUBCKT unpu_pe_11_DW_mult_uns_0_DW_mult_uns_15 a[7] a[6] a[5] a[4] a[3] a[2]
+ a[1] a[0] b[7] b[6] b[5] b[4] b[3] b[2] b[1] b[0] product[15] product[14]
+ product[13] product[12] product[11] product[10] product[9] product[8]
+ product[7] product[6] product[5] product[4] product[3] product[2] product[1]
+ product[0] VDD VSS
XU2 ad01d0 $PINS A=n99 B=n15 CI=n2 CO=product[15] S=product[14] VDD=VDD VSS=VSS
XU3 ad01d0 $PINS A=n16 B=n17 CI=n3 CO=n2 S=product[13] VDD=VDD VSS=VSS
XU4 ad01d1 $PINS A=n18 B=n21 CI=n4 CO=n3 S=product[12] VDD=VDD VSS=VSS
XU5 ad01d0 $PINS A=n27 B=n22 CI=n5 CO=n4 S=product[11] VDD=VDD VSS=VSS
XU6 ad01d0 $PINS A=n35 B=n28 CI=n6 CO=n5 S=product[10] VDD=VDD VSS=VSS
XU7 ad01d0 $PINS A=n45 B=n36 CI=n7 CO=n6 S=product[9] VDD=VDD VSS=VSS
XU8 ad01d0 $PINS A=n57 B=n46 CI=n8 CO=n7 S=product[8] VDD=VDD VSS=VSS
XU9 ad01d0 $PINS A=n69 B=n58 CI=n9 CO=n8 S=product[7] VDD=VDD VSS=VSS
XU10 ad01d1 $PINS A=n79 B=n70 CI=n10 CO=n9 S=product[6] VDD=VDD VSS=VSS
XU11 ad01d0 $PINS A=n87 B=n80 CI=n11 CO=n10 S=product[5] VDD=VDD VSS=VSS
XU12 ad01d0 $PINS A=n93 B=n88 CI=n12 CO=n11 S=product[4] VDD=VDD VSS=VSS
XU13 ad01d0 $PINS A=n96 B=n13 CI=n94 CO=n12 S=product[3] VDD=VDD VSS=VSS
XU14 ad01d0 $PINS A=n146 B=n14 CI=n98 CO=n13 S=product[2] VDD=VDD VSS=VSS
XU15 ah01d1 $PINS A=n161 B=n154 CO=n14 S=product[1] VDD=VDD VSS=VSS
XU16 ad01d0 $PINS A=n107 B=n100 CI=n19 CO=n15 S=n16 VDD=VDD VSS=VSS
XU17 ad01d0 $PINS A=n25 B=n20 CI=n23 CO=n17 S=n18 VDD=VDD VSS=VSS
XU18 ad01d0 $PINS A=n115 B=n101 CI=n108 CO=n19 S=n20 VDD=VDD VSS=VSS
XU19 ad01d0 $PINS A=n31 B=n24 CI=n29 CO=n21 S=n22 VDD=VDD VSS=VSS
XU20 ad01d0 $PINS A=n116 B=n33 CI=n26 CO=n23 S=n24 VDD=VDD VSS=VSS
XU21 ad01d0 $PINS A=n123 B=n102 CI=n109 CO=n25 S=n26 VDD=VDD VSS=VSS
XU22 ad01d0 $PINS A=n32 B=n37 CI=n30 CO=n27 S=n28 VDD=VDD VSS=VSS
XU23 ad01d0 $PINS A=n41 B=n34 CI=n39 CO=n29 S=n30 VDD=VDD VSS=VSS
XU24 ad01d0 $PINS A=n124 B=n117 CI=n43 CO=n31 S=n32 VDD=VDD VSS=VSS
XU25 ad01d0 $PINS A=n131 B=n103 CI=n110 CO=n33 S=n34 VDD=VDD VSS=VSS
XU26 ad01d0 $PINS A=n40 B=n47 CI=n38 CO=n35 S=n36 VDD=VDD VSS=VSS
XU27 ad01d0 $PINS A=n44 B=n51 CI=n49 CO=n37 S=n38 VDD=VDD VSS=VSS
XU28 ad01d0 $PINS A=n55 B=n53 CI=n42 CO=n39 S=n40 VDD=VDD VSS=VSS
XU29 ad01d0 $PINS A=n118 B=n125 CI=n132 CO=n41 S=n42 VDD=VDD VSS=VSS
XU30 ad01d0 $PINS A=n139 B=n104 CI=n111 CO=n43 S=n44 VDD=VDD VSS=VSS
XU31 ad01d0 $PINS A=n50 B=n59 CI=n48 CO=n45 S=n46 VDD=VDD VSS=VSS
XU32 ad01d0 $PINS A=n54 B=n52 CI=n61 CO=n47 S=n48 VDD=VDD VSS=VSS
XU33 ad01d0 $PINS A=n56 B=n65 CI=n63 CO=n49 S=n50 VDD=VDD VSS=VSS
XU34 ad01d0 $PINS A=n140 B=n133 CI=n67 CO=n51 S=n52 VDD=VDD VSS=VSS
XU35 ad01d0 $PINS A=n126 B=n119 CI=n147 CO=n53 S=n54 VDD=VDD VSS=VSS
XU36 ah01d1 $PINS A=n105 B=n112 CO=n55 S=n56 VDD=VDD VSS=VSS
XU37 ad01d0 $PINS A=n71 B=n62 CI=n60 CO=n57 S=n58 VDD=VDD VSS=VSS
XU38 ad01d0 $PINS A=n64 B=n66 CI=n73 CO=n59 S=n60 VDD=VDD VSS=VSS
XU39 ad01d0 $PINS A=n77 B=n68 CI=n75 CO=n61 S=n62 VDD=VDD VSS=VSS
XU40 ad01d0 $PINS A=n141 B=n127 CI=n134 CO=n63 S=n64 VDD=VDD VSS=VSS
XU41 ad01d0 $PINS A=n155 B=n120 CI=n148 CO=n65 S=n66 VDD=VDD VSS=VSS
XU42 ah01d1 $PINS A=n106 B=n113 CO=n67 S=n68 VDD=VDD VSS=VSS
XU43 ad01d0 $PINS A=n81 B=n74 CI=n72 CO=n69 S=n70 VDD=VDD VSS=VSS
XU44 ad01d0 $PINS A=n78 B=n83 CI=n76 CO=n71 S=n72 VDD=VDD VSS=VSS
XU45 ad01d0 $PINS A=n142 B=n135 CI=n85 CO=n73 S=n74 VDD=VDD VSS=VSS
XU46 ad01d0 $PINS A=n156 B=n128 CI=n149 CO=n75 S=n76 VDD=VDD VSS=VSS
XU47 ah01d1 $PINS A=n114 B=n121 CO=n77 S=n78 VDD=VDD VSS=VSS
XU48 ad01d0 $PINS A=n89 B=n84 CI=n82 CO=n79 S=n80 VDD=VDD VSS=VSS
XU49 ad01d0 $PINS A=n150 B=n91 CI=n86 CO=n81 S=n82 VDD=VDD VSS=VSS
XU50 ad01d0 $PINS A=n157 B=n136 CI=n143 CO=n83 S=n84 VDD=VDD VSS=VSS
XU51 ah01d1 $PINS A=n122 B=n129 CO=n85 S=n86 VDD=VDD VSS=VSS
XU52 ad01d0 $PINS A=n95 B=n92 CI=n90 CO=n87 S=n88 VDD=VDD VSS=VSS
XU53 ad01d0 $PINS A=n158 B=n144 CI=n151 CO=n89 S=n90 VDD=VDD VSS=VSS
XU54 ah01d1 $PINS A=n130 B=n137 CO=n91 S=n92 VDD=VDD VSS=VSS
XU55 ad01d0 $PINS A=n159 B=n152 CI=n97 CO=n93 S=n94 VDD=VDD VSS=VSS
XU56 ah01d1 $PINS A=n138 B=n145 CO=n95 S=n96 VDD=VDD VSS=VSS
XU57 ah01d1 $PINS A=n153 B=n160 CO=n97 S=n98 VDD=VDD VSS=VSS
XU140 inv0d0 $PINS I=b[4] ZN=n225 VDD=VDD VSS=VSS
XU142 inv0d0 $PINS I=b[2] ZN=n227 VDD=VDD VSS=VSS
XU144 inv0d0 $PINS I=a[2] ZN=n219 VDD=VDD VSS=VSS
XU145 inv0d0 $PINS I=b[3] ZN=n226 VDD=VDD VSS=VSS
XU146 inv0d0 $PINS I=a[5] ZN=n216 VDD=VDD VSS=VSS
XU147 inv0d0 $PINS I=b[1] ZN=n228 VDD=VDD VSS=VSS
XU148 inv0d0 $PINS I=b[0] ZN=n229 VDD=VDD VSS=VSS
XU149 inv0d0 $PINS I=a[4] ZN=n217 VDD=VDD VSS=VSS
XU150 inv0d0 $PINS I=b[6] ZN=n223 VDD=VDD VSS=VSS
XU152 inv0d0 $PINS I=b[5] ZN=n224 VDD=VDD VSS=VSS
XU153 inv0d0 $PINS I=b[7] ZN=n222 VDD=VDD VSS=VSS
XU154 inv0d0 $PINS I=a[6] ZN=n215 VDD=VDD VSS=VSS
XU156 nr02d0 $PINS A1=a[0] A2=n229 ZN=product[0] VDD=VDD VSS=VSS
XU157 nr02d0 $PINS A1=a[7] A2=n222 ZN=n99 VDD=VDD VSS=VSS
XU158 nr02d0 $PINS A1=a[0] A2=n228 ZN=n161 VDD=VDD VSS=VSS
XU159 nr02d0 $PINS A1=a[0] A2=n227 ZN=n160 VDD=VDD VSS=VSS
XU160 nr02d0 $PINS A1=a[0] A2=n226 ZN=n159 VDD=VDD VSS=VSS
XU161 nr02d0 $PINS A1=a[0] A2=n225 ZN=n158 VDD=VDD VSS=VSS
XU162 nr02d0 $PINS A1=a[0] A2=n224 ZN=n157 VDD=VDD VSS=VSS
XU163 nr02d0 $PINS A1=a[0] A2=n223 ZN=n156 VDD=VDD VSS=VSS
XU164 nr02d0 $PINS A1=a[0] A2=n222 ZN=n155 VDD=VDD VSS=VSS
XU165 nr02d0 $PINS A1=n229 A2=a[1] ZN=n154 VDD=VDD VSS=VSS
XU166 nr02d0 $PINS A1=n228 A2=a[1] ZN=n153 VDD=VDD VSS=VSS
XU167 nr02d0 $PINS A1=n227 A2=a[1] ZN=n152 VDD=VDD VSS=VSS
XU168 nr02d0 $PINS A1=n226 A2=a[1] ZN=n151 VDD=VDD VSS=VSS
XU169 nr02d0 $PINS A1=n225 A2=a[1] ZN=n150 VDD=VDD VSS=VSS
XU170 nr02d0 $PINS A1=n224 A2=a[1] ZN=n149 VDD=VDD VSS=VSS
XU171 nr02d0 $PINS A1=n223 A2=a[1] ZN=n148 VDD=VDD VSS=VSS
XU172 nr02d0 $PINS A1=n222 A2=a[1] ZN=n147 VDD=VDD VSS=VSS
XU173 nr02d0 $PINS A1=n229 A2=n219 ZN=n146 VDD=VDD VSS=VSS
XU174 nr02d0 $PINS A1=n228 A2=n219 ZN=n145 VDD=VDD VSS=VSS
XU175 nr02d0 $PINS A1=n227 A2=n219 ZN=n144 VDD=VDD VSS=VSS
XU176 nr02d0 $PINS A1=n226 A2=n219 ZN=n143 VDD=VDD VSS=VSS
XU177 nr02d0 $PINS A1=n225 A2=n219 ZN=n142 VDD=VDD VSS=VSS
XU178 nr02d0 $PINS A1=n224 A2=n219 ZN=n141 VDD=VDD VSS=VSS
XU179 nr02d0 $PINS A1=n223 A2=n219 ZN=n140 VDD=VDD VSS=VSS
XU180 nr02d0 $PINS A1=n222 A2=n219 ZN=n139 VDD=VDD VSS=VSS
XU181 nr02d0 $PINS A1=n229 A2=a[3] ZN=n138 VDD=VDD VSS=VSS
XU182 nr02d0 $PINS A1=n228 A2=a[3] ZN=n137 VDD=VDD VSS=VSS
XU183 nr02d0 $PINS A1=n227 A2=a[3] ZN=n136 VDD=VDD VSS=VSS
XU184 nr02d0 $PINS A1=n226 A2=a[3] ZN=n135 VDD=VDD VSS=VSS
XU185 nr02d0 $PINS A1=n225 A2=a[3] ZN=n134 VDD=VDD VSS=VSS
XU186 nr02d0 $PINS A1=n224 A2=a[3] ZN=n133 VDD=VDD VSS=VSS
XU187 nr02d0 $PINS A1=n223 A2=a[3] ZN=n132 VDD=VDD VSS=VSS
XU188 nr02d0 $PINS A1=n222 A2=a[3] ZN=n131 VDD=VDD VSS=VSS
XU189 nr02d0 $PINS A1=n229 A2=n217 ZN=n130 VDD=VDD VSS=VSS
XU190 nr02d0 $PINS A1=n228 A2=n217 ZN=n129 VDD=VDD VSS=VSS
XU191 nr02d0 $PINS A1=n227 A2=n217 ZN=n128 VDD=VDD VSS=VSS
XU192 nr02d0 $PINS A1=n226 A2=n217 ZN=n127 VDD=VDD VSS=VSS
XU193 nr02d0 $PINS A1=n225 A2=n217 ZN=n126 VDD=VDD VSS=VSS
XU194 nr02d0 $PINS A1=n224 A2=n217 ZN=n125 VDD=VDD VSS=VSS
XU195 nr02d0 $PINS A1=n223 A2=n217 ZN=n124 VDD=VDD VSS=VSS
XU196 nr02d0 $PINS A1=n222 A2=n217 ZN=n123 VDD=VDD VSS=VSS
XU197 nr02d0 $PINS A1=n229 A2=n216 ZN=n122 VDD=VDD VSS=VSS
XU198 nr02d0 $PINS A1=n228 A2=n216 ZN=n121 VDD=VDD VSS=VSS
XU199 nr02d0 $PINS A1=n227 A2=n216 ZN=n120 VDD=VDD VSS=VSS
XU200 nr02d0 $PINS A1=n226 A2=n216 ZN=n119 VDD=VDD VSS=VSS
XU201 nr02d0 $PINS A1=n225 A2=n216 ZN=n118 VDD=VDD VSS=VSS
XU202 nr02d0 $PINS A1=n224 A2=n216 ZN=n117 VDD=VDD VSS=VSS
XU203 nr02d0 $PINS A1=n223 A2=n216 ZN=n116 VDD=VDD VSS=VSS
XU204 nr02d0 $PINS A1=n222 A2=n216 ZN=n115 VDD=VDD VSS=VSS
XU205 nr02d0 $PINS A1=n229 A2=n215 ZN=n114 VDD=VDD VSS=VSS
XU206 nr02d0 $PINS A1=n228 A2=n215 ZN=n113 VDD=VDD VSS=VSS
XU207 nr02d0 $PINS A1=n227 A2=n215 ZN=n112 VDD=VDD VSS=VSS
XU208 nr02d0 $PINS A1=n226 A2=n215 ZN=n111 VDD=VDD VSS=VSS
XU209 nr02d0 $PINS A1=n225 A2=n215 ZN=n110 VDD=VDD VSS=VSS
XU210 nr02d0 $PINS A1=n224 A2=n215 ZN=n109 VDD=VDD VSS=VSS
XU211 nr02d0 $PINS A1=n223 A2=n215 ZN=n108 VDD=VDD VSS=VSS
XU212 nr02d0 $PINS A1=n222 A2=n215 ZN=n107 VDD=VDD VSS=VSS
XU213 nr02d0 $PINS A1=n229 A2=a[7] ZN=n106 VDD=VDD VSS=VSS
XU214 nr02d0 $PINS A1=a[7] A2=n228 ZN=n105 VDD=VDD VSS=VSS
XU215 nr02d0 $PINS A1=a[7] A2=n227 ZN=n104 VDD=VDD VSS=VSS
XU216 nr02d0 $PINS A1=a[7] A2=n226 ZN=n103 VDD=VDD VSS=VSS
XU217 nr02d0 $PINS A1=a[7] A2=n225 ZN=n102 VDD=VDD VSS=VSS
XU218 nr02d0 $PINS A1=a[7] A2=n224 ZN=n101 VDD=VDD VSS=VSS
XU219 nr02d0 $PINS A1=a[7] A2=n223 ZN=n100 VDD=VDD VSS=VSS
.ENDS

.SUBCKT unpu_pe_11_DW01_add_0_DW01_add_12 A[31] A[30] A[29] A[28] A[27] A[26]
+ A[25] A[24] A[23] A[22] A[21] A[20] A[19] A[18] A[17] A[16] A[15] A[14] A[13]
+ A[12] A[11] A[10] A[9] A[8] A[7] A[6] A[5] A[4] A[3] A[2] A[1] A[0] B[31]
+ B[30] B[29] B[28] B[27] B[26] B[25] B[24] B[23] B[22] B[21] B[20] B[19] B[18]
+ B[17] B[16] B[15] B[14] B[13] B[12] B[11] B[10] B[9] B[8] B[7] B[6] B[5] B[4]
+ B[3] B[2] B[1] B[0] CI SUM[31] SUM[30] SUM[29] SUM[28] SUM[27] SUM[26]
+ SUM[25] SUM[24] SUM[23] SUM[22] SUM[21] SUM[20] SUM[19] SUM[18] SUM[17]
+ SUM[16] SUM[15] SUM[14] SUM[13] SUM[12] SUM[11] SUM[10] SUM[9] SUM[8] SUM[7]
+ SUM[6] SUM[5] SUM[4] SUM[3] SUM[2] SUM[1] SUM[0] CO VDD VSS
XU1_31 ad01d0 $PINS A=A[31] B=B[31] CI=carry[31] S=SUM[31] VDD=VDD VSS=VSS
XU1_30 ad01d0 $PINS A=A[30] B=B[30] CI=carry[30] CO=carry[31] S=SUM[30] VDD=VDD
+ VSS=VSS
XU1_29 ad01d0 $PINS A=A[29] B=B[29] CI=carry[29] CO=carry[30] S=SUM[29] VDD=VDD
+ VSS=VSS
XU1_28 ad01d0 $PINS A=copt_net_324 B=B[28] CI=carry[28] CO=carry[29] S=SUM[28]
+ VDD=VDD VSS=VSS
XU1_27 ad01d0 $PINS A=A[27] B=B[27] CI=carry[27] CO=carry[28] S=SUM[27] VDD=VDD
+ VSS=VSS
XU1_26 ad01d0 $PINS A=A[26] B=B[26] CI=carry[26] CO=carry[27] S=SUM[26] VDD=VDD
+ VSS=VSS
XU1_25 ad01d0 $PINS A=A[25] B=B[25] CI=carry[25] CO=carry[26] S=SUM[25] VDD=VDD
+ VSS=VSS
XU1_24 ad01d0 $PINS A=A[24] B=B[24] CI=carry[24] CO=carry[25] S=SUM[24] VDD=VDD
+ VSS=VSS
XU1_23 ad01d0 $PINS A=A[23] B=B[23] CI=carry[23] CO=carry[24] S=SUM[23] VDD=VDD
+ VSS=VSS
XU1_22 ad01d0 $PINS A=A[22] B=B[22] CI=carry[22] CO=carry[23] S=SUM[22] VDD=VDD
+ VSS=VSS
XU1_21 ad01d1 $PINS A=A[21] B=B[21] CI=carry[21] CO=carry[22] S=SUM[21] VDD=VDD
+ VSS=VSS
XU1_20 ad01d0 $PINS A=A[20] B=B[20] CI=carry[20] CO=carry[21] S=SUM[20] VDD=VDD
+ VSS=VSS
XU1_19 ad01d0 $PINS A=A[19] B=B[19] CI=carry[19] CO=carry[20] S=SUM[19] VDD=VDD
+ VSS=VSS
XU1_18 ad01d1 $PINS A=A[18] B=B[18] CI=carry[18] CO=carry[19] S=SUM[18] VDD=VDD
+ VSS=VSS
XU1_17 ad01d1 $PINS A=A[17] B=B[17] CI=carry[17] CO=carry[18] S=SUM[17] VDD=VDD
+ VSS=VSS
XU1_16 ad01d0 $PINS A=A[16] B=B[16] CI=carry[16] CO=carry[17] S=SUM[16] VDD=VDD
+ VSS=VSS
XU1_15 ad01d1 $PINS A=A[15] B=B[15] CI=carry[15] CO=carry[16] S=SUM[15] VDD=VDD
+ VSS=VSS
XU1_14 ad01d1 $PINS A=A[14] B=B[14] CI=carry[14] CO=carry[15] S=SUM[14] VDD=VDD
+ VSS=VSS
XU1_13 ad01d0 $PINS A=A[13] B=B[13] CI=carry[13] CO=carry[14] S=SUM[13] VDD=VDD
+ VSS=VSS
XU1_12 ad01d0 $PINS A=A[12] B=B[12] CI=carry[12] CO=carry[13] S=SUM[12] VDD=VDD
+ VSS=VSS
XU1_11 ad01d0 $PINS A=A[11] B=B[11] CI=carry[11] CO=carry[12] S=SUM[11] VDD=VDD
+ VSS=VSS
XU1_10 ad01d1 $PINS A=A[10] B=B[10] CI=carry[10] CO=carry[11] S=SUM[10] VDD=VDD
+ VSS=VSS
XU1_9 ad01d1 $PINS A=A[9] B=B[9] CI=carry[9] CO=carry[10] S=SUM[9] VDD=VDD
+ VSS=VSS
XU1_8 ad01d1 $PINS A=A[8] B=B[8] CI=carry[8] CO=carry[9] S=SUM[8] VDD=VDD
+ VSS=VSS
XU1_7 ad01d1 $PINS A=A[7] B=B[7] CI=carry[7] CO=carry[8] S=SUM[7] VDD=VDD
+ VSS=VSS
XU1_6 ad01d1 $PINS A=A[6] B=B[6] CI=carry[6] CO=carry[7] S=SUM[6] VDD=VDD
+ VSS=VSS
XU1_5 ad01d1 $PINS A=A[5] B=B[5] CI=carry[5] CO=carry[6] S=SUM[5] VDD=VDD
+ VSS=VSS
XU1_4 ad01d1 $PINS A=A[4] B=B[4] CI=carry[4] CO=carry[5] S=SUM[4] VDD=VDD
+ VSS=VSS
XU1_3 ad01d1 $PINS A=A[3] B=B[3] CI=carry[3] CO=carry[4] S=SUM[3] VDD=VDD
+ VSS=VSS
XU1_2 ad01d1 $PINS A=A[2] B=B[2] CI=carry[2] CO=carry[3] S=SUM[2] VDD=VDD
+ VSS=VSS
XU1_1 ad01d0 $PINS A=A[1] B=B[1] CI=n1 CO=carry[2] S=SUM[1] VDD=VDD VSS=VSS
XU1 an02d1 $PINS A1=B[0] A2=A[0] Z=n1 VDD=VDD VSS=VSS
XU2 xr02d1 $PINS A1=A[0] A2=B[0] Z=SUM[0] VDD=VDD VSS=VSS
Xcopt_h_inst_3154 dl01d1 $PINS I=A[28] Z=copt_net_324 VDD=VDD VSS=VSS
.ENDS

.SUBCKT unpu_pe_11 rst_n array_en weight_load mode_unsigned weight_in[7]
+ weight_in[6] weight_in[5] weight_in[4] weight_in[3] weight_in[2] weight_in[1]
+ weight_in[0] act_in[7] act_in[6] act_in[5] act_in[4] act_in[3] act_in[2]
+ act_in[1] act_in[0] psum_in[31] psum_in[30] psum_in[29] psum_in[28]
+ psum_in[27] psum_in[26] psum_in[25] psum_in[24] psum_in[23] psum_in[22]
+ psum_in[21] psum_in[20] psum_in[19] psum_in[18] psum_in[17] psum_in[16]
+ psum_in[15] psum_in[14] psum_in[13] psum_in[12] psum_in[11] psum_in[10]
+ psum_in[9] psum_in[8] psum_in[7] psum_in[6] psum_in[5] psum_in[4] psum_in[3]
+ psum_in[2] psum_in[1] psum_in[0] act_out[7] act_out[6] act_out[5] act_out[4]
+ act_out[3] act_out[2] act_out[1] act_out[0] psum_out[31] psum_out[30]
+ psum_out[29] psum_out[28] psum_out[27] psum_out[26] psum_out[25] psum_out[24]
+ psum_out[23] psum_out[22] psum_out[21] psum_out[20] psum_out[19] psum_out[18]
+ psum_out[17] psum_out[16] psum_out[15] psum_out[14] psum_out[13] psum_out[12]
+ psum_out[11] psum_out[10] psum_out[9] psum_out[8] psum_out[7] psum_out[6]
+ psum_out[5] psum_out[4] psum_out[3] psum_out[2] psum_out[1] psum_out[0] VDD
+ VSS ZCTSNET_0 HFSNET_2 HFSNET_3 HFSNET_4 HFSNET_5 HFSNET_7 HFSNET_8 HFSNET_9
+ HFSNET_10 HFSNET_11 ZCTSNET_1
XU2 aor22d1 $PINS A1=N_uc_30 A2=HFSNET_2 B1=mode_unsigned B2=N_uc_14
+ Z=product[9] VDD=VDD VSS=VSS
XU3 aor22d1 $PINS A1=N_uc_29 A2=HFSNET_2 B1=N_uc_13 B2=mode_unsigned
+ Z=product[8] VDD=VDD VSS=VSS
XU5 aor22d1 $PINS A1=N_uc_28 A2=HFSNET_2 B1=N_uc_12 B2=mode_unsigned
+ Z=product[7] VDD=VDD VSS=VSS
XU6 aor22d1 $PINS A1=N_uc_27 A2=HFSNET_2 B1=N_uc_11 B2=mode_unsigned
+ Z=product[6] VDD=VDD VSS=VSS
XU7 aor22d1 $PINS A1=N_uc_26 A2=HFSNET_2 B1=N_uc_10 B2=mode_unsigned
+ Z=product[5] VDD=VDD VSS=VSS
XU8 aor22d1 $PINS A1=N_uc_9 A2=mode_unsigned B1=N_uc_25 B2=HFSNET_2
+ Z=product[4] VDD=VDD VSS=VSS
XU9 aor22d1 $PINS A1=N_uc_8 A2=mode_unsigned B1=N_uc_24 B2=HFSNET_2
+ Z=product[3] VDD=VDD VSS=VSS
XU10 aor22d1 $PINS A1=N_uc_7 A2=mode_unsigned B1=N_uc_23 B2=HFSNET_2
+ Z=product[2] VDD=VDD VSS=VSS
XU11 aor22d1 $PINS A1=N_uc_6 A2=mode_unsigned B1=N_uc_22 B2=HFSNET_2
+ Z=product[1] VDD=VDD VSS=VSS
XU12 oaim21d1 $PINS B1=N_uc_20 B2=mode_unsigned A=n13 ZN=product[15] VDD=VDD
+ VSS=VSS
XU13 aor22d1 $PINS A1=N_uc_35 A2=HFSNET_2 B1=N_uc_19 B2=mode_unsigned
+ Z=product[14] VDD=VDD VSS=VSS
XU14 aor22d1 $PINS A1=N_uc_34 A2=HFSNET_2 B1=N_uc_18 B2=mode_unsigned
+ Z=product[13] VDD=VDD VSS=VSS
XU15 aor22d1 $PINS A1=N_uc_33 A2=HFSNET_2 B1=N_uc_17 B2=mode_unsigned
+ Z=product[12] VDD=VDD VSS=VSS
XU16 aor22d1 $PINS A1=N_uc_32 A2=HFSNET_2 B1=N_uc_16 B2=mode_unsigned
+ Z=product[11] VDD=VDD VSS=VSS
XU17 aor22d1 $PINS A1=N_uc_31 A2=HFSNET_2 B1=N_uc_15 B2=mode_unsigned
+ Z=product[10] VDD=VDD VSS=VSS
XU18 aor22d1 $PINS A1=N_uc_5 A2=mode_unsigned B1=N_uc_21 B2=HFSNET_2
+ Z=product[0] VDD=VDD VSS=VSS
Xadd_42 unpu_pe_11_DW01_add_0_DW01_add_12 $PINS A[31]=psum_in[31]
+ A[30]=psum_in[30] A[29]=psum_in[29] A[28]=psum_in[28] A[27]=psum_in[27]
+ A[26]=psum_in[26] A[25]=psum_in[25] A[24]=psum_in[24] A[23]=psum_in[23]
+ A[22]=psum_in[22] A[21]=psum_in[21] A[20]=psum_in[20] A[19]=psum_in[19]
+ A[18]=psum_in[18] A[17]=psum_in[17] A[16]=psum_in[16] A[15]=psum_in[15]
+ A[14]=psum_in[14] A[13]=psum_in[13] A[12]=psum_in[12] A[11]=psum_in[11]
+ A[10]=psum_in[10] A[9]=psum_in[9] A[8]=psum_in[8] A[7]=psum_in[7]
+ A[6]=psum_in[6] A[5]=psum_in[5] A[4]=psum_in[4] A[3]=psum_in[3] A[2]=psum_in[2]
+ A[1]=psum_in[1] A[0]=psum_in[0] B[31]=n2 B[30]=n2 B[29]=n2 B[28]=n2 B[27]=n2
+ B[26]=n2 B[25]=n2 B[24]=n2 B[23]=n2 B[22]=n2 B[21]=n2 B[20]=n2 B[19]=n2
+ B[18]=n2 B[17]=n2 B[16]=n2 B[15]=product[15] B[14]=product[14]
+ B[13]=product[13] B[12]=product[12] B[11]=product[11] B[10]=product[10]
+ B[9]=product[9] B[8]=product[8] B[7]=product[7] B[6]=product[6] B[5]=product[5]
+ B[4]=product[4] B[3]=product[3] B[2]=product[2] B[1]=product[1] B[0]=product[0]
+ CI=VSS SUM[31]=N_uc_71 SUM[30]=N_uc_70 SUM[29]=N_uc_69 SUM[28]=N_uc_68
+ SUM[27]=N_uc_67 SUM[26]=N_uc_66 SUM[25]=N_uc_65 SUM[24]=N_uc_64 SUM[23]=N_uc_63
+ SUM[22]=N_uc_62 SUM[21]=N_uc_61 SUM[20]=N_uc_60 SUM[19]=N_uc_59 SUM[18]=N_uc_58
+ SUM[17]=N_uc_57 SUM[16]=N_uc_56 SUM[15]=N_uc_55 SUM[14]=N_uc_54 SUM[13]=N_uc_53
+ SUM[12]=N_uc_52 SUM[11]=N_uc_51 SUM[10]=N_uc_50 SUM[9]=N_uc_49 SUM[8]=N_uc_48
+ SUM[7]=N_uc_47 SUM[6]=N_uc_46 SUM[5]=N_uc_45 SUM[4]=N_uc_44 SUM[3]=N_uc_43
+ SUM[2]=N_uc_42 SUM[1]=N_uc_41 SUM[0]=N_uc_40 VDD=VDD VSS=VSS
Xmult_28 unpu_pe_11_DW_mult_uns_0_DW_mult_uns_15 $PINS a[7]=gre_a_INV_1877_3
+ a[6]=weight_reg[6] a[5]=weight_reg[5] a[4]=weight_reg[4] a[3]=gre_a_INV_1821_3
+ a[2]=weight_reg[2] a[1]=gre_a_INV_1950_3 a[0]=gre_a_INV_1739_3 b[7]=act_in[7]
+ b[6]=act_in[6] b[5]=act_in[5] b[4]=act_in[4] b[3]=act_in[3] b[2]=act_in[2]
+ b[1]=act_in[1] b[0]=act_in[0] product[15]=N_uc_20 product[14]=N_uc_19
+ product[13]=N_uc_18 product[12]=N_uc_17 product[11]=N_uc_16 product[10]=N_uc_15
+ product[9]=N_uc_14 product[8]=N_uc_13 product[7]=N_uc_12 product[6]=N_uc_11
+ product[5]=N_uc_10 product[4]=N_uc_9 product[3]=N_uc_8 product[2]=N_uc_7
+ product[1]=N_uc_6 product[0]=N_uc_5 VDD=VDD VSS=VSS
Xmult_30 unpu_pe_11_DW_mult_tc_0_DW_mult_tc_14 $PINS a[7]=weight_reg[7]
+ a[6]=weight_reg[6] a[5]=weight_reg[5] a[4]=weight_reg[4] a[3]=weight_reg[3]
+ a[2]=weight_reg[2] a[1]=weight_reg[1] a[0]=gre_a_INV_1739_3 b[7]=act_in[7]
+ b[6]=act_in[6] b[5]=act_in[5] b[4]=act_in[4] b[3]=act_in[3] b[2]=act_in[2]
+ b[1]=act_in[1] b[0]=act_in[0] product[15]=N_uc_36 product[14]=N_uc_35
+ product[13]=N_uc_34 product[12]=N_uc_33 product[11]=N_uc_32 product[10]=N_uc_31
+ product[9]=N_uc_30 product[8]=N_uc_29 product[7]=N_uc_28 product[6]=N_uc_27
+ product[5]=N_uc_26 product[4]=N_uc_25 product[3]=N_uc_24 product[2]=N_uc_23
+ product[1]=N_uc_22 product[0]=N_uc_21 VDD=VDD VSS=VSS
+ gre_a_INV_1877_2=gre_a_INV_1877_3 gre_a_INV_1821_2=gre_a_INV_1821_3
+ gre_a_INV_1950_2=gre_a_INV_1950_3
Xact_out_reg_3_ decrq1 $PINS D=act_in[3] ENN=HFSNET_5 CP=ZCTSNET_1
+ CDN=HFSNET_10 Q=act_out[3] VDD=VDD VSS=VSS
Xact_out_reg_2_ decrq1 $PINS D=act_in[2] ENN=HFSNET_5 CP=ZCTSNET_1
+ CDN=HFSNET_11 Q=act_out[2] VDD=VDD VSS=VSS
Xact_out_reg_1_ decrq1 $PINS D=act_in[1] ENN=HFSNET_5 CP=ZCTSNET_1
+ CDN=HFSNET_11 Q=act_out[1] VDD=VDD VSS=VSS
Xact_out_reg_7_ decrq1 $PINS D=act_in[7] ENN=HFSNET_5 CP=ZCTSNET_1
+ CDN=HFSNET_10 Q=act_out[7] VDD=VDD VSS=VSS
Xact_out_reg_6_ decrq1 $PINS D=act_in[6] ENN=HFSNET_5 CP=ZCTSNET_1
+ CDN=HFSNET_11 Q=act_out[6] VDD=VDD VSS=VSS
Xact_out_reg_5_ decrq1 $PINS D=act_in[5] ENN=HFSNET_5 CP=ZCTSNET_1
+ CDN=HFSNET_11 Q=act_out[5] VDD=VDD VSS=VSS
Xact_out_reg_4_ decrq1 $PINS D=copt_net_289 ENN=HFSNET_5 CP=ZCTSNET_1
+ CDN=HFSNET_11 Q=act_out[4] VDD=VDD VSS=VSS
Xact_out_reg_0_ decrq1 $PINS D=act_in[0] ENN=HFSNET_5 CP=ZCTSNET_1
+ CDN=HFSNET_11 Q=act_out[0] VDD=VDD VSS=VSS
Xpsum_out_reg_7_ decrq1 $PINS D=N_uc_47 ENN=array_en CP=ZCTSNET_1 CDN=HFSNET_11
+ Q=psum_out[7] VDD=VDD VSS=VSS
Xpsum_out_reg_6_ decrq1 $PINS D=N_uc_46 ENN=array_en CP=ZCTSNET_1 CDN=HFSNET_11
+ Q=psum_out[6] VDD=VDD VSS=VSS
Xpsum_out_reg_5_ decrq1 $PINS D=N_uc_45 ENN=array_en CP=ZCTSNET_1 CDN=HFSNET_11
+ Q=psum_out[5] VDD=VDD VSS=VSS
Xpsum_out_reg_4_ decrq1 $PINS D=N_uc_44 ENN=array_en CP=ZCTSNET_1 CDN=HFSNET_11
+ Q=psum_out[4] VDD=VDD VSS=VSS
Xpsum_out_reg_3_ decrq1 $PINS D=N_uc_43 ENN=array_en CP=ZCTSNET_1 CDN=HFSNET_11
+ Q=psum_out[3] VDD=VDD VSS=VSS
Xpsum_out_reg_2_ decrq1 $PINS D=N_uc_42 ENN=array_en CP=ZCTSNET_1 CDN=HFSNET_11
+ Q=psum_out[2] VDD=VDD VSS=VSS
Xpsum_out_reg_1_ decrq1 $PINS D=N_uc_41 ENN=HFSNET_5 CP=ZCTSNET_1 CDN=HFSNET_9
+ Q=psum_out[1] VDD=VDD VSS=VSS
Xpsum_out_reg_0_ decrq1 $PINS D=N_uc_40 ENN=HFSNET_5 CP=ZCTSNET_1 CDN=HFSNET_9
+ Q=psum_out[0] VDD=VDD VSS=VSS
Xpsum_out_reg_8_ decrq1 $PINS D=N_uc_48 ENN=array_en CP=ZCTSNET_1 CDN=HFSNET_11
+ Q=psum_out[8] VDD=VDD VSS=VSS
Xpsum_out_reg_9_ decrq1 $PINS D=N_uc_49 ENN=array_en CP=ZCTSNET_1 CDN=HFSNET_11
+ Q=psum_out[9] VDD=VDD VSS=VSS
Xpsum_out_reg_10_ decrq1 $PINS D=N_uc_50 ENN=array_en CP=ZCTSNET_1
+ CDN=HFSNET_11 Q=psum_out[10] VDD=VDD VSS=VSS
Xweight_reg_reg_7_ decrq1 $PINS D=weight_in[7] ENN=n12 CP=ZCTSNET_0 CDN=rst_n
+ Q=weight_reg[7] VDD=VDD VSS=VSS
Xweight_reg_reg_6_ decrq1 $PINS D=weight_in[6] ENN=n12 CP=ZCTSNET_0 CDN=rst_n
+ Q=weight_reg[6] VDD=VDD VSS=VSS
Xweight_reg_reg_5_ decrq1 $PINS D=weight_in[5] ENN=n12 CP=ZCTSNET_0 CDN=rst_n
+ Q=weight_reg[5] VDD=VDD VSS=VSS
Xweight_reg_reg_4_ decrq1 $PINS D=weight_in[4] ENN=n12 CP=ZCTSNET_0
+ CDN=HFSNET_9 Q=weight_reg[4] VDD=VDD VSS=VSS
Xweight_reg_reg_3_ decrq1 $PINS D=weight_in[3] ENN=n12 CP=ZCTSNET_0
+ CDN=HFSNET_9 Q=weight_reg[3] VDD=VDD VSS=VSS
Xweight_reg_reg_2_ decrq1 $PINS D=weight_in[2] ENN=n12 CP=ZCTSNET_0
+ CDN=HFSNET_9 Q=weight_reg[2] VDD=VDD VSS=VSS
Xweight_reg_reg_1_ decrq1 $PINS D=weight_in[1] ENN=n12 CP=ZCTSNET_0
+ CDN=HFSNET_9 Q=weight_reg[1] VDD=VDD VSS=VSS
Xweight_reg_reg_0_ decrq1 $PINS D=weight_in[0] ENN=n12 CP=ZCTSNET_1
+ CDN=HFSNET_9 Q=weight_reg[0] VDD=VDD VSS=VSS
Xpsum_out_reg_11_ decrq1 $PINS D=N_uc_51 ENN=HFSNET_5 CP=ZCTSNET_1
+ CDN=HFSNET_11 Q=psum_out[11] VDD=VDD VSS=VSS
Xpsum_out_reg_12_ decrq1 $PINS D=N_uc_52 ENN=HFSNET_5 CP=ZCTSNET_1
+ CDN=HFSNET_11 Q=psum_out[12] VDD=VDD VSS=VSS
Xpsum_out_reg_13_ decrq1 $PINS D=N_uc_53 ENN=HFSNET_5 CP=ZCTSNET_1
+ CDN=HFSNET_11 Q=psum_out[13] VDD=VDD VSS=VSS
Xpsum_out_reg_14_ decrq1 $PINS D=N_uc_54 ENN=HFSNET_5 CP=ZCTSNET_1
+ CDN=HFSNET_11 Q=psum_out[14] VDD=VDD VSS=VSS
Xpsum_out_reg_15_ decrq1 $PINS D=N_uc_55 ENN=HFSNET_5 CP=ZCTSNET_1
+ CDN=HFSNET_11 Q=psum_out[15] VDD=VDD VSS=VSS
Xpsum_out_reg_16_ decrq1 $PINS D=N_uc_56 ENN=HFSNET_5 CP=ZCTSNET_1
+ CDN=HFSNET_11 Q=psum_out[16] VDD=VDD VSS=VSS
Xpsum_out_reg_17_ decrq1 $PINS D=N_uc_57 ENN=HFSNET_5 CP=ZCTSNET_1
+ CDN=HFSNET_11 Q=psum_out[17] VDD=VDD VSS=VSS
Xpsum_out_reg_18_ decrq1 $PINS D=N_uc_58 ENN=HFSNET_7 CP=ZCTSNET_1 CDN=HFSNET_9
+ Q=psum_out[18] VDD=VDD VSS=VSS
Xpsum_out_reg_19_ decrq1 $PINS D=N_uc_59 ENN=array_en CP=ZCTSNET_1
+ CDN=HFSNET_11 Q=psum_out[19] VDD=VDD VSS=VSS
Xpsum_out_reg_20_ decrq1 $PINS D=N_uc_60 ENN=HFSNET_5 CP=ZCTSNET_1 CDN=HFSNET_9
+ Q=psum_out[20] VDD=VDD VSS=VSS
Xpsum_out_reg_21_ decrq1 $PINS D=N_uc_61 ENN=HFSNET_5 CP=ZCTSNET_1 CDN=HFSNET_9
+ Q=psum_out[21] VDD=VDD VSS=VSS
Xpsum_out_reg_22_ decrq1 $PINS D=N_uc_62 ENN=array_en CP=ZCTSNET_1
+ CDN=HFSNET_11 Q=psum_out[22] VDD=VDD VSS=VSS
Xpsum_out_reg_23_ decrq1 $PINS D=N_uc_63 ENN=HFSNET_7 CP=ZCTSNET_1 CDN=HFSNET_9
+ Q=psum_out[23] VDD=VDD VSS=VSS
Xpsum_out_reg_24_ decrq1 $PINS D=N_uc_64 ENN=HFSNET_4 CP=ZCTSNET_0 CDN=HFSNET_9
+ Q=psum_out[24] VDD=VDD VSS=VSS
Xpsum_out_reg_25_ decrq1 $PINS D=N_uc_65 ENN=HFSNET_5 CP=ZCTSNET_1 CDN=HFSNET_9
+ Q=psum_out[25] VDD=VDD VSS=VSS
Xpsum_out_reg_26_ decrq1 $PINS D=N_uc_66 ENN=HFSNET_5 CP=ZCTSNET_1 CDN=HFSNET_9
+ Q=psum_out[26] VDD=VDD VSS=VSS
Xpsum_out_reg_27_ decrq1 $PINS D=N_uc_67 ENN=HFSNET_7 CP=ZCTSNET_0 CDN=HFSNET_9
+ Q=psum_out[27] VDD=VDD VSS=VSS
Xpsum_out_reg_28_ decrq1 $PINS D=N_uc_68 ENN=HFSNET_7 CP=ZCTSNET_1 CDN=HFSNET_9
+ Q=psum_out[28] VDD=VDD VSS=VSS
Xpsum_out_reg_29_ decrq1 $PINS D=N_uc_69 ENN=HFSNET_4 CP=ZCTSNET_0 CDN=HFSNET_9
+ Q=psum_out[29] VDD=VDD VSS=VSS
Xpsum_out_reg_30_ decrq1 $PINS D=N_uc_70 ENN=HFSNET_7 CP=ZCTSNET_1 CDN=HFSNET_9
+ Q=psum_out[30] VDD=VDD VSS=VSS
Xpsum_out_reg_31_ decrq1 $PINS D=N_uc_71 ENN=HFSNET_5 CP=ZCTSNET_1 CDN=HFSNET_9
+ Q=psum_out[31] VDD=VDD VSS=VSS
XU19 inv0d2 $PINS I=n13 ZN=n2 VDD=VDD VSS=VSS
Xcopt_h_inst_3119 dl02d1 $PINS I=act_in[4] Z=copt_net_289 VDD=VDD VSS=VSS
Xgre_a_INV_1739_inst_5798 inv0d1 $PINS I=weight_reg[0] ZN=gre_a_INV_1739_3
+ VDD=VDD VSS=VSS
XU22 nd02d1 $PINS A1=weight_load A2=HFSNET_8 ZN=n12 VDD=VDD VSS=VSS
Xgre_a_INV_1877_inst_5805 inv0d1 $PINS I=weight_reg[7] ZN=gre_a_INV_1877_3
+ VDD=VDD VSS=VSS
Xgre_a_INV_1821_inst_5814 inv0d1 $PINS I=weight_reg[3] ZN=gre_a_INV_1821_3
+ VDD=VDD VSS=VSS
Xgre_a_INV_1950_inst_5833 inv0d1 $PINS I=weight_reg[1] ZN=gre_a_INV_1950_3
+ VDD=VDD VSS=VSS
XU27 nd02d1 $PINS A1=N_uc_36 A2=HFSNET_3 ZN=n13 VDD=VDD VSS=VSS
.ENDS

.SUBCKT unpu_pe_12_DW_mult_tc_0_DW_mult_tc_9 a[7] a[6] a[5] a[4] a[3] a[2] a[1]
+ a[0] b[7] b[6] b[5] b[4] b[3] b[2] b[1] b[0] product[15] product[14]
+ product[13] product[12] product[11] product[10] product[9] product[8]
+ product[7] product[6] product[5] product[4] product[3] product[2] product[1]
+ product[0] VDD VSS gre_a_INV_1429_2
XU2 ad01d0 $PINS A=n196 B=n61 CI=n2 CO=n1 S=product[14] VDD=VDD VSS=VSS
XU3 ad01d0 $PINS A=n17 B=n16 CI=n3 CO=n2 S=product[13] VDD=VDD VSS=VSS
XU4 ad01d0 $PINS A=n18 B=n19 CI=n4 CO=n3 S=product[12] VDD=VDD VSS=VSS
XU5 ad01d0 $PINS A=n20 B=n23 CI=n5 CO=n4 S=product[11] VDD=VDD VSS=VSS
XU6 ad01d0 $PINS A=n27 B=n24 CI=n6 CO=n5 S=product[10] VDD=VDD VSS=VSS
XU7 ad01d0 $PINS A=n33 B=n28 CI=n7 CO=n6 S=product[9] VDD=VDD VSS=VSS
XU8 ad01d0 $PINS A=n39 B=n34 CI=n8 CO=n7 S=product[8] VDD=VDD VSS=VSS
XU9 ad01d0 $PINS A=n45 B=n40 CI=n9 CO=n8 S=product[7] VDD=VDD VSS=VSS
XU10 ad01d0 $PINS A=n49 B=n46 CI=n10 CO=n9 S=product[6] VDD=VDD VSS=VSS
XU11 ad01d0 $PINS A=n53 B=n50 CI=n11 CO=n10 S=product[5] VDD=VDD VSS=VSS
XU12 ad01d0 $PINS A=n55 B=n54 CI=n12 CO=n11 S=product[4] VDD=VDD VSS=VSS
XU13 ad01d0 $PINS A=n59 B=n56 CI=n13 CO=n12 S=product[3] VDD=VDD VSS=VSS
XU14 ad01d0 $PINS A=n84 B=n91 CI=n14 CO=n13 S=product[2] VDD=VDD VSS=VSS
XctmTdsLR_1_2935 an02d1 $PINS A1=n90 A2=n83 Z=n55 VDD=VDD VSS=VSS
XU17 ad01d0 $PINS A=n195 B=n62 CI=n69 CO=n17 S=n18 VDD=VDD VSS=VSS
XU18 ad01d0 $PINS A=n63 B=n25 CI=n22 CO=n19 S=n20 VDD=VDD VSS=VSS
XU20 ad01d0 $PINS A=n64 B=n26 CI=n29 CO=n23 S=n24 VDD=VDD VSS=VSS
XU21 ad01d0 $PINS A=n194 B=n70 CI=n77 CO=n25 S=n26 VDD=VDD VSS=VSS
XU22 ad01d0 $PINS A=n32 B=n35 CI=n30 CO=n27 S=n28 VDD=VDD VSS=VSS
XU23 ad01d0 $PINS A=n71 B=n65 CI=n37 CO=n29 S=n30 VDD=VDD VSS=VSS
XU25 ad01d0 $PINS A=n38 B=n41 CI=n36 CO=n33 S=n34 VDD=VDD VSS=VSS
XU26 ad01d0 $PINS A=n72 B=n85 CI=n43 CO=n35 S=n36 VDD=VDD VSS=VSS
XU29 ad01d0 $PINS A=n44 B=n47 CI=n42 CO=n39 S=n40 VDD=VDD VSS=VSS
XU30 ad01d0 $PINS A=n86 B=n73 CI=n79 CO=n41 S=n42 VDD=VDD VSS=VSS
XU32 ad01d0 $PINS A=n74 B=n51 CI=n48 CO=n45 S=n46 VDD=VDD VSS=VSS
XU33 ad01d0 $PINS A=n68 B=n87 CI=n80 CO=n47 S=n48 VDD=VDD VSS=VSS
XU34 ad01d0 $PINS A=n88 B=n81 CI=n52 CO=n49 S=n50 VDD=VDD VSS=VSS
XctmTdsLR_1_2949 an02d1 $PINS A1=n57 A2=n67 Z=n43 VDD=VDD VSS=VSS
XU36 ad01d0 $PINS A=n76 B=n89 CI=n82 CO=n53 S=n54 VDD=VDD VSS=VSS
XctmTdsLR_2_2950 aoim21d1 $PINS B1=n57 B2=n67 A=n43 ZN=n44 VDD=VDD VSS=VSS
XU145 oai21d1 $PINS B1=n203 B2=n249 A=n222 ZN=n77 VDD=VDD VSS=VSS
XU146 oai21d1 $PINS B1=n201 B2=n250 A=n232 ZN=n69 VDD=VDD VSS=VSS
XU147 oai21d1 $PINS B1=n199 B2=n251 A=n242 ZN=n61 VDD=VDD VSS=VSS
XU148 inv0d0 $PINS I=n16 ZN=n196 VDD=VDD VSS=VSS
XU149 inv0d0 $PINS I=n223 ZN=n201 VDD=VDD VSS=VSS
XU150 inv0d0 $PINS I=n214 ZN=n203 VDD=VDD VSS=VSS
XU151 inv0d0 $PINS I=n233 ZN=n199 VDD=VDD VSS=VSS
XU152 inv0d0 $PINS I=n32 ZN=n194 VDD=VDD VSS=VSS
XU153 inv0d0 $PINS I=n22 ZN=n195 VDD=VDD VSS=VSS
XU154 nd02d1 $PINS A1=n214 A2=n249 ZN=n216 VDD=VDD VSS=VSS
XU155 xr02d1 $PINS A1=a[2] A2=n204 Z=n214 VDD=VDD VSS=VSS
XU156 inv0d1 $PINS I=a[1] ZN=n204 VDD=VDD VSS=VSS
XU157 nd02d1 $PINS A1=n223 A2=n250 ZN=n225 VDD=VDD VSS=VSS
XU158 xr02d1 $PINS A1=a[4] A2=n202 Z=n223 VDD=VDD VSS=VSS
XU159 inv0d1 $PINS I=a[3] ZN=n202 VDD=VDD VSS=VSS
XU160 nd02d1 $PINS A1=a[1] A2=a[0] ZN=n206 VDD=VDD VSS=VSS
XU162 xr02d1 $PINS A1=a[6] A2=gre_a_INV_1429_2 Z=n233 VDD=VDD VSS=VSS
XU164 inv0d0 $PINS I=b[0] ZN=n197 VDD=VDD VSS=VSS
XU165 nd02d1 $PINS A1=n233 A2=n251 ZN=n235 VDD=VDD VSS=VSS
XU166 inv0d1 $PINS I=a[7] ZN=n198 VDD=VDD VSS=VSS
XU167 inv0d0 $PINS I=n1 ZN=product[15] VDD=VDD VSS=VSS
XU168 nr02d0 $PINS A1=a[0] A2=n197 ZN=product[0] VDD=VDD VSS=VSS
XU169 oai22d1 $PINS A1=b[0] A2=n206 B1=n207 B2=a[0] ZN=n92 VDD=VDD VSS=VSS
XU170 oai22d1 $PINS A1=n207 A2=n206 B1=n208 B2=a[0] ZN=n91 VDD=VDD VSS=VSS
XU171 xr02d1 $PINS A1=b[1] A2=n204 Z=n207 VDD=VDD VSS=VSS
XU172 oai22d1 $PINS A1=n208 A2=n206 B1=n209 B2=a[0] ZN=n90 VDD=VDD VSS=VSS
XU173 xr02d1 $PINS A1=b[2] A2=n204 Z=n208 VDD=VDD VSS=VSS
XU174 oai22d1 $PINS A1=n209 A2=n206 B1=n210 B2=a[0] ZN=n89 VDD=VDD VSS=VSS
XU175 xr02d1 $PINS A1=b[3] A2=n204 Z=n209 VDD=VDD VSS=VSS
XU176 oai22d1 $PINS A1=n210 A2=n206 B1=n211 B2=a[0] ZN=n88 VDD=VDD VSS=VSS
XU177 xr02d1 $PINS A1=b[4] A2=n204 Z=n210 VDD=VDD VSS=VSS
XU178 oai22d1 $PINS A1=n211 A2=n206 B1=n212 B2=a[0] ZN=n87 VDD=VDD VSS=VSS
XU179 xr02d1 $PINS A1=b[5] A2=n204 Z=n211 VDD=VDD VSS=VSS
XU180 oai22d1 $PINS A1=n212 A2=n206 B1=n213 B2=a[0] ZN=n86 VDD=VDD VSS=VSS
XU181 xr02d1 $PINS A1=b[6] A2=n204 Z=n212 VDD=VDD VSS=VSS
XU182 aor21d1 $PINS B1=a[0] B2=n206 A=n213 Z=n85 VDD=VDD VSS=VSS
XU183 xr02d1 $PINS A1=b[7] A2=n204 Z=n213 VDD=VDD VSS=VSS
XU184 nr02d0 $PINS A1=n214 A2=n197 ZN=n84 VDD=VDD VSS=VSS
XU185 oai22d1 $PINS A1=n216 A2=n215 B1=n214 B2=n217 ZN=n83 VDD=VDD VSS=VSS
XctmTdsLR_1_2925 an02d1 $PINS A1=n60 A2=n92 Z=n14 VDD=VDD VSS=VSS
XU187 oai22d1 $PINS A1=n217 A2=n216 B1=n214 B2=n218 ZN=n82 VDD=VDD VSS=VSS
XU188 xr02d1 $PINS A1=b[1] A2=n202 Z=n217 VDD=VDD VSS=VSS
XU189 oai22d1 $PINS A1=n218 A2=n216 B1=n214 B2=n219 ZN=n81 VDD=VDD VSS=VSS
XU190 xr02d1 $PINS A1=b[2] A2=n202 Z=n218 VDD=VDD VSS=VSS
XU191 oai22d1 $PINS A1=n219 A2=n216 B1=n214 B2=n220 ZN=n80 VDD=VDD VSS=VSS
XU192 xr02d1 $PINS A1=b[3] A2=n202 Z=n219 VDD=VDD VSS=VSS
XU193 oai22d1 $PINS A1=n220 A2=n216 B1=n214 B2=n221 ZN=n79 VDD=VDD VSS=VSS
XU194 xr02d1 $PINS A1=b[4] A2=n202 Z=n220 VDD=VDD VSS=VSS
XU195 nr02d0 $PINS A1=n223 A2=n197 ZN=n76 VDD=VDD VSS=VSS
XU196 oai22d1 $PINS A1=n225 A2=n224 B1=n226 B2=n223 ZN=n75 VDD=VDD VSS=VSS
XctmTdsLR_2_2926 aoim21d1 $PINS B1=n92 B2=n60 A=n14 ZN=product[1] VDD=VDD
+ VSS=VSS
XU198 oai22d1 $PINS A1=n226 A2=n225 B1=n223 B2=n227 ZN=n74 VDD=VDD VSS=VSS
XU199 xr02d1 $PINS A1=b[1] A2=gre_a_INV_1429_2 Z=n226 VDD=VDD VSS=VSS
XU200 oai22d1 $PINS A1=n227 A2=n225 B1=n223 B2=n228 ZN=n73 VDD=VDD VSS=VSS
XU201 xr02d1 $PINS A1=b[2] A2=gre_a_INV_1429_2 Z=n227 VDD=VDD VSS=VSS
XU202 oai22d1 $PINS A1=n228 A2=n225 B1=n223 B2=n229 ZN=n72 VDD=VDD VSS=VSS
XU203 xr02d1 $PINS A1=b[3] A2=gre_a_INV_1429_2 Z=n228 VDD=VDD VSS=VSS
XU204 oai22d1 $PINS A1=n229 A2=n225 B1=n223 B2=n230 ZN=n71 VDD=VDD VSS=VSS
XU205 xr02d1 $PINS A1=b[4] A2=gre_a_INV_1429_2 Z=n229 VDD=VDD VSS=VSS
XU206 oai22d1 $PINS A1=n230 A2=n225 B1=n223 B2=n231 ZN=n70 VDD=VDD VSS=VSS
XU207 xr02d1 $PINS A1=b[5] A2=gre_a_INV_1429_2 Z=n230 VDD=VDD VSS=VSS
XU208 nr02d0 $PINS A1=n233 A2=n197 ZN=n68 VDD=VDD VSS=VSS
XU209 oai22d1 $PINS A1=n235 A2=n234 B1=n233 B2=n236 ZN=n67 VDD=VDD VSS=VSS
XctmTdsLR_2_2936 aoim21d1 $PINS B1=n90 B2=n83 A=n55 ZN=n56 VDD=VDD VSS=VSS
XU211 oai22d1 $PINS A1=n237 A2=n235 B1=n233 B2=n238 ZN=n65 VDD=VDD VSS=VSS
XU212 oai22d1 $PINS A1=n238 A2=n235 B1=n233 B2=n239 ZN=n64 VDD=VDD VSS=VSS
XU213 xr02d1 $PINS A1=b[3] A2=n198 Z=n238 VDD=VDD VSS=VSS
XU214 oai22d1 $PINS A1=n239 A2=n235 B1=n233 B2=n240 ZN=n63 VDD=VDD VSS=VSS
XU215 xr02d1 $PINS A1=b[4] A2=n198 Z=n239 VDD=VDD VSS=VSS
XU216 oai22d1 $PINS A1=n240 A2=n235 B1=n233 B2=n241 ZN=n62 VDD=VDD VSS=VSS
XU217 xr02d1 $PINS A1=b[5] A2=n198 Z=n240 VDD=VDD VSS=VSS
XU218 oai21d1 $PINS B1=b[0] B2=n204 A=n206 ZN=n60 VDD=VDD VSS=VSS
XU219 oai21d1 $PINS B1=n202 B2=n216 A=n243 ZN=n59 VDD=VDD VSS=VSS
XU220 nd03d0 $PINS A1=n203 A2=n197 A3=a[3] ZN=n243 VDD=VDD VSS=VSS
XU221 oai21d1 $PINS B1=gre_a_INV_1429_2 B2=n225 A=n244 ZN=n58 VDD=VDD VSS=VSS
XU222 nd03d0 $PINS A1=n201 A2=n197 A3=a[5] ZN=n244 VDD=VDD VSS=VSS
XU223 oai21d1 $PINS B1=n235 B2=n198 A=n245 ZN=n57 VDD=VDD VSS=VSS
XU224 nd03d0 $PINS A1=n199 A2=n197 A3=a[7] ZN=n245 VDD=VDD VSS=VSS
XU225 xn02d1 $PINS A1=n246 A2=n247 ZN=n38 VDD=VDD VSS=VSS
XU226 or02d0 $PINS A1=n247 A2=n246 Z=n37 VDD=VDD VSS=VSS
XU227 oai22d1 $PINS A1=n236 A2=n235 B1=n233 B2=n237 ZN=n246 VDD=VDD VSS=VSS
XU228 xr02d1 $PINS A1=b[2] A2=n198 Z=n237 VDD=VDD VSS=VSS
XU229 xr02d1 $PINS A1=b[1] A2=n198 Z=n236 VDD=VDD VSS=VSS
XU230 oai22d1 $PINS A1=n221 A2=n216 B1=n214 B2=n248 ZN=n247 VDD=VDD VSS=VSS
XU231 xr02d1 $PINS A1=b[5] A2=n202 Z=n221 VDD=VDD VSS=VSS
XU232 aoim22d1 $PINS A1=n203 A2=n222 B1=n248 B2=n216 Z=n32 VDD=VDD VSS=VSS
XU233 xr02d1 $PINS A1=a[3] A2=a[2] Z=n249 VDD=VDD VSS=VSS
XU234 xr02d1 $PINS A1=b[6] A2=n202 Z=n248 VDD=VDD VSS=VSS
XU235 xr02d1 $PINS A1=b[7] A2=a[3] Z=n222 VDD=VDD VSS=VSS
XU236 aoim22d1 $PINS A1=n201 A2=n232 B1=n231 B2=n225 Z=n22 VDD=VDD VSS=VSS
XU237 xr02d1 $PINS A1=a[5] A2=a[4] Z=n250 VDD=VDD VSS=VSS
XU238 xr02d1 $PINS A1=b[6] A2=gre_a_INV_1429_2 Z=n231 VDD=VDD VSS=VSS
XU239 xr02d1 $PINS A1=b[7] A2=a[5] Z=n232 VDD=VDD VSS=VSS
XU240 aoim22d1 $PINS A1=n199 A2=n242 B1=n241 B2=n235 Z=n16 VDD=VDD VSS=VSS
XU241 xr02d1 $PINS A1=a[7] A2=a[6] Z=n251 VDD=VDD VSS=VSS
XU242 xr02d1 $PINS A1=b[6] A2=n198 Z=n241 VDD=VDD VSS=VSS
XU243 xr02d1 $PINS A1=b[7] A2=a[7] Z=n242 VDD=VDD VSS=VSS
XctmTdsLR_1_1324 aoim22d1 $PINS A1=n202 A2=b[0] B1=n202 B2=b[0] Z=n215 VDD=VDD
+ VSS=VSS
XctmTdsLR_1_1325 aoim22d1 $PINS A1=gre_a_INV_1429_2 A2=b[0] B1=gre_a_INV_1429_2
+ B2=b[0] Z=n224 VDD=VDD VSS=VSS
XctmTdsLR_1_1326 aoim22d1 $PINS A1=n198 A2=b[0] B1=n198 B2=b[0] Z=n234 VDD=VDD
+ VSS=VSS
XctmTdsLR_1_2937 an02d1 $PINS A1=n58 A2=n75 Z=n51 VDD=VDD VSS=VSS
XctmTdsLR_2_2938 aoim21d1 $PINS B1=n58 B2=n75 A=n51 ZN=n52 VDD=VDD VSS=VSS
.ENDS

.SUBCKT unpu_pe_12_DW_mult_uns_0_DW_mult_uns_10 a[7] a[6] a[5] a[4] a[3] a[2]
+ a[1] a[0] b[7] b[6] b[5] b[4] b[3] b[2] b[1] b[0] product[15] product[14]
+ product[13] product[12] product[11] product[10] product[9] product[8]
+ product[7] product[6] product[5] product[4] product[3] product[2] product[1]
+ product[0] VDD VSS
XU2 ad01d0 $PINS A=n99 B=n15 CI=n2 CO=product[15] S=product[14] VDD=VDD VSS=VSS
XU3 ad01d0 $PINS A=n16 B=n17 CI=n3 CO=n2 S=product[13] VDD=VDD VSS=VSS
XU4 ad01d0 $PINS A=n18 B=n21 CI=n4 CO=n3 S=product[12] VDD=VDD VSS=VSS
XU5 ad01d0 $PINS A=n27 B=n22 CI=n5 CO=n4 S=product[11] VDD=VDD VSS=VSS
XU6 ad01d0 $PINS A=n35 B=n28 CI=n6 CO=n5 S=product[10] VDD=VDD VSS=VSS
XU7 ad01d0 $PINS A=n45 B=n36 CI=n7 CO=n6 S=product[9] VDD=VDD VSS=VSS
XU8 ad01d0 $PINS A=n57 B=n46 CI=n8 CO=n7 S=product[8] VDD=VDD VSS=VSS
XU9 ad01d0 $PINS A=n69 B=n58 CI=n9 CO=n8 S=product[7] VDD=VDD VSS=VSS
XU10 ad01d0 $PINS A=n79 B=n70 CI=n10 CO=n9 S=product[6] VDD=VDD VSS=VSS
XU11 ad01d0 $PINS A=n87 B=n80 CI=n11 CO=n10 S=product[5] VDD=VDD VSS=VSS
XU12 ad01d0 $PINS A=n93 B=n88 CI=n12 CO=n11 S=product[4] VDD=VDD VSS=VSS
XU13 ad01d0 $PINS A=n96 B=n13 CI=n94 CO=n12 S=product[3] VDD=VDD VSS=VSS
XU14 ad01d0 $PINS A=n146 B=n14 CI=n98 CO=n13 S=product[2] VDD=VDD VSS=VSS
XU15 ah01d1 $PINS A=n161 B=n154 CO=n14 S=product[1] VDD=VDD VSS=VSS
XU16 ad01d0 $PINS A=n107 B=n100 CI=n19 CO=n15 S=n16 VDD=VDD VSS=VSS
XU17 ad01d0 $PINS A=n25 B=n20 CI=n23 CO=n17 S=n18 VDD=VDD VSS=VSS
XU18 ad01d0 $PINS A=n115 B=n101 CI=n108 CO=n19 S=n20 VDD=VDD VSS=VSS
XU19 ad01d0 $PINS A=n31 B=n24 CI=n29 CO=n21 S=n22 VDD=VDD VSS=VSS
XU20 ad01d0 $PINS A=n116 B=n33 CI=n26 CO=n23 S=n24 VDD=VDD VSS=VSS
XU21 ad01d0 $PINS A=n123 B=n102 CI=n109 CO=n25 S=n26 VDD=VDD VSS=VSS
XU22 ad01d0 $PINS A=n32 B=n37 CI=n30 CO=n27 S=n28 VDD=VDD VSS=VSS
XU23 ad01d0 $PINS A=n41 B=n34 CI=n39 CO=n29 S=n30 VDD=VDD VSS=VSS
XU24 ad01d0 $PINS A=n124 B=n117 CI=n43 CO=n31 S=n32 VDD=VDD VSS=VSS
XU25 ad01d0 $PINS A=n131 B=n103 CI=n110 CO=n33 S=n34 VDD=VDD VSS=VSS
XU26 ad01d0 $PINS A=n40 B=n47 CI=n38 CO=n35 S=n36 VDD=VDD VSS=VSS
XU27 ad01d0 $PINS A=n44 B=n51 CI=n49 CO=n37 S=n38 VDD=VDD VSS=VSS
XU28 ad01d0 $PINS A=n55 B=n53 CI=n42 CO=n39 S=n40 VDD=VDD VSS=VSS
XU29 ad01d0 $PINS A=n118 B=n125 CI=n132 CO=n41 S=n42 VDD=VDD VSS=VSS
XU30 ad01d0 $PINS A=n139 B=n104 CI=n111 CO=n43 S=n44 VDD=VDD VSS=VSS
XU31 ad01d0 $PINS A=n50 B=n59 CI=n48 CO=n45 S=n46 VDD=VDD VSS=VSS
XU32 ad01d0 $PINS A=n54 B=n52 CI=n61 CO=n47 S=n48 VDD=VDD VSS=VSS
XU33 ad01d0 $PINS A=n56 B=n65 CI=n63 CO=n49 S=n50 VDD=VDD VSS=VSS
XU34 ad01d0 $PINS A=n140 B=n133 CI=n67 CO=n51 S=n52 VDD=VDD VSS=VSS
XU35 ad01d0 $PINS A=n126 B=n119 CI=n147 CO=n53 S=n54 VDD=VDD VSS=VSS
XU36 ah01d1 $PINS A=n105 B=n112 CO=n55 S=n56 VDD=VDD VSS=VSS
XU37 ad01d0 $PINS A=n71 B=n62 CI=n60 CO=n57 S=n58 VDD=VDD VSS=VSS
XU38 ad01d0 $PINS A=n64 B=n66 CI=n73 CO=n59 S=n60 VDD=VDD VSS=VSS
XU39 ad01d0 $PINS A=n77 B=n68 CI=n75 CO=n61 S=n62 VDD=VDD VSS=VSS
XU40 ad01d0 $PINS A=n141 B=n127 CI=n134 CO=n63 S=n64 VDD=VDD VSS=VSS
XU41 ad01d0 $PINS A=n155 B=n120 CI=n148 CO=n65 S=n66 VDD=VDD VSS=VSS
XU42 ah01d1 $PINS A=n106 B=n113 CO=n67 S=n68 VDD=VDD VSS=VSS
XU43 ad01d0 $PINS A=n81 B=n74 CI=n72 CO=n69 S=n70 VDD=VDD VSS=VSS
XU44 ad01d0 $PINS A=n78 B=n83 CI=n76 CO=n71 S=n72 VDD=VDD VSS=VSS
XU45 ad01d0 $PINS A=n142 B=n135 CI=n85 CO=n73 S=n74 VDD=VDD VSS=VSS
XU46 ad01d0 $PINS A=n156 B=n128 CI=n149 CO=n75 S=n76 VDD=VDD VSS=VSS
XU47 ah01d1 $PINS A=n114 B=n121 CO=n77 S=n78 VDD=VDD VSS=VSS
XU48 ad01d0 $PINS A=n89 B=n84 CI=n82 CO=n79 S=n80 VDD=VDD VSS=VSS
XU49 ad01d0 $PINS A=n150 B=n91 CI=n86 CO=n81 S=n82 VDD=VDD VSS=VSS
XU50 ad01d0 $PINS A=n157 B=n136 CI=n143 CO=n83 S=n84 VDD=VDD VSS=VSS
XU51 ah01d1 $PINS A=n122 B=n129 CO=n85 S=n86 VDD=VDD VSS=VSS
XU52 ad01d0 $PINS A=n95 B=n92 CI=n90 CO=n87 S=n88 VDD=VDD VSS=VSS
XU53 ad01d0 $PINS A=n158 B=n144 CI=n151 CO=n89 S=n90 VDD=VDD VSS=VSS
XU54 ah01d1 $PINS A=n130 B=n137 CO=n91 S=n92 VDD=VDD VSS=VSS
XU55 ad01d0 $PINS A=n159 B=n152 CI=n97 CO=n93 S=n94 VDD=VDD VSS=VSS
XU56 ah01d1 $PINS A=n138 B=n145 CO=n95 S=n96 VDD=VDD VSS=VSS
XU57 ah01d1 $PINS A=n153 B=n160 CO=n97 S=n98 VDD=VDD VSS=VSS
XU140 inv0d0 $PINS I=b[4] ZN=n217 VDD=VDD VSS=VSS
XU141 inv0d0 $PINS I=a[1] ZN=n228 VDD=VDD VSS=VSS
XU142 inv0d0 $PINS I=b[2] ZN=n219 VDD=VDD VSS=VSS
XU144 inv0d0 $PINS I=a[2] ZN=n227 VDD=VDD VSS=VSS
XU145 inv0d0 $PINS I=b[3] ZN=n218 VDD=VDD VSS=VSS
XU148 inv0d0 $PINS I=b[0] ZN=n221 VDD=VDD VSS=VSS
XU149 inv0d0 $PINS I=a[4] ZN=n225 VDD=VDD VSS=VSS
XU150 inv0d0 $PINS I=b[6] ZN=n215 VDD=VDD VSS=VSS
XU151 inv0d0 $PINS I=a[3] ZN=n226 VDD=VDD VSS=VSS
XU152 inv0d0 $PINS I=b[5] ZN=n216 VDD=VDD VSS=VSS
XU153 inv0d0 $PINS I=b[7] ZN=n214 VDD=VDD VSS=VSS
XU154 inv0d0 $PINS I=a[6] ZN=n223 VDD=VDD VSS=VSS
XU155 inv0d0 $PINS I=a[7] ZN=n222 VDD=VDD VSS=VSS
XU156 nr02d0 $PINS A1=a[0] A2=n221 ZN=product[0] VDD=VDD VSS=VSS
XU157 nr02d0 $PINS A1=n222 A2=n214 ZN=n99 VDD=VDD VSS=VSS
XU158 nr02d0 $PINS A1=a[0] A2=gre_a_INV_518_3 ZN=n161 VDD=VDD VSS=VSS
XU159 nr02d0 $PINS A1=a[0] A2=n219 ZN=n160 VDD=VDD VSS=VSS
XU160 nr02d0 $PINS A1=a[0] A2=n218 ZN=n159 VDD=VDD VSS=VSS
XU161 nr02d0 $PINS A1=a[0] A2=n217 ZN=n158 VDD=VDD VSS=VSS
XU162 nr02d0 $PINS A1=a[0] A2=n216 ZN=n157 VDD=VDD VSS=VSS
XU163 nr02d0 $PINS A1=a[0] A2=n215 ZN=n156 VDD=VDD VSS=VSS
XU164 nr02d0 $PINS A1=a[0] A2=n214 ZN=n155 VDD=VDD VSS=VSS
XU165 nr02d0 $PINS A1=n221 A2=n228 ZN=n154 VDD=VDD VSS=VSS
XU166 nr02d0 $PINS A1=gre_a_INV_518_3 A2=n228 ZN=n153 VDD=VDD VSS=VSS
XU167 nr02d0 $PINS A1=n219 A2=n228 ZN=n152 VDD=VDD VSS=VSS
XU168 nr02d0 $PINS A1=n218 A2=n228 ZN=n151 VDD=VDD VSS=VSS
XU169 nr02d0 $PINS A1=n217 A2=n228 ZN=n150 VDD=VDD VSS=VSS
XU170 nr02d0 $PINS A1=n216 A2=n228 ZN=n149 VDD=VDD VSS=VSS
XU171 nr02d0 $PINS A1=n215 A2=n228 ZN=n148 VDD=VDD VSS=VSS
XU172 nr02d0 $PINS A1=n214 A2=n228 ZN=n147 VDD=VDD VSS=VSS
XU173 nr02d0 $PINS A1=n221 A2=n227 ZN=n146 VDD=VDD VSS=VSS
XU174 nr02d0 $PINS A1=gre_a_INV_518_3 A2=n227 ZN=n145 VDD=VDD VSS=VSS
XU175 nr02d0 $PINS A1=n219 A2=n227 ZN=n144 VDD=VDD VSS=VSS
XU176 nr02d0 $PINS A1=n218 A2=n227 ZN=n143 VDD=VDD VSS=VSS
XU177 nr02d0 $PINS A1=n217 A2=n227 ZN=n142 VDD=VDD VSS=VSS
XU178 nr02d0 $PINS A1=n216 A2=n227 ZN=n141 VDD=VDD VSS=VSS
XU179 nr02d0 $PINS A1=n215 A2=n227 ZN=n140 VDD=VDD VSS=VSS
XU180 nr02d0 $PINS A1=n214 A2=n227 ZN=n139 VDD=VDD VSS=VSS
XU181 nr02d0 $PINS A1=n221 A2=n226 ZN=n138 VDD=VDD VSS=VSS
XU182 nr02d0 $PINS A1=gre_a_INV_518_3 A2=n226 ZN=n137 VDD=VDD VSS=VSS
XU183 nr02d0 $PINS A1=n219 A2=n226 ZN=n136 VDD=VDD VSS=VSS
XU184 nr02d0 $PINS A1=n218 A2=n226 ZN=n135 VDD=VDD VSS=VSS
XU185 nr02d0 $PINS A1=n217 A2=n226 ZN=n134 VDD=VDD VSS=VSS
XU186 nr02d0 $PINS A1=n216 A2=n226 ZN=n133 VDD=VDD VSS=VSS
XU187 nr02d0 $PINS A1=n215 A2=n226 ZN=n132 VDD=VDD VSS=VSS
XU188 nr02d0 $PINS A1=n214 A2=n226 ZN=n131 VDD=VDD VSS=VSS
XU189 nr02d0 $PINS A1=n221 A2=n225 ZN=n130 VDD=VDD VSS=VSS
XU190 nr02d0 $PINS A1=gre_a_INV_518_3 A2=n225 ZN=n129 VDD=VDD VSS=VSS
XU191 nr02d0 $PINS A1=n219 A2=n225 ZN=n128 VDD=VDD VSS=VSS
XU192 nr02d0 $PINS A1=n218 A2=n225 ZN=n127 VDD=VDD VSS=VSS
XU193 nr02d0 $PINS A1=n217 A2=n225 ZN=n126 VDD=VDD VSS=VSS
XU194 nr02d0 $PINS A1=n216 A2=n225 ZN=n125 VDD=VDD VSS=VSS
XU195 nr02d0 $PINS A1=n215 A2=n225 ZN=n124 VDD=VDD VSS=VSS
XU196 nr02d0 $PINS A1=n214 A2=n225 ZN=n123 VDD=VDD VSS=VSS
XU197 nr02d0 $PINS A1=n221 A2=a[5] ZN=n122 VDD=VDD VSS=VSS
XU198 nr02d0 $PINS A1=gre_a_INV_518_3 A2=a[5] ZN=n121 VDD=VDD VSS=VSS
XU199 nr02d0 $PINS A1=n219 A2=a[5] ZN=n120 VDD=VDD VSS=VSS
XU200 nr02d0 $PINS A1=n218 A2=a[5] ZN=n119 VDD=VDD VSS=VSS
XU201 nr02d0 $PINS A1=n217 A2=a[5] ZN=n118 VDD=VDD VSS=VSS
XU202 nr02d0 $PINS A1=n216 A2=a[5] ZN=n117 VDD=VDD VSS=VSS
XU203 nr02d0 $PINS A1=n215 A2=a[5] ZN=n116 VDD=VDD VSS=VSS
XU204 nr02d0 $PINS A1=n214 A2=a[5] ZN=n115 VDD=VDD VSS=VSS
XU205 nr02d0 $PINS A1=n221 A2=n223 ZN=n114 VDD=VDD VSS=VSS
XU206 nr02d0 $PINS A1=gre_a_INV_518_3 A2=n223 ZN=n113 VDD=VDD VSS=VSS
XU207 nr02d0 $PINS A1=n219 A2=n223 ZN=n112 VDD=VDD VSS=VSS
XU208 nr02d0 $PINS A1=n218 A2=n223 ZN=n111 VDD=VDD VSS=VSS
XU209 nr02d0 $PINS A1=n217 A2=n223 ZN=n110 VDD=VDD VSS=VSS
XU210 nr02d0 $PINS A1=n216 A2=n223 ZN=n109 VDD=VDD VSS=VSS
XU211 nr02d0 $PINS A1=n215 A2=n223 ZN=n108 VDD=VDD VSS=VSS
XU212 nr02d0 $PINS A1=n214 A2=n223 ZN=n107 VDD=VDD VSS=VSS
XU213 nr02d0 $PINS A1=n221 A2=n222 ZN=n106 VDD=VDD VSS=VSS
XU214 nr02d0 $PINS A1=n222 A2=gre_a_INV_518_3 ZN=n105 VDD=VDD VSS=VSS
XU215 nr02d0 $PINS A1=n222 A2=n219 ZN=n104 VDD=VDD VSS=VSS
XU216 nr02d0 $PINS A1=n222 A2=n218 ZN=n103 VDD=VDD VSS=VSS
XU217 nr02d0 $PINS A1=n222 A2=n217 ZN=n102 VDD=VDD VSS=VSS
XU218 nr02d0 $PINS A1=n222 A2=n216 ZN=n101 VDD=VDD VSS=VSS
XU219 nr02d0 $PINS A1=n222 A2=n215 ZN=n100 VDD=VDD VSS=VSS
Xgre_a_INV_518_inst_5797 inv0d0 $PINS I=b[1] ZN=gre_a_INV_518_3 VDD=VDD VSS=VSS
.ENDS

.SUBCKT unpu_pe_12_DW01_add_0_DW01_add_13 A[31] A[30] A[29] A[28] A[27] A[26]
+ A[25] A[24] A[23] A[22] A[21] A[20] A[19] A[18] A[17] A[16] A[15] A[14] A[13]
+ A[12] A[11] A[10] A[9] A[8] A[7] A[6] A[5] A[4] A[3] A[2] A[1] A[0] B[31]
+ B[30] B[29] B[28] B[27] B[26] B[25] B[24] B[23] B[22] B[21] B[20] B[19] B[18]
+ B[17] B[16] B[15] B[14] B[13] B[12] B[11] B[10] B[9] B[8] B[7] B[6] B[5] B[4]
+ B[3] B[2] B[1] B[0] CI SUM[31] SUM[30] SUM[29] SUM[28] SUM[27] SUM[26]
+ SUM[25] SUM[24] SUM[23] SUM[22] SUM[21] SUM[20] SUM[19] SUM[18] SUM[17]
+ SUM[16] SUM[15] SUM[14] SUM[13] SUM[12] SUM[11] SUM[10] SUM[9] SUM[8] SUM[7]
+ SUM[6] SUM[5] SUM[4] SUM[3] SUM[2] SUM[1] SUM[0] CO VDD VSS
*.CONNECT SUM[0] B[0]
XU1_31 ad01d0 $PINS A=A[31] B=B[31] CI=carry[31] S=SUM[31] VDD=VDD VSS=VSS
XU1_13 ad01d0 $PINS A=A[13] B=B[13] CI=carry[13] CO=carry[14] S=SUM[13] VDD=VDD
+ VSS=VSS
XU1_12 ad01d0 $PINS A=A[12] B=B[12] CI=carry[12] CO=carry[13] S=SUM[12] VDD=VDD
+ VSS=VSS
XU1_11 ad01d0 $PINS A=A[11] B=B[11] CI=carry[11] CO=carry[12] S=SUM[11] VDD=VDD
+ VSS=VSS
XU1_10 ad01d0 $PINS A=A[10] B=B[10] CI=carry[10] CO=carry[11] S=SUM[10] VDD=VDD
+ VSS=VSS
XU1_9 ad01d0 $PINS A=A[9] B=B[9] CI=carry[9] CO=carry[10] S=SUM[9] VDD=VDD
+ VSS=VSS
XU1_8 ad01d0 $PINS A=A[8] B=B[8] CI=carry[8] CO=carry[9] S=SUM[8] VDD=VDD
+ VSS=VSS
XU1_7 ad01d0 $PINS A=A[7] B=B[7] CI=carry[7] CO=carry[8] S=SUM[7] VDD=VDD
+ VSS=VSS
XU1_6 ad01d0 $PINS A=A[6] B=B[6] CI=carry[6] CO=carry[7] S=SUM[6] VDD=VDD
+ VSS=VSS
XU1_5 ad01d0 $PINS A=A[5] B=B[5] CI=carry[5] CO=carry[6] S=SUM[5] VDD=VDD
+ VSS=VSS
XU1_4 ad01d0 $PINS A=A[4] B=B[4] CI=carry[4] CO=carry[5] S=SUM[4] VDD=VDD
+ VSS=VSS
XU1_3 ad01d0 $PINS A=A[3] B=B[3] CI=carry[3] CO=carry[4] S=SUM[3] VDD=VDD
+ VSS=VSS
XU1_1 ad01d0 $PINS A=A[1] B=B[1] CI=VSS CO=carry[2] S=SUM[1] VDD=VDD VSS=VSS
XU1_2 ad01d0 $PINS A=A[2] B=B[2] CI=carry[2] CO=carry[3] S=SUM[2] VDD=VDD
+ VSS=VSS
XU1_14 ad01d0 $PINS A=A[14] B=B[14] CI=carry[14] CO=carry[15] S=SUM[14] VDD=VDD
+ VSS=VSS
XU1_15 ad01d0 $PINS A=A[15] B=B[15] CI=carry[15] CO=carry[16] S=SUM[15] VDD=VDD
+ VSS=VSS
XU1_30 ad01d0 $PINS A=A[30] B=B[30] CI=carry[30] CO=carry[31] S=SUM[30] VDD=VDD
+ VSS=VSS
XU1_29 ad01d0 $PINS A=A[29] B=B[29] CI=carry[29] CO=carry[30] S=SUM[29] VDD=VDD
+ VSS=VSS
XU1_28 ad01d0 $PINS A=A[28] B=B[28] CI=carry[28] CO=carry[29] S=SUM[28] VDD=VDD
+ VSS=VSS
XU1_27 ad01d0 $PINS A=A[27] B=B[27] CI=carry[27] CO=carry[28] S=SUM[27] VDD=VDD
+ VSS=VSS
XU1_26 ad01d0 $PINS A=A[26] B=B[26] CI=carry[26] CO=carry[27] S=SUM[26] VDD=VDD
+ VSS=VSS
XU1_25 ad01d0 $PINS A=A[25] B=B[25] CI=carry[25] CO=carry[26] S=SUM[25] VDD=VDD
+ VSS=VSS
XU1_24 ad01d0 $PINS A=A[24] B=B[24] CI=carry[24] CO=carry[25] S=SUM[24] VDD=VDD
+ VSS=VSS
XU1_23 ad01d0 $PINS A=A[23] B=B[23] CI=carry[23] CO=carry[24] S=SUM[23] VDD=VDD
+ VSS=VSS
XU1_22 ad01d0 $PINS A=A[22] B=B[22] CI=carry[22] CO=carry[23] S=SUM[22] VDD=VDD
+ VSS=VSS
XU1_21 ad01d0 $PINS A=A[21] B=B[21] CI=carry[21] CO=carry[22] S=SUM[21] VDD=VDD
+ VSS=VSS
XU1_20 ad01d0 $PINS A=A[20] B=B[20] CI=carry[20] CO=carry[21] S=SUM[20] VDD=VDD
+ VSS=VSS
XU1_19 ad01d0 $PINS A=A[19] B=B[19] CI=carry[19] CO=carry[20] S=SUM[19] VDD=VDD
+ VSS=VSS
XU1_18 ad01d0 $PINS A=A[18] B=B[18] CI=carry[18] CO=carry[19] S=SUM[18] VDD=VDD
+ VSS=VSS
XU1_17 ad01d0 $PINS A=A[17] B=B[17] CI=carry[17] CO=carry[18] S=SUM[17] VDD=VDD
+ VSS=VSS
XU1_16 ad01d0 $PINS A=A[16] B=B[16] CI=carry[16] CO=carry[17] S=SUM[16] VDD=VDD
+ VSS=VSS
.ENDS

.SUBCKT unpu_pe_12 ZCTSNET_7 rst_n array_en weight_load mode_unsigned
+ weight_in[7] weight_in[6] weight_in[5] weight_in[4] weight_in[3] weight_in[2]
+ weight_in[1] weight_in[0] act_in[7] act_in[6] act_in[5] act_in[4] act_in[3]
+ act_in[2] act_in[1] act_in[0] psum_in[31] psum_in[30] psum_in[29] psum_in[28]
+ psum_in[27] psum_in[26] psum_in[25] psum_in[24] psum_in[23] psum_in[22]
+ psum_in[21] psum_in[20] psum_in[19] psum_in[18] psum_in[17] psum_in[16]
+ psum_in[15] psum_in[14] psum_in[13] psum_in[12] psum_in[11] psum_in[10]
+ psum_in[9] psum_in[8] psum_in[7] psum_in[6] psum_in[5] psum_in[4] psum_in[3]
+ psum_in[2] psum_in[1] psum_in[0] act_out[7] act_out[6] act_out[5] act_out[4]
+ act_out[3] act_out[2] act_out[1] act_out[0] psum_out[31] psum_out[30]
+ psum_out[29] psum_out[28] psum_out[27] psum_out[26] psum_out[25] psum_out[24]
+ psum_out[23] psum_out[22] psum_out[21] psum_out[20] psum_out[19] psum_out[18]
+ psum_out[17] psum_out[16] psum_out[15] psum_out[14] psum_out[13] psum_out[12]
+ psum_out[11] psum_out[10] psum_out[9] psum_out[8] psum_out[7] psum_out[6]
+ psum_out[5] psum_out[4] psum_out[3] psum_out[2] psum_out[1] psum_out[0] VDD
+ VSS ZCTSNET_0 HFSNET_1 HFSNET_2 HFSNET_3 HFSNET_4 HFSNET_5 HFSNET_6 ZCTSNET_1
+ ZCTSNET_3
XU2 aor22d1 $PINS A1=N_uc_30 A2=HFSNET_1 B1=mode_unsigned B2=N_uc_14
+ Z=product[9] VDD=VDD VSS=VSS
XU3 aor22d1 $PINS A1=N_uc_29 A2=HFSNET_1 B1=N_uc_13 B2=mode_unsigned
+ Z=product[8] VDD=VDD VSS=VSS
XU5 aor22d1 $PINS A1=N_uc_28 A2=HFSNET_1 B1=N_uc_12 B2=mode_unsigned
+ Z=product[7] VDD=VDD VSS=VSS
XU6 aor22d1 $PINS A1=N_uc_27 A2=HFSNET_1 B1=N_uc_11 B2=mode_unsigned
+ Z=product[6] VDD=VDD VSS=VSS
XU7 aor22d1 $PINS A1=N_uc_26 A2=HFSNET_1 B1=N_uc_10 B2=mode_unsigned
+ Z=product[5] VDD=VDD VSS=VSS
XU8 aor22d1 $PINS A1=N_uc_9 A2=mode_unsigned B1=N_uc_25 B2=HFSNET_1
+ Z=product[4] VDD=VDD VSS=VSS
XU9 aor22d1 $PINS A1=N_uc_8 A2=mode_unsigned B1=N_uc_24 B2=HFSNET_1
+ Z=product[3] VDD=VDD VSS=VSS
XU10 aor22d1 $PINS A1=N_uc_7 A2=mode_unsigned B1=N_uc_23 B2=HFSNET_1
+ Z=product[2] VDD=VDD VSS=VSS
XU11 aor22d1 $PINS A1=N_uc_6 A2=mode_unsigned B1=N_uc_22 B2=HFSNET_1
+ Z=product[1] VDD=VDD VSS=VSS
XU12 oaim21d1 $PINS B1=N_uc_20 B2=mode_unsigned A=n16 ZN=product[15] VDD=VDD
+ VSS=VSS
XU13 aor22d1 $PINS A1=N_uc_35 A2=HFSNET_1 B1=N_uc_19 B2=mode_unsigned
+ Z=product[14] VDD=VDD VSS=VSS
XU14 aor22d1 $PINS A1=N_uc_34 A2=HFSNET_1 B1=N_uc_18 B2=mode_unsigned
+ Z=product[13] VDD=VDD VSS=VSS
XU15 aor22d1 $PINS A1=N_uc_33 A2=HFSNET_1 B1=N_uc_17 B2=mode_unsigned
+ Z=product[12] VDD=VDD VSS=VSS
XU16 aor22d1 $PINS A1=N_uc_32 A2=HFSNET_1 B1=N_uc_16 B2=mode_unsigned
+ Z=product[11] VDD=VDD VSS=VSS
XU17 aor22d1 $PINS A1=N_uc_31 A2=HFSNET_1 B1=N_uc_15 B2=mode_unsigned
+ Z=product[10] VDD=VDD VSS=VSS
XU18 aor22d1 $PINS A1=N_uc_5 A2=mode_unsigned B1=N_uc_21 B2=HFSNET_1
+ Z=product[0] VDD=VDD VSS=VSS
Xadd_42 unpu_pe_12_DW01_add_0_DW01_add_13 $PINS A[31]=psum_in[31]
+ A[30]=psum_in[30] A[29]=psum_in[29] A[28]=psum_in[28] A[27]=psum_in[27]
+ A[26]=psum_in[26] A[25]=psum_in[25] A[24]=psum_in[24] A[23]=psum_in[23]
+ A[22]=psum_in[22] A[21]=psum_in[21] A[20]=psum_in[20] A[19]=psum_in[19]
+ A[18]=psum_in[18] A[17]=psum_in[17] A[16]=psum_in[16] A[15]=psum_in[15]
+ A[14]=psum_in[14] A[13]=psum_in[13] A[12]=psum_in[12] A[11]=psum_in[11]
+ A[10]=psum_in[10] A[9]=psum_in[9] A[8]=psum_in[8] A[7]=psum_in[7]
+ A[6]=psum_in[6] A[5]=psum_in[5] A[4]=psum_in[4] A[3]=psum_in[3] A[2]=psum_in[2]
+ A[1]=psum_in[1] A[0]=psum_in[0] B[31]=n2 B[30]=n2 B[29]=n2 B[28]=n2 B[27]=n2
+ B[26]=n2 B[25]=n2 B[24]=n2 B[23]=n2 B[22]=n2 B[21]=n2 B[20]=n2 B[19]=n2
+ B[18]=n2 B[17]=n2 B[16]=n2 B[15]=product[15] B[14]=product[14]
+ B[13]=product[13] B[12]=product[12] B[11]=product[11] B[10]=product[10]
+ B[9]=product[9] B[8]=product[8] B[7]=product[7] B[6]=product[6] B[5]=product[5]
+ B[4]=product[4] B[3]=product[3] B[2]=product[2] B[1]=product[1] B[0]=product[0]
+ CI=VSS SUM[31]=N_uc_71 SUM[30]=N_uc_70 SUM[29]=N_uc_69 SUM[28]=N_uc_68
+ SUM[27]=N_uc_67 SUM[26]=N_uc_66 SUM[25]=N_uc_65 SUM[24]=N_uc_64 SUM[23]=N_uc_63
+ SUM[22]=N_uc_62 SUM[21]=N_uc_61 SUM[20]=N_uc_60 SUM[19]=N_uc_59 SUM[18]=N_uc_58
+ SUM[17]=N_uc_57 SUM[16]=N_uc_56 SUM[15]=N_uc_55 SUM[14]=N_uc_54 SUM[13]=N_uc_53
+ SUM[12]=N_uc_52 SUM[11]=N_uc_51 SUM[10]=N_uc_50 SUM[9]=N_uc_49 SUM[8]=N_uc_48
+ SUM[7]=N_uc_47 SUM[6]=N_uc_46 SUM[5]=N_uc_45 SUM[4]=N_uc_44 SUM[3]=N_uc_43
+ SUM[2]=N_uc_42 SUM[1]=N_uc_41 SUM[0]=N_uc_40 VDD=VDD VSS=VSS
Xmult_28 unpu_pe_12_DW_mult_uns_0_DW_mult_uns_10 $PINS a[7]=weight_reg[7]
+ a[6]=weight_reg[6] a[5]=gre_a_INV_1429_3 a[4]=weight_reg[4] a[3]=weight_reg[3]
+ a[2]=weight_reg[2] a[1]=weight_reg[1] a[0]=gre_a_INV_1374_3 b[7]=act_in[7]
+ b[6]=act_in[6] b[5]=act_in[5] b[4]=act_in[4] b[3]=act_in[3] b[2]=act_in[2]
+ b[1]=act_in[1] b[0]=act_in[0] product[15]=N_uc_20 product[14]=N_uc_19
+ product[13]=N_uc_18 product[12]=N_uc_17 product[11]=N_uc_16 product[10]=N_uc_15
+ product[9]=N_uc_14 product[8]=N_uc_13 product[7]=N_uc_12 product[6]=N_uc_11
+ product[5]=N_uc_10 product[4]=N_uc_9 product[3]=N_uc_8 product[2]=N_uc_7
+ product[1]=N_uc_6 product[0]=N_uc_5 VDD=VDD VSS=VSS
Xmult_30 unpu_pe_12_DW_mult_tc_0_DW_mult_tc_9 $PINS a[7]=weight_reg[7]
+ a[6]=weight_reg[6] a[5]=weight_reg[5] a[4]=weight_reg[4] a[3]=weight_reg[3]
+ a[2]=weight_reg[2] a[1]=weight_reg[1] a[0]=gre_a_INV_1374_3 b[7]=act_in[7]
+ b[6]=act_in[6] b[5]=act_in[5] b[4]=act_in[4] b[3]=act_in[3] b[2]=act_in[2]
+ b[1]=act_in[1] b[0]=act_in[0] product[15]=N_uc_36 product[14]=N_uc_35
+ product[13]=N_uc_34 product[12]=N_uc_33 product[11]=N_uc_32 product[10]=N_uc_31
+ product[9]=N_uc_30 product[8]=N_uc_29 product[7]=N_uc_28 product[6]=N_uc_27
+ product[5]=N_uc_26 product[4]=N_uc_25 product[3]=N_uc_24 product[2]=N_uc_23
+ product[1]=N_uc_22 product[0]=N_uc_21 VDD=VDD VSS=VSS
+ gre_a_INV_1429_2=gre_a_INV_1429_3
Xact_out_reg_3_ decrq1 $PINS D=copt_net_2095 ENN=HFSNET_2 CP=ZCTSNET_0
+ CDN=rst_n Q=_gOb65_act_out[3] VDD=VDD VSS=VSS
Xact_out_reg_2_ decrq1 $PINS D=copt_net_2029 ENN=HFSNET_2 CP=ZCTSNET_0
+ CDN=HFSNET_6 Q=_gOb67_act_out[2] VDD=VDD VSS=VSS
Xact_out_reg_1_ decrq1 $PINS D=ropt_net_3207 ENN=HFSNET_2 CP=ZCTSNET_0
+ CDN=HFSNET_6 Q=_gOb69_act_out[1] VDD=VDD VSS=VSS
Xact_out_reg_7_ decrq1 $PINS D=copt_net_2062 ENN=HFSNET_2 CP=ZCTSNET_0
+ CDN=HFSNET_6 Q=_gOb57_act_out[7] VDD=VDD VSS=VSS
Xact_out_reg_6_ decrq1 $PINS D=copt_net_2113 ENN=HFSNET_2 CP=ZCTSNET_0
+ CDN=HFSNET_6 Q=_gOb59_act_out[6] VDD=VDD VSS=VSS
Xact_out_reg_5_ decrq1 $PINS D=copt_net_2104 ENN=HFSNET_2 CP=ZCTSNET_0
+ CDN=HFSNET_6 Q=_gOb61_act_out[5] VDD=VDD VSS=VSS
Xact_out_reg_4_ decrq1 $PINS D=copt_net_2068 ENN=HFSNET_2 CP=ZCTSNET_0
+ CDN=HFSNET_6 Q=_gOb63_act_out[4] VDD=VDD VSS=VSS
Xact_out_reg_0_ decrq1 $PINS D=copt_net_2703 ENN=HFSNET_3 CP=ZCTSNET_7
+ CDN=rst_n Q=_gOb71_act_out[0] VDD=VDD VSS=VSS
Xpsum_out_reg_8_ decrq1 $PINS D=N_uc_48 ENN=HFSNET_3 CP=ZCTSNET_1 CDN=rst_n
+ Q=psum_out[8] VDD=VDD VSS=VSS
Xpsum_out_reg_7_ decrq1 $PINS D=N_uc_47 ENN=HFSNET_3 CP=ZCTSNET_1 CDN=rst_n
+ Q=psum_out[7] VDD=VDD VSS=VSS
Xpsum_out_reg_6_ decrq1 $PINS D=N_uc_46 ENN=HFSNET_3 CP=ZCTSNET_1 CDN=rst_n
+ Q=psum_out[6] VDD=VDD VSS=VSS
Xpsum_out_reg_5_ decrq1 $PINS D=N_uc_45 ENN=HFSNET_3 CP=ZCTSNET_1 CDN=rst_n
+ Q=psum_out[5] VDD=VDD VSS=VSS
Xpsum_out_reg_4_ decrq1 $PINS D=N_uc_44 ENN=HFSNET_3 CP=ZCTSNET_1 CDN=rst_n
+ Q=psum_out[4] VDD=VDD VSS=VSS
Xpsum_out_reg_3_ decrq1 $PINS D=N_uc_43 ENN=HFSNET_3 CP=ZCTSNET_1 CDN=rst_n
+ Q=psum_out[3] VDD=VDD VSS=VSS
Xpsum_out_reg_2_ decrq1 $PINS D=N_uc_42 ENN=HFSNET_3 CP=ZCTSNET_1 CDN=rst_n
+ Q=psum_out[2] VDD=VDD VSS=VSS
Xpsum_out_reg_1_ decrq1 $PINS D=N_uc_41 ENN=HFSNET_3 CP=ZCTSNET_1 CDN=rst_n
+ Q=psum_out[1] VDD=VDD VSS=VSS
Xpsum_out_reg_0_ decrq1 $PINS D=N_uc_40 ENN=HFSNET_3 CP=ZCTSNET_7 CDN=rst_n
+ Q=psum_out[0] VDD=VDD VSS=VSS
Xpsum_out_reg_9_ decrq1 $PINS D=N_uc_49 ENN=HFSNET_3 CP=ZCTSNET_1 CDN=rst_n
+ Q=psum_out[9] VDD=VDD VSS=VSS
Xpsum_out_reg_10_ decrq1 $PINS D=N_uc_50 ENN=HFSNET_3 CP=ZCTSNET_1 CDN=rst_n
+ Q=psum_out[10] VDD=VDD VSS=VSS
Xpsum_out_reg_11_ decrq1 $PINS D=N_uc_51 ENN=HFSNET_3 CP=ZCTSNET_1 CDN=rst_n
+ Q=psum_out[11] VDD=VDD VSS=VSS
Xweight_reg_reg_7_ decrq1 $PINS D=weight_in[7] ENN=n15 CP=ZCTSNET_3
+ CDN=HFSNET_6 Q=weight_reg[7] VDD=VDD VSS=VSS
Xweight_reg_reg_6_ decrq1 $PINS D=weight_in[6] ENN=n15 CP=ZCTSNET_3
+ CDN=HFSNET_6 Q=weight_reg[6] VDD=VDD VSS=VSS
Xweight_reg_reg_5_ decrq1 $PINS D=weight_in[5] ENN=n15 CP=ZCTSNET_0
+ CDN=HFSNET_6 Q=weight_reg[5] VDD=VDD VSS=VSS
Xweight_reg_reg_4_ decrq1 $PINS D=ropt_net_3208 ENN=n15 CP=ZCTSNET_0 CDN=rst_n
+ Q=weight_reg[4] VDD=VDD VSS=VSS
Xweight_reg_reg_3_ decrq1 $PINS D=weight_in[3] ENN=n15 CP=ZCTSNET_3 CDN=rst_n
+ Q=weight_reg[3] VDD=VDD VSS=VSS
Xweight_reg_reg_2_ decrq1 $PINS D=weight_in[2] ENN=n15 CP=ZCTSNET_0 CDN=rst_n
+ Q=weight_reg[2] VDD=VDD VSS=VSS
Xweight_reg_reg_1_ decrq1 $PINS D=weight_in[1] ENN=n15 CP=ZCTSNET_0 CDN=rst_n
+ Q=weight_reg[1] VDD=VDD VSS=VSS
Xweight_reg_reg_0_ decrq1 $PINS D=weight_in[0] ENN=n15 CP=ZCTSNET_0 CDN=rst_n
+ Q=weight_reg[0] VDD=VDD VSS=VSS
Xpsum_out_reg_12_ decrq1 $PINS D=N_uc_52 ENN=HFSNET_3 CP=ZCTSNET_1 CDN=rst_n
+ Q=psum_out[12] VDD=VDD VSS=VSS
Xpsum_out_reg_13_ decrq1 $PINS D=N_uc_53 ENN=HFSNET_3 CP=ZCTSNET_7 CDN=rst_n
+ Q=psum_out[13] VDD=VDD VSS=VSS
Xpsum_out_reg_14_ decrq1 $PINS D=N_uc_54 ENN=HFSNET_3 CP=ZCTSNET_7 CDN=rst_n
+ Q=psum_out[14] VDD=VDD VSS=VSS
Xpsum_out_reg_15_ decrq1 $PINS D=N_uc_55 ENN=HFSNET_3 CP=ZCTSNET_7 CDN=rst_n
+ Q=psum_out[15] VDD=VDD VSS=VSS
Xpsum_out_reg_31_ decrq1 $PINS D=N_uc_71 ENN=HFSNET_3 CP=ZCTSNET_1 CDN=rst_n
+ Q=psum_out[31] VDD=VDD VSS=VSS
Xpsum_out_reg_30_ decrq1 $PINS D=N_uc_70 ENN=HFSNET_3 CP=ZCTSNET_1 CDN=rst_n
+ Q=psum_out[30] VDD=VDD VSS=VSS
Xpsum_out_reg_29_ decrq1 $PINS D=N_uc_69 ENN=HFSNET_3 CP=ZCTSNET_7 CDN=rst_n
+ Q=psum_out[29] VDD=VDD VSS=VSS
Xpsum_out_reg_28_ decrq1 $PINS D=N_uc_68 ENN=HFSNET_3 CP=ZCTSNET_0 CDN=rst_n
+ Q=psum_out[28] VDD=VDD VSS=VSS
Xpsum_out_reg_27_ decrq1 $PINS D=N_uc_67 ENN=array_en CP=ZCTSNET_7 CDN=HFSNET_5
+ Q=psum_out[27] VDD=VDD VSS=VSS
Xpsum_out_reg_26_ decrq1 $PINS D=N_uc_66 ENN=array_en CP=ZCTSNET_7 CDN=HFSNET_5
+ Q=psum_out[26] VDD=VDD VSS=VSS
Xpsum_out_reg_25_ decrq1 $PINS D=N_uc_65 ENN=array_en CP=ZCTSNET_3 CDN=HFSNET_5
+ Q=psum_out[25] VDD=VDD VSS=VSS
Xpsum_out_reg_24_ decrq1 $PINS D=N_uc_64 ENN=array_en CP=ZCTSNET_3 CDN=HFSNET_5
+ Q=psum_out[24] VDD=VDD VSS=VSS
Xpsum_out_reg_23_ decrq1 $PINS D=N_uc_63 ENN=array_en CP=ZCTSNET_3 CDN=HFSNET_5
+ Q=psum_out[23] VDD=VDD VSS=VSS
Xpsum_out_reg_22_ decrq1 $PINS D=N_uc_62 ENN=array_en CP=ZCTSNET_7 CDN=HFSNET_5
+ Q=psum_out[22] VDD=VDD VSS=VSS
Xpsum_out_reg_21_ decrq1 $PINS D=N_uc_61 ENN=array_en CP=ZCTSNET_3 CDN=HFSNET_5
+ Q=psum_out[21] VDD=VDD VSS=VSS
Xpsum_out_reg_20_ decrq1 $PINS D=N_uc_60 ENN=array_en CP=ZCTSNET_7 CDN=HFSNET_5
+ Q=psum_out[20] VDD=VDD VSS=VSS
Xpsum_out_reg_19_ decrq1 $PINS D=N_uc_59 ENN=HFSNET_2 CP=ZCTSNET_0 CDN=rst_n
+ Q=psum_out[19] VDD=VDD VSS=VSS
Xpsum_out_reg_18_ decrq1 $PINS D=N_uc_58 ENN=HFSNET_3 CP=ZCTSNET_7 CDN=rst_n
+ Q=psum_out[18] VDD=VDD VSS=VSS
Xpsum_out_reg_17_ decrq1 $PINS D=N_uc_57 ENN=HFSNET_3 CP=ZCTSNET_7 CDN=rst_n
+ Q=psum_out[17] VDD=VDD VSS=VSS
Xpsum_out_reg_16_ decrq1 $PINS D=N_uc_56 ENN=HFSNET_3 CP=ZCTSNET_7 CDN=rst_n
+ Q=psum_out[16] VDD=VDD VSS=VSS
XU19 inv0d2 $PINS I=n16 ZN=n2 VDD=VDD VSS=VSS
Xgre_a_INV_1374_inst_5804 inv0d1 $PINS I=weight_reg[0] ZN=gre_a_INV_1374_3
+ VDD=VDD VSS=VSS
Xcopt_h_inst_4862 buffd3 $PINS I=act_in[2] Z=copt_net_2029 VDD=VDD VSS=VSS
Xcopt_h_inst_4895 buffd1 $PINS I=act_in[7] Z=copt_net_2062 VDD=VDD VSS=VSS
XU24 nd02d1 $PINS A1=weight_load A2=HFSNET_4 ZN=n15 VDD=VDD VSS=VSS
Xcopt_h_inst_4901 buffd1 $PINS I=act_in[4] Z=copt_net_2068 VDD=VDD VSS=VSS
Xcopt_h_inst_4928 buffd1 $PINS I=act_in[3] Z=copt_net_2095 VDD=VDD VSS=VSS
Xcopt_h_inst_4937 buffd1 $PINS I=act_in[5] Z=copt_net_2104 VDD=VDD VSS=VSS
Xcopt_h_inst_4946 buffd1 $PINS I=act_in[6] Z=copt_net_2113 VDD=VDD VSS=VSS
XU29 nd02d1 $PINS A1=N_uc_36 A2=HFSNET_1 ZN=n16 VDD=VDD VSS=VSS
Xcopt_h_inst_5536 buffd1 $PINS I=act_in[0] Z=copt_net_2703 VDD=VDD VSS=VSS
Xgre_a_INV_1429_inst_5832 inv0d1 $PINS I=weight_reg[5] ZN=gre_a_INV_1429_3
+ VDD=VDD VSS=VSS
Xropt_h_inst_5863 dl01d1 $PINS I=act_in[1] Z=ropt_net_3207 VDD=VDD VSS=VSS
Xropt_h_inst_5864 buffd1 $PINS I=ropt_net_3209 Z=ropt_net_3208 VDD=VDD VSS=VSS
Xropt_h_inst_5865 buffd1 $PINS I=weight_in[4] Z=ropt_net_3209 VDD=VDD VSS=VSS
.ENDS

.SUBCKT unpu_pe_13_DW_mult_tc_0_DW_mult_tc_10 a[7] a[6] a[5] a[4] a[3] a[2]
+ a[1] a[0] b[7] b[6] b[5] b[4] b[3] b[2] b[1] b[0] product[15] product[14]
+ product[13] product[12] product[11] product[10] product[9] product[8]
+ product[7] product[6] product[5] product[4] product[3] product[2] product[1]
+ product[0] VDD VSS
XU2 ad01d0 $PINS A=n196 B=n61 CI=n2 CO=n1 S=product[14] VDD=VDD VSS=VSS
XU3 ad01d0 $PINS A=n17 B=n16 CI=n3 CO=n2 S=product[13] VDD=VDD VSS=VSS
XU4 ad01d0 $PINS A=n18 B=n19 CI=n4 CO=n3 S=product[12] VDD=VDD VSS=VSS
XU5 ad01d0 $PINS A=n20 B=n23 CI=n5 CO=n4 S=product[11] VDD=VDD VSS=VSS
XU6 ad01d0 $PINS A=n27 B=n24 CI=n6 CO=n5 S=product[10] VDD=VDD VSS=VSS
XU7 ad01d0 $PINS A=n33 B=n28 CI=n7 CO=n6 S=product[9] VDD=VDD VSS=VSS
XU8 ad01d0 $PINS A=n39 B=n34 CI=n8 CO=n7 S=product[8] VDD=VDD VSS=VSS
XU9 ad01d0 $PINS A=n45 B=n40 CI=n9 CO=n8 S=product[7] VDD=VDD VSS=VSS
XU10 ad01d0 $PINS A=n49 B=n46 CI=n10 CO=n9 S=product[6] VDD=VDD VSS=VSS
XU11 ad01d0 $PINS A=n53 B=n50 CI=n11 CO=n10 S=product[5] VDD=VDD VSS=VSS
XU12 ad01d0 $PINS A=n55 B=n54 CI=n12 CO=n11 S=product[4] VDD=VDD VSS=VSS
XU13 ad01d0 $PINS A=n59 B=n56 CI=n13 CO=n12 S=product[3] VDD=VDD VSS=VSS
XU14 ad01d0 $PINS A=n84 B=n91 CI=n14 CO=n13 S=product[2] VDD=VDD VSS=VSS
XctmTdsLR_1_2921 an02d1 $PINS A1=n58 A2=n75 Z=n51 VDD=VDD VSS=VSS
XU17 ad01d0 $PINS A=n195 B=n62 CI=n69 CO=n17 S=n18 VDD=VDD VSS=VSS
XU18 ad01d0 $PINS A=n63 B=n25 CI=n22 CO=n19 S=n20 VDD=VDD VSS=VSS
XU20 ad01d0 $PINS A=n64 B=n26 CI=n29 CO=n23 S=n24 VDD=VDD VSS=VSS
XU21 ad01d0 $PINS A=n194 B=n70 CI=n77 CO=n25 S=n26 VDD=VDD VSS=VSS
XU22 ad01d0 $PINS A=n32 B=n35 CI=n30 CO=n27 S=n28 VDD=VDD VSS=VSS
XU23 ad01d0 $PINS A=n71 B=n65 CI=n37 CO=n29 S=n30 VDD=VDD VSS=VSS
XU25 ad01d0 $PINS A=n38 B=n41 CI=n36 CO=n33 S=n34 VDD=VDD VSS=VSS
XU26 ad01d0 $PINS A=n72 B=n85 CI=n43 CO=n35 S=n36 VDD=VDD VSS=VSS
XU29 ad01d0 $PINS A=n44 B=n47 CI=n42 CO=n39 S=n40 VDD=VDD VSS=VSS
XU30 ad01d0 $PINS A=n86 B=n73 CI=n79 CO=n41 S=n42 VDD=VDD VSS=VSS
XU32 ad01d0 $PINS A=n74 B=n51 CI=n48 CO=n45 S=n46 VDD=VDD VSS=VSS
XU33 ad01d0 $PINS A=n68 B=n87 CI=n80 CO=n47 S=n48 VDD=VDD VSS=VSS
XU34 ad01d0 $PINS A=n88 B=n81 CI=n52 CO=n49 S=n50 VDD=VDD VSS=VSS
XU36 ad01d0 $PINS A=n76 B=n89 CI=n82 CO=n53 S=n54 VDD=VDD VSS=VSS
XU37 ah01d1 $PINS A=n83 B=n90 CO=n55 S=n56 VDD=VDD VSS=VSS
XU145 oai21d1 $PINS B1=n203 B2=n249 A=n222 ZN=n77 VDD=VDD VSS=VSS
XU146 oai21d1 $PINS B1=n201 B2=n250 A=n232 ZN=n69 VDD=VDD VSS=VSS
XU147 oai21d1 $PINS B1=n199 B2=n251 A=n242 ZN=n61 VDD=VDD VSS=VSS
XU148 inv0d0 $PINS I=n16 ZN=n196 VDD=VDD VSS=VSS
XU149 inv0d0 $PINS I=n223 ZN=n201 VDD=VDD VSS=VSS
XU150 inv0d0 $PINS I=n214 ZN=n203 VDD=VDD VSS=VSS
XU151 inv0d0 $PINS I=n233 ZN=n199 VDD=VDD VSS=VSS
XU152 inv0d0 $PINS I=n32 ZN=n194 VDD=VDD VSS=VSS
XU153 inv0d0 $PINS I=n22 ZN=n195 VDD=VDD VSS=VSS
XU154 nd02d1 $PINS A1=n214 A2=n249 ZN=n216 VDD=VDD VSS=VSS
XU155 xr02d1 $PINS A1=a[2] A2=n204 Z=n214 VDD=VDD VSS=VSS
XU156 inv0d1 $PINS I=a[1] ZN=n204 VDD=VDD VSS=VSS
XU157 nd02d1 $PINS A1=n223 A2=n250 ZN=n225 VDD=VDD VSS=VSS
XU158 xr02d1 $PINS A1=a[4] A2=n202 Z=n223 VDD=VDD VSS=VSS
XU159 inv0d1 $PINS I=a[3] ZN=n202 VDD=VDD VSS=VSS
XU160 nd02d1 $PINS A1=a[1] A2=a[0] ZN=n206 VDD=VDD VSS=VSS
XU162 xr02d1 $PINS A1=a[6] A2=n200 Z=n233 VDD=VDD VSS=VSS
XU163 inv0d1 $PINS I=a[5] ZN=n200 VDD=VDD VSS=VSS
XU164 inv0d0 $PINS I=b[0] ZN=n197 VDD=VDD VSS=VSS
XU165 nd02d1 $PINS A1=n233 A2=n251 ZN=n235 VDD=VDD VSS=VSS
XU166 inv0d1 $PINS I=a[7] ZN=n198 VDD=VDD VSS=VSS
XU167 inv0d0 $PINS I=n1 ZN=product[15] VDD=VDD VSS=VSS
XU168 nr02d0 $PINS A1=a[0] A2=n197 ZN=product[0] VDD=VDD VSS=VSS
XU169 oai22d1 $PINS A1=b[0] A2=n206 B1=n207 B2=a[0] ZN=n92 VDD=VDD VSS=VSS
XU170 oai22d1 $PINS A1=n207 A2=n206 B1=n208 B2=a[0] ZN=n91 VDD=VDD VSS=VSS
XU171 xr02d1 $PINS A1=b[1] A2=n204 Z=n207 VDD=VDD VSS=VSS
XU172 oai22d1 $PINS A1=n208 A2=n206 B1=n209 B2=a[0] ZN=n90 VDD=VDD VSS=VSS
XU173 xr02d1 $PINS A1=b[2] A2=n204 Z=n208 VDD=VDD VSS=VSS
XU174 oai22d1 $PINS A1=n209 A2=n206 B1=n210 B2=a[0] ZN=n89 VDD=VDD VSS=VSS
XU175 xr02d1 $PINS A1=b[3] A2=n204 Z=n209 VDD=VDD VSS=VSS
XU176 oai22d1 $PINS A1=n210 A2=n206 B1=n211 B2=a[0] ZN=n88 VDD=VDD VSS=VSS
XU177 xr02d1 $PINS A1=b[4] A2=n204 Z=n210 VDD=VDD VSS=VSS
XU178 oai22d1 $PINS A1=n211 A2=n206 B1=n212 B2=a[0] ZN=n87 VDD=VDD VSS=VSS
XU179 xr02d1 $PINS A1=b[5] A2=n204 Z=n211 VDD=VDD VSS=VSS
XU180 oai22d1 $PINS A1=n212 A2=n206 B1=n213 B2=a[0] ZN=n86 VDD=VDD VSS=VSS
XU181 xr02d1 $PINS A1=b[6] A2=n204 Z=n212 VDD=VDD VSS=VSS
XU182 aor21d1 $PINS B1=a[0] B2=n206 A=n213 Z=n85 VDD=VDD VSS=VSS
XU183 xr02d1 $PINS A1=b[7] A2=n204 Z=n213 VDD=VDD VSS=VSS
XU184 nr02d0 $PINS A1=n214 A2=n197 ZN=n84 VDD=VDD VSS=VSS
XU185 oai22d1 $PINS A1=n216 A2=n215 B1=n214 B2=n217 ZN=n83 VDD=VDD VSS=VSS
XctmTdsLR_1_2915 an02d1 $PINS A1=n92 A2=n60 Z=n14 VDD=VDD VSS=VSS
XU187 oai22d1 $PINS A1=n217 A2=n216 B1=n214 B2=n218 ZN=n82 VDD=VDD VSS=VSS
XU188 xr02d1 $PINS A1=b[1] A2=n202 Z=n217 VDD=VDD VSS=VSS
XU189 oai22d1 $PINS A1=n218 A2=n216 B1=n214 B2=n219 ZN=n81 VDD=VDD VSS=VSS
XU190 xr02d1 $PINS A1=b[2] A2=n202 Z=n218 VDD=VDD VSS=VSS
XU191 oai22d1 $PINS A1=n219 A2=n216 B1=n214 B2=n220 ZN=n80 VDD=VDD VSS=VSS
XU192 xr02d1 $PINS A1=b[3] A2=n202 Z=n219 VDD=VDD VSS=VSS
XU193 oai22d1 $PINS A1=n220 A2=n216 B1=n214 B2=n221 ZN=n79 VDD=VDD VSS=VSS
XU194 xr02d1 $PINS A1=b[4] A2=n202 Z=n220 VDD=VDD VSS=VSS
XU195 nr02d0 $PINS A1=n223 A2=n197 ZN=n76 VDD=VDD VSS=VSS
XU196 oai22d1 $PINS A1=n225 A2=n224 B1=n223 B2=n226 ZN=n75 VDD=VDD VSS=VSS
XctmTdsLR_2_2916 aoim21d1 $PINS B1=n92 B2=n60 A=n14 ZN=product[1] VDD=VDD
+ VSS=VSS
XU198 oai22d1 $PINS A1=n226 A2=n225 B1=n223 B2=n227 ZN=n74 VDD=VDD VSS=VSS
XU199 xr02d1 $PINS A1=b[1] A2=n200 Z=n226 VDD=VDD VSS=VSS
XU200 oai22d1 $PINS A1=n227 A2=n225 B1=n223 B2=n228 ZN=n73 VDD=VDD VSS=VSS
XU201 xr02d1 $PINS A1=b[2] A2=n200 Z=n227 VDD=VDD VSS=VSS
XU202 oai22d1 $PINS A1=n228 A2=n225 B1=n223 B2=n229 ZN=n72 VDD=VDD VSS=VSS
XU203 xr02d1 $PINS A1=b[3] A2=n200 Z=n228 VDD=VDD VSS=VSS
XU204 oai22d1 $PINS A1=n229 A2=n225 B1=n223 B2=n230 ZN=n71 VDD=VDD VSS=VSS
XU205 xr02d1 $PINS A1=b[4] A2=n200 Z=n229 VDD=VDD VSS=VSS
XU206 oai22d1 $PINS A1=n230 A2=n225 B1=n223 B2=n231 ZN=n70 VDD=VDD VSS=VSS
XU207 xr02d1 $PINS A1=b[5] A2=n200 Z=n230 VDD=VDD VSS=VSS
XU208 nr02d0 $PINS A1=n233 A2=n197 ZN=n68 VDD=VDD VSS=VSS
XU209 oai22d1 $PINS A1=n235 A2=n234 B1=n233 B2=n236 ZN=n67 VDD=VDD VSS=VSS
XctmTdsLR_2_2922 aoim21d1 $PINS B1=n58 B2=n75 A=n51 ZN=n52 VDD=VDD VSS=VSS
XU211 oai22d1 $PINS A1=n237 A2=n235 B1=n233 B2=n238 ZN=n65 VDD=VDD VSS=VSS
XU212 oai22d1 $PINS A1=n238 A2=n235 B1=n233 B2=n239 ZN=n64 VDD=VDD VSS=VSS
XU213 xr02d1 $PINS A1=b[3] A2=n198 Z=n238 VDD=VDD VSS=VSS
XU214 oai22d1 $PINS A1=n239 A2=n235 B1=n233 B2=n240 ZN=n63 VDD=VDD VSS=VSS
XU215 xr02d1 $PINS A1=b[4] A2=n198 Z=n239 VDD=VDD VSS=VSS
XU216 oai22d1 $PINS A1=n240 A2=n235 B1=n233 B2=n241 ZN=n62 VDD=VDD VSS=VSS
XU217 xr02d1 $PINS A1=b[5] A2=n198 Z=n240 VDD=VDD VSS=VSS
XU218 oai21d1 $PINS B1=n204 B2=b[0] A=n206 ZN=n60 VDD=VDD VSS=VSS
XU219 oai21d1 $PINS B1=n202 B2=n216 A=n243 ZN=n59 VDD=VDD VSS=VSS
XU220 nd03d0 $PINS A1=n203 A2=n197 A3=a[3] ZN=n243 VDD=VDD VSS=VSS
XU221 oai21d1 $PINS B1=n200 B2=n225 A=n244 ZN=n58 VDD=VDD VSS=VSS
XU222 nd03d0 $PINS A1=n201 A2=n197 A3=a[5] ZN=n244 VDD=VDD VSS=VSS
XU223 oai21d1 $PINS B1=n198 B2=n235 A=n245 ZN=n57 VDD=VDD VSS=VSS
XU224 nd03d0 $PINS A1=n199 A2=n197 A3=a[7] ZN=n245 VDD=VDD VSS=VSS
XU225 xn02d1 $PINS A1=n246 A2=n247 ZN=n38 VDD=VDD VSS=VSS
XU226 or02d0 $PINS A1=n247 A2=n246 Z=n37 VDD=VDD VSS=VSS
XU227 oai22d1 $PINS A1=n236 A2=n235 B1=n233 B2=n237 ZN=n246 VDD=VDD VSS=VSS
XU228 xr02d1 $PINS A1=b[2] A2=n198 Z=n237 VDD=VDD VSS=VSS
XU229 xr02d1 $PINS A1=b[1] A2=n198 Z=n236 VDD=VDD VSS=VSS
XU230 oai22d1 $PINS A1=n221 A2=n216 B1=n214 B2=n248 ZN=n247 VDD=VDD VSS=VSS
XU231 xr02d1 $PINS A1=b[5] A2=n202 Z=n221 VDD=VDD VSS=VSS
XU232 aoim22d1 $PINS A1=n203 A2=n222 B1=n248 B2=n216 Z=n32 VDD=VDD VSS=VSS
XU233 xr02d1 $PINS A1=a[3] A2=a[2] Z=n249 VDD=VDD VSS=VSS
XU234 xr02d1 $PINS A1=b[6] A2=n202 Z=n248 VDD=VDD VSS=VSS
XU235 xr02d1 $PINS A1=b[7] A2=a[3] Z=n222 VDD=VDD VSS=VSS
XU236 aoim22d1 $PINS A1=n201 A2=n232 B1=n231 B2=n225 Z=n22 VDD=VDD VSS=VSS
XU237 xr02d1 $PINS A1=a[5] A2=a[4] Z=n250 VDD=VDD VSS=VSS
XU238 xr02d1 $PINS A1=b[6] A2=n200 Z=n231 VDD=VDD VSS=VSS
XU239 xr02d1 $PINS A1=b[7] A2=a[5] Z=n232 VDD=VDD VSS=VSS
XU240 aoim22d1 $PINS A1=n199 A2=n242 B1=n241 B2=n235 Z=n16 VDD=VDD VSS=VSS
XU241 xr02d1 $PINS A1=a[7] A2=a[6] Z=n251 VDD=VDD VSS=VSS
XU242 xr02d1 $PINS A1=b[6] A2=n198 Z=n241 VDD=VDD VSS=VSS
XU243 xr02d1 $PINS A1=b[7] A2=a[7] Z=n242 VDD=VDD VSS=VSS
XctmTdsLR_1_1300 aoim22d1 $PINS A1=n202 A2=b[0] B1=n202 B2=b[0] Z=n215 VDD=VDD
+ VSS=VSS
XctmTdsLR_1_1301 aoim22d1 $PINS A1=n200 A2=b[0] B1=n200 B2=b[0] Z=n224 VDD=VDD
+ VSS=VSS
XctmTdsLR_1_1302 aoim22d1 $PINS A1=n198 A2=b[0] B1=n198 B2=b[0] Z=n234 VDD=VDD
+ VSS=VSS
XctmTdsLR_1_2923 an02d1 $PINS A1=n57 A2=n67 Z=n43 VDD=VDD VSS=VSS
XctmTdsLR_2_2924 aoim21d1 $PINS B1=n57 B2=n67 A=n43 ZN=n44 VDD=VDD VSS=VSS
.ENDS

.SUBCKT unpu_pe_13_DW_mult_uns_0_DW_mult_uns_11 a[7] a[6] a[5] a[4] a[3] a[2]
+ a[1] a[0] b[7] b[6] b[5] b[4] b[3] b[2] b[1] b[0] product[15] product[14]
+ product[13] product[12] product[11] product[10] product[9] product[8]
+ product[7] product[6] product[5] product[4] product[3] product[2] product[1]
+ product[0] VDD VSS
XU2 ad01d0 $PINS A=n99 B=n15 CI=n2 CO=product[15] S=product[14] VDD=VDD VSS=VSS
XU3 ad01d0 $PINS A=n16 B=n17 CI=n3 CO=n2 S=product[13] VDD=VDD VSS=VSS
XU4 ad01d0 $PINS A=n18 B=n21 CI=n4 CO=n3 S=product[12] VDD=VDD VSS=VSS
XU5 ad01d0 $PINS A=n27 B=n22 CI=n5 CO=n4 S=product[11] VDD=VDD VSS=VSS
XU6 ad01d0 $PINS A=n35 B=n28 CI=n6 CO=n5 S=product[10] VDD=VDD VSS=VSS
XU7 ad01d0 $PINS A=n45 B=n36 CI=n7 CO=n6 S=product[9] VDD=VDD VSS=VSS
XU8 ad01d0 $PINS A=n57 B=n46 CI=n8 CO=n7 S=product[8] VDD=VDD VSS=VSS
XU9 ad01d0 $PINS A=n69 B=n58 CI=n9 CO=n8 S=product[7] VDD=VDD VSS=VSS
XU10 ad01d0 $PINS A=n79 B=n70 CI=n10 CO=n9 S=product[6] VDD=VDD VSS=VSS
XU11 ad01d0 $PINS A=n87 B=n80 CI=n11 CO=n10 S=product[5] VDD=VDD VSS=VSS
XU12 ad01d0 $PINS A=n93 B=n88 CI=n12 CO=n11 S=product[4] VDD=VDD VSS=VSS
XU13 ad01d0 $PINS A=n96 B=n13 CI=n94 CO=n12 S=product[3] VDD=VDD VSS=VSS
XU14 ad01d0 $PINS A=n146 B=n14 CI=n98 CO=n13 S=product[2] VDD=VDD VSS=VSS
XU15 ah01d1 $PINS A=n161 B=n154 CO=n14 S=product[1] VDD=VDD VSS=VSS
XU16 ad01d0 $PINS A=n107 B=n100 CI=n19 CO=n15 S=n16 VDD=VDD VSS=VSS
XU17 ad01d0 $PINS A=n25 B=n20 CI=n23 CO=n17 S=n18 VDD=VDD VSS=VSS
XU18 ad01d0 $PINS A=n115 B=n101 CI=n108 CO=n19 S=n20 VDD=VDD VSS=VSS
XU19 ad01d0 $PINS A=n31 B=n24 CI=n29 CO=n21 S=n22 VDD=VDD VSS=VSS
XU20 ad01d0 $PINS A=n116 B=n33 CI=n26 CO=n23 S=n24 VDD=VDD VSS=VSS
XU21 ad01d0 $PINS A=n123 B=n102 CI=n109 CO=n25 S=n26 VDD=VDD VSS=VSS
XU22 ad01d0 $PINS A=n32 B=n37 CI=n30 CO=n27 S=n28 VDD=VDD VSS=VSS
XU23 ad01d0 $PINS A=n41 B=n34 CI=n39 CO=n29 S=n30 VDD=VDD VSS=VSS
XU24 ad01d0 $PINS A=n124 B=n117 CI=n43 CO=n31 S=n32 VDD=VDD VSS=VSS
XU25 ad01d0 $PINS A=n131 B=n103 CI=n110 CO=n33 S=n34 VDD=VDD VSS=VSS
XU26 ad01d0 $PINS A=n40 B=n47 CI=n38 CO=n35 S=n36 VDD=VDD VSS=VSS
XU27 ad01d0 $PINS A=n44 B=n51 CI=n49 CO=n37 S=n38 VDD=VDD VSS=VSS
XU28 ad01d0 $PINS A=n55 B=n53 CI=n42 CO=n39 S=n40 VDD=VDD VSS=VSS
XU29 ad01d0 $PINS A=n118 B=n125 CI=n132 CO=n41 S=n42 VDD=VDD VSS=VSS
XU30 ad01d0 $PINS A=n139 B=n104 CI=n111 CO=n43 S=n44 VDD=VDD VSS=VSS
XU31 ad01d0 $PINS A=n50 B=n59 CI=n48 CO=n45 S=n46 VDD=VDD VSS=VSS
XU32 ad01d0 $PINS A=n54 B=n52 CI=n61 CO=n47 S=n48 VDD=VDD VSS=VSS
XU33 ad01d0 $PINS A=n56 B=n65 CI=n63 CO=n49 S=n50 VDD=VDD VSS=VSS
XU34 ad01d0 $PINS A=n140 B=n133 CI=n67 CO=n51 S=n52 VDD=VDD VSS=VSS
XU35 ad01d0 $PINS A=n126 B=n119 CI=n147 CO=n53 S=n54 VDD=VDD VSS=VSS
XU36 ah01d1 $PINS A=n105 B=n112 CO=n55 S=n56 VDD=VDD VSS=VSS
XU37 ad01d0 $PINS A=n71 B=n62 CI=n60 CO=n57 S=n58 VDD=VDD VSS=VSS
XU38 ad01d0 $PINS A=n64 B=n66 CI=n73 CO=n59 S=n60 VDD=VDD VSS=VSS
XU39 ad01d0 $PINS A=n77 B=n68 CI=n75 CO=n61 S=n62 VDD=VDD VSS=VSS
XU40 ad01d0 $PINS A=n141 B=n127 CI=n134 CO=n63 S=n64 VDD=VDD VSS=VSS
XU41 ad01d0 $PINS A=n155 B=n120 CI=n148 CO=n65 S=n66 VDD=VDD VSS=VSS
XU42 ah01d1 $PINS A=n106 B=n113 CO=n67 S=n68 VDD=VDD VSS=VSS
XU43 ad01d0 $PINS A=n81 B=n74 CI=n72 CO=n69 S=n70 VDD=VDD VSS=VSS
XU44 ad01d0 $PINS A=n78 B=n83 CI=n76 CO=n71 S=n72 VDD=VDD VSS=VSS
XU45 ad01d0 $PINS A=n142 B=n135 CI=n85 CO=n73 S=n74 VDD=VDD VSS=VSS
XU46 ad01d0 $PINS A=n156 B=n128 CI=n149 CO=n75 S=n76 VDD=VDD VSS=VSS
XU47 ah01d1 $PINS A=n114 B=n121 CO=n77 S=n78 VDD=VDD VSS=VSS
XU48 ad01d0 $PINS A=n89 B=n84 CI=n82 CO=n79 S=n80 VDD=VDD VSS=VSS
XU49 ad01d0 $PINS A=n150 B=n91 CI=n86 CO=n81 S=n82 VDD=VDD VSS=VSS
XU50 ad01d0 $PINS A=n157 B=n136 CI=n143 CO=n83 S=n84 VDD=VDD VSS=VSS
XU51 ah01d1 $PINS A=n122 B=n129 CO=n85 S=n86 VDD=VDD VSS=VSS
XU52 ad01d0 $PINS A=n95 B=n92 CI=n90 CO=n87 S=n88 VDD=VDD VSS=VSS
XU53 ad01d0 $PINS A=n158 B=n144 CI=n151 CO=n89 S=n90 VDD=VDD VSS=VSS
XU54 ah01d1 $PINS A=n130 B=n137 CO=n91 S=n92 VDD=VDD VSS=VSS
XU55 ad01d0 $PINS A=n159 B=n152 CI=n97 CO=n93 S=n94 VDD=VDD VSS=VSS
XU56 ah01d1 $PINS A=n138 B=n145 CO=n95 S=n96 VDD=VDD VSS=VSS
XU57 ah01d1 $PINS A=n153 B=n160 CO=n97 S=n98 VDD=VDD VSS=VSS
XU140 inv0d0 $PINS I=b[4] ZN=n217 VDD=VDD VSS=VSS
XU141 inv0d1 $PINS I=a[1] ZN=n228 VDD=VDD VSS=VSS
XU142 inv0d0 $PINS I=b[2] ZN=n219 VDD=VDD VSS=VSS
XU144 inv0d0 $PINS I=a[2] ZN=n227 VDD=VDD VSS=VSS
XU145 inv0d0 $PINS I=b[3] ZN=n218 VDD=VDD VSS=VSS
XU146 inv0d0 $PINS I=a[5] ZN=n224 VDD=VDD VSS=VSS
XU147 inv0d0 $PINS I=b[1] ZN=n220 VDD=VDD VSS=VSS
XU148 inv0d0 $PINS I=b[0] ZN=n221 VDD=VDD VSS=VSS
XU149 inv0d0 $PINS I=a[4] ZN=n225 VDD=VDD VSS=VSS
XU150 inv0d0 $PINS I=b[6] ZN=n215 VDD=VDD VSS=VSS
XU151 inv0d0 $PINS I=a[3] ZN=n226 VDD=VDD VSS=VSS
XU152 inv0d0 $PINS I=b[5] ZN=n216 VDD=VDD VSS=VSS
XU153 inv0d0 $PINS I=b[7] ZN=n214 VDD=VDD VSS=VSS
XU154 inv0d0 $PINS I=a[6] ZN=n223 VDD=VDD VSS=VSS
XU155 inv0d0 $PINS I=a[7] ZN=n222 VDD=VDD VSS=VSS
XU156 nr02d0 $PINS A1=a[0] A2=n221 ZN=product[0] VDD=VDD VSS=VSS
XU157 nr02d0 $PINS A1=n222 A2=n214 ZN=n99 VDD=VDD VSS=VSS
XU158 nr02d0 $PINS A1=a[0] A2=n220 ZN=n161 VDD=VDD VSS=VSS
XU159 nr02d0 $PINS A1=a[0] A2=n219 ZN=n160 VDD=VDD VSS=VSS
XU160 nr02d0 $PINS A1=a[0] A2=n218 ZN=n159 VDD=VDD VSS=VSS
XU161 nr02d0 $PINS A1=a[0] A2=n217 ZN=n158 VDD=VDD VSS=VSS
XU162 nr02d0 $PINS A1=a[0] A2=n216 ZN=n157 VDD=VDD VSS=VSS
XU163 nr02d0 $PINS A1=a[0] A2=n215 ZN=n156 VDD=VDD VSS=VSS
XU164 nr02d0 $PINS A1=a[0] A2=n214 ZN=n155 VDD=VDD VSS=VSS
XU165 nr02d0 $PINS A1=n221 A2=n228 ZN=n154 VDD=VDD VSS=VSS
XU166 nr02d0 $PINS A1=n220 A2=n228 ZN=n153 VDD=VDD VSS=VSS
XU167 nr02d0 $PINS A1=n219 A2=n228 ZN=n152 VDD=VDD VSS=VSS
XU168 nr02d0 $PINS A1=n218 A2=n228 ZN=n151 VDD=VDD VSS=VSS
XU169 nr02d0 $PINS A1=n217 A2=n228 ZN=n150 VDD=VDD VSS=VSS
XU170 nr02d0 $PINS A1=n216 A2=n228 ZN=n149 VDD=VDD VSS=VSS
XU171 nr02d0 $PINS A1=n215 A2=n228 ZN=n148 VDD=VDD VSS=VSS
XU172 nr02d0 $PINS A1=n214 A2=n228 ZN=n147 VDD=VDD VSS=VSS
XU173 nr02d0 $PINS A1=n221 A2=n227 ZN=n146 VDD=VDD VSS=VSS
XU174 nr02d0 $PINS A1=n220 A2=n227 ZN=n145 VDD=VDD VSS=VSS
XU175 nr02d0 $PINS A1=n219 A2=n227 ZN=n144 VDD=VDD VSS=VSS
XU176 nr02d0 $PINS A1=n218 A2=n227 ZN=n143 VDD=VDD VSS=VSS
XU177 nr02d0 $PINS A1=n217 A2=n227 ZN=n142 VDD=VDD VSS=VSS
XU178 nr02d0 $PINS A1=n216 A2=n227 ZN=n141 VDD=VDD VSS=VSS
XU179 nr02d0 $PINS A1=n215 A2=n227 ZN=n140 VDD=VDD VSS=VSS
XU180 nr02d0 $PINS A1=n214 A2=n227 ZN=n139 VDD=VDD VSS=VSS
XU181 nr02d0 $PINS A1=n221 A2=n226 ZN=n138 VDD=VDD VSS=VSS
XU182 nr02d0 $PINS A1=n220 A2=n226 ZN=n137 VDD=VDD VSS=VSS
XU183 nr02d0 $PINS A1=n219 A2=n226 ZN=n136 VDD=VDD VSS=VSS
XU184 nr02d0 $PINS A1=n218 A2=n226 ZN=n135 VDD=VDD VSS=VSS
XU185 nr02d0 $PINS A1=n217 A2=n226 ZN=n134 VDD=VDD VSS=VSS
XU186 nr02d0 $PINS A1=n216 A2=n226 ZN=n133 VDD=VDD VSS=VSS
XU187 nr02d0 $PINS A1=n215 A2=n226 ZN=n132 VDD=VDD VSS=VSS
XU188 nr02d0 $PINS A1=n214 A2=n226 ZN=n131 VDD=VDD VSS=VSS
XU189 nr02d0 $PINS A1=n221 A2=n225 ZN=n130 VDD=VDD VSS=VSS
XU190 nr02d0 $PINS A1=n220 A2=n225 ZN=n129 VDD=VDD VSS=VSS
XU191 nr02d0 $PINS A1=n219 A2=n225 ZN=n128 VDD=VDD VSS=VSS
XU192 nr02d0 $PINS A1=n218 A2=n225 ZN=n127 VDD=VDD VSS=VSS
XU193 nr02d0 $PINS A1=n217 A2=n225 ZN=n126 VDD=VDD VSS=VSS
XU194 nr02d0 $PINS A1=n216 A2=n225 ZN=n125 VDD=VDD VSS=VSS
XU195 nr02d0 $PINS A1=n215 A2=n225 ZN=n124 VDD=VDD VSS=VSS
XU196 nr02d0 $PINS A1=n214 A2=n225 ZN=n123 VDD=VDD VSS=VSS
XU197 nr02d0 $PINS A1=n221 A2=n224 ZN=n122 VDD=VDD VSS=VSS
XU198 nr02d0 $PINS A1=n220 A2=n224 ZN=n121 VDD=VDD VSS=VSS
XU199 nr02d0 $PINS A1=n219 A2=n224 ZN=n120 VDD=VDD VSS=VSS
XU200 nr02d0 $PINS A1=n218 A2=n224 ZN=n119 VDD=VDD VSS=VSS
XU201 nr02d0 $PINS A1=n217 A2=n224 ZN=n118 VDD=VDD VSS=VSS
XU202 nr02d0 $PINS A1=n216 A2=n224 ZN=n117 VDD=VDD VSS=VSS
XU203 nr02d0 $PINS A1=n215 A2=n224 ZN=n116 VDD=VDD VSS=VSS
XU204 nr02d0 $PINS A1=n214 A2=n224 ZN=n115 VDD=VDD VSS=VSS
XU205 nr02d0 $PINS A1=n221 A2=n223 ZN=n114 VDD=VDD VSS=VSS
XU206 nr02d0 $PINS A1=n220 A2=n223 ZN=n113 VDD=VDD VSS=VSS
XU207 nr02d0 $PINS A1=n219 A2=n223 ZN=n112 VDD=VDD VSS=VSS
XU208 nr02d0 $PINS A1=n218 A2=n223 ZN=n111 VDD=VDD VSS=VSS
XU209 nr02d0 $PINS A1=n217 A2=n223 ZN=n110 VDD=VDD VSS=VSS
XU210 nr02d0 $PINS A1=n216 A2=n223 ZN=n109 VDD=VDD VSS=VSS
XU211 nr02d0 $PINS A1=n215 A2=n223 ZN=n108 VDD=VDD VSS=VSS
XU212 nr02d0 $PINS A1=n214 A2=n223 ZN=n107 VDD=VDD VSS=VSS
XU213 nr02d0 $PINS A1=n221 A2=n222 ZN=n106 VDD=VDD VSS=VSS
XU214 nr02d0 $PINS A1=n222 A2=n220 ZN=n105 VDD=VDD VSS=VSS
XU215 nr02d0 $PINS A1=n222 A2=n219 ZN=n104 VDD=VDD VSS=VSS
XU216 nr02d0 $PINS A1=n222 A2=n218 ZN=n103 VDD=VDD VSS=VSS
XU217 nr02d0 $PINS A1=n222 A2=n217 ZN=n102 VDD=VDD VSS=VSS
XU218 nr02d0 $PINS A1=n222 A2=n216 ZN=n101 VDD=VDD VSS=VSS
XU219 nr02d0 $PINS A1=n222 A2=n215 ZN=n100 VDD=VDD VSS=VSS
.ENDS

.SUBCKT unpu_pe_13_DW01_add_0_DW01_add_14 A[31] A[30] A[29] A[28] A[27] A[26]
+ A[25] A[24] A[23] A[22] A[21] A[20] A[19] A[18] A[17] A[16] A[15] A[14] A[13]
+ A[12] A[11] A[10] A[9] A[8] A[7] A[6] A[5] A[4] A[3] A[2] A[1] A[0] B[31]
+ B[30] B[29] B[28] B[27] B[26] B[25] B[24] B[23] B[22] B[21] B[20] B[19] B[18]
+ B[17] B[16] B[15] B[14] B[13] B[12] B[11] B[10] B[9] B[8] B[7] B[6] B[5] B[4]
+ B[3] B[2] B[1] B[0] CI SUM[31] SUM[30] SUM[29] SUM[28] SUM[27] SUM[26]
+ SUM[25] SUM[24] SUM[23] SUM[22] SUM[21] SUM[20] SUM[19] SUM[18] SUM[17]
+ SUM[16] SUM[15] SUM[14] SUM[13] SUM[12] SUM[11] SUM[10] SUM[9] SUM[8] SUM[7]
+ SUM[6] SUM[5] SUM[4] SUM[3] SUM[2] SUM[1] SUM[0] CO VDD VSS
*.CONNECT SUM[0] B[0]
XU1_31 ad01d0 $PINS A=A[31] B=B[31] CI=carry[31] S=SUM[31] VDD=VDD VSS=VSS
XU1_13 ad01d0 $PINS A=A[13] B=B[13] CI=carry[13] CO=carry[14] S=SUM[13] VDD=VDD
+ VSS=VSS
XU1_12 ad01d0 $PINS A=A[12] B=B[12] CI=carry[12] CO=carry[13] S=SUM[12] VDD=VDD
+ VSS=VSS
XU1_11 ad01d0 $PINS A=A[11] B=B[11] CI=carry[11] CO=carry[12] S=SUM[11] VDD=VDD
+ VSS=VSS
XU1_10 ad01d0 $PINS A=A[10] B=B[10] CI=carry[10] CO=carry[11] S=SUM[10] VDD=VDD
+ VSS=VSS
XU1_9 ad01d0 $PINS A=A[9] B=B[9] CI=carry[9] CO=carry[10] S=SUM[9] VDD=VDD
+ VSS=VSS
XU1_8 ad01d0 $PINS A=A[8] B=B[8] CI=carry[8] CO=carry[9] S=SUM[8] VDD=VDD
+ VSS=VSS
XU1_7 ad01d0 $PINS A=A[7] B=B[7] CI=carry[7] CO=carry[8] S=SUM[7] VDD=VDD
+ VSS=VSS
XU1_6 ad01d0 $PINS A=A[6] B=B[6] CI=carry[6] CO=carry[7] S=SUM[6] VDD=VDD
+ VSS=VSS
XU1_5 ad01d0 $PINS A=A[5] B=B[5] CI=carry[5] CO=carry[6] S=SUM[5] VDD=VDD
+ VSS=VSS
XU1_4 ad01d0 $PINS A=A[4] B=B[4] CI=carry[4] CO=carry[5] S=SUM[4] VDD=VDD
+ VSS=VSS
XU1_3 ad01d0 $PINS A=A[3] B=B[3] CI=carry[3] CO=carry[4] S=SUM[3] VDD=VDD
+ VSS=VSS
XU1_1 ad01d0 $PINS A=A[1] B=B[1] CI=VSS CO=carry[2] S=SUM[1] VDD=VDD VSS=VSS
XU1_2 ad01d0 $PINS A=A[2] B=B[2] CI=carry[2] CO=carry[3] S=SUM[2] VDD=VDD
+ VSS=VSS
XU1_14 ad01d0 $PINS A=A[14] B=B[14] CI=carry[14] CO=carry[15] S=SUM[14] VDD=VDD
+ VSS=VSS
XU1_15 ad01d0 $PINS A=A[15] B=B[15] CI=carry[15] CO=carry[16] S=SUM[15] VDD=VDD
+ VSS=VSS
XU1_30 ad01d0 $PINS A=A[30] B=B[30] CI=carry[30] CO=carry[31] S=SUM[30] VDD=VDD
+ VSS=VSS
XU1_29 ad01d0 $PINS A=A[29] B=B[29] CI=carry[29] CO=carry[30] S=SUM[29] VDD=VDD
+ VSS=VSS
XU1_28 ad01d0 $PINS A=A[28] B=B[28] CI=carry[28] CO=carry[29] S=SUM[28] VDD=VDD
+ VSS=VSS
XU1_27 ad01d0 $PINS A=A[27] B=B[27] CI=carry[27] CO=carry[28] S=SUM[27] VDD=VDD
+ VSS=VSS
XU1_26 ad01d0 $PINS A=A[26] B=B[26] CI=carry[26] CO=carry[27] S=SUM[26] VDD=VDD
+ VSS=VSS
XU1_25 ad01d0 $PINS A=A[25] B=B[25] CI=carry[25] CO=carry[26] S=SUM[25] VDD=VDD
+ VSS=VSS
XU1_24 ad01d0 $PINS A=A[24] B=B[24] CI=carry[24] CO=carry[25] S=SUM[24] VDD=VDD
+ VSS=VSS
XU1_23 ad01d0 $PINS A=A[23] B=B[23] CI=carry[23] CO=carry[24] S=SUM[23] VDD=VDD
+ VSS=VSS
XU1_22 ad01d0 $PINS A=A[22] B=B[22] CI=carry[22] CO=carry[23] S=SUM[22] VDD=VDD
+ VSS=VSS
XU1_21 ad01d0 $PINS A=A[21] B=B[21] CI=carry[21] CO=carry[22] S=SUM[21] VDD=VDD
+ VSS=VSS
XU1_20 ad01d0 $PINS A=A[20] B=B[20] CI=carry[20] CO=carry[21] S=SUM[20] VDD=VDD
+ VSS=VSS
XU1_19 ad01d0 $PINS A=A[19] B=B[19] CI=carry[19] CO=carry[20] S=SUM[19] VDD=VDD
+ VSS=VSS
XU1_18 ad01d0 $PINS A=A[18] B=B[18] CI=carry[18] CO=carry[19] S=SUM[18] VDD=VDD
+ VSS=VSS
XU1_17 ad01d0 $PINS A=A[17] B=B[17] CI=carry[17] CO=carry[18] S=SUM[17] VDD=VDD
+ VSS=VSS
XU1_16 ad01d0 $PINS A=A[16] B=B[16] CI=carry[16] CO=carry[17] S=SUM[16] VDD=VDD
+ VSS=VSS
.ENDS

.SUBCKT unpu_pe_13 rst_n array_en weight_load mode_unsigned weight_in[7]
+ weight_in[6] weight_in[5] weight_in[4] weight_in[3] weight_in[2] weight_in[1]
+ weight_in[0] act_in[7] act_in[6] act_in[5] act_in[4] act_in[3] act_in[2]
+ act_in[1] act_in[0] psum_in[31] psum_in[30] psum_in[29] psum_in[28]
+ psum_in[27] psum_in[26] psum_in[25] psum_in[24] psum_in[23] psum_in[22]
+ psum_in[21] psum_in[20] psum_in[19] psum_in[18] psum_in[17] psum_in[16]
+ psum_in[15] psum_in[14] psum_in[13] psum_in[12] psum_in[11] psum_in[10]
+ psum_in[9] psum_in[8] psum_in[7] psum_in[6] psum_in[5] psum_in[4] psum_in[3]
+ psum_in[2] psum_in[1] psum_in[0] act_out[7] act_out[6] act_out[5] act_out[4]
+ act_out[3] act_out[2] act_out[1] act_out[0] psum_out[31] psum_out[30]
+ psum_out[29] psum_out[28] psum_out[27] psum_out[26] psum_out[25] psum_out[24]
+ psum_out[23] psum_out[22] psum_out[21] psum_out[20] psum_out[19] psum_out[18]
+ psum_out[17] psum_out[16] psum_out[15] psum_out[14] psum_out[13] psum_out[12]
+ psum_out[11] psum_out[10] psum_out[9] psum_out[8] psum_out[7] psum_out[6]
+ psum_out[5] psum_out[4] psum_out[3] psum_out[2] psum_out[1] psum_out[0] VDD
+ VSS ZCTSNET_11 HFSNET_2 HFSNET_5 HFSNET_6 HFSNET_8 HFSNET_9 ZCTSNET_0
+ ZCTSNET_1
XU2 aor22d1 $PINS A1=N_uc_30 A2=mode_unsigned B1=HFSNET_2 B2=N_uc_14
+ Z=product[9] VDD=VDD VSS=VSS
XU3 aor22d1 $PINS A1=N_uc_29 A2=mode_unsigned B1=N_uc_13 B2=HFSNET_2
+ Z=product[8] VDD=VDD VSS=VSS
XU5 aor22d1 $PINS A1=N_uc_28 A2=mode_unsigned B1=N_uc_12 B2=HFSNET_2
+ Z=product[7] VDD=VDD VSS=VSS
XU6 aor22d1 $PINS A1=N_uc_27 A2=mode_unsigned B1=N_uc_11 B2=HFSNET_2
+ Z=product[6] VDD=VDD VSS=VSS
XU7 aor22d1 $PINS A1=N_uc_26 A2=mode_unsigned B1=N_uc_10 B2=HFSNET_2
+ Z=product[5] VDD=VDD VSS=VSS
XU8 aor22d1 $PINS A1=N_uc_9 A2=HFSNET_2 B1=N_uc_25 B2=mode_unsigned
+ Z=product[4] VDD=VDD VSS=VSS
XU9 aor22d1 $PINS A1=N_uc_8 A2=HFSNET_2 B1=N_uc_24 B2=mode_unsigned
+ Z=product[3] VDD=VDD VSS=VSS
XU10 aor22d1 $PINS A1=N_uc_7 A2=HFSNET_2 B1=N_uc_23 B2=mode_unsigned
+ Z=product[2] VDD=VDD VSS=VSS
XU11 aor22d1 $PINS A1=N_uc_6 A2=HFSNET_2 B1=N_uc_22 B2=mode_unsigned
+ Z=product[1] VDD=VDD VSS=VSS
XU12 oaim21d1 $PINS B1=N_uc_20 B2=HFSNET_2 A=n16 ZN=product[15] VDD=VDD VSS=VSS
XU13 aor22d1 $PINS A1=N_uc_35 A2=mode_unsigned B1=N_uc_19 B2=HFSNET_2
+ Z=product[14] VDD=VDD VSS=VSS
XU14 aor22d1 $PINS A1=N_uc_34 A2=mode_unsigned B1=N_uc_18 B2=HFSNET_2
+ Z=product[13] VDD=VDD VSS=VSS
XU15 aor22d1 $PINS A1=N_uc_33 A2=mode_unsigned B1=N_uc_17 B2=HFSNET_2
+ Z=product[12] VDD=VDD VSS=VSS
XU16 aor22d1 $PINS A1=N_uc_32 A2=mode_unsigned B1=N_uc_16 B2=HFSNET_2
+ Z=product[11] VDD=VDD VSS=VSS
XU17 aor22d1 $PINS A1=N_uc_31 A2=mode_unsigned B1=N_uc_15 B2=HFSNET_2
+ Z=product[10] VDD=VDD VSS=VSS
XU18 aor22d4 $PINS A1=N_uc_5 A2=HFSNET_2 B1=N_uc_21 B2=mode_unsigned
+ Z=product[0] VDD=VDD VSS=VSS
Xadd_42 unpu_pe_13_DW01_add_0_DW01_add_14 $PINS A[31]=psum_in[31]
+ A[30]=psum_in[30] A[29]=psum_in[29] A[28]=psum_in[28] A[27]=psum_in[27]
+ A[26]=psum_in[26] A[25]=psum_in[25] A[24]=psum_in[24] A[23]=psum_in[23]
+ A[22]=psum_in[22] A[21]=psum_in[21] A[20]=psum_in[20] A[19]=psum_in[19]
+ A[18]=psum_in[18] A[17]=psum_in[17] A[16]=psum_in[16] A[15]=psum_in[15]
+ A[14]=psum_in[14] A[13]=psum_in[13] A[12]=psum_in[12] A[11]=psum_in[11]
+ A[10]=psum_in[10] A[9]=psum_in[9] A[8]=psum_in[8] A[7]=psum_in[7]
+ A[6]=psum_in[6] A[5]=psum_in[5] A[4]=psum_in[4] A[3]=psum_in[3] A[2]=psum_in[2]
+ A[1]=psum_in[1] A[0]=psum_in[0] B[31]=n2 B[30]=n2 B[29]=n2 B[28]=n2 B[27]=n2
+ B[26]=n2 B[25]=n2 B[24]=n2 B[23]=n2 B[22]=n2 B[21]=n2 B[20]=n2 B[19]=n2
+ B[18]=n2 B[17]=n2 B[16]=n2 B[15]=product[15] B[14]=product[14]
+ B[13]=product[13] B[12]=product[12] B[11]=product[11] B[10]=product[10]
+ B[9]=product[9] B[8]=product[8] B[7]=product[7] B[6]=product[6] B[5]=product[5]
+ B[4]=product[4] B[3]=product[3] B[2]=product[2] B[1]=product[1] B[0]=product[0]
+ CI=VSS SUM[31]=N_uc_71 SUM[30]=N_uc_70 SUM[29]=N_uc_69 SUM[28]=N_uc_68
+ SUM[27]=N_uc_67 SUM[26]=N_uc_66 SUM[25]=N_uc_65 SUM[24]=N_uc_64 SUM[23]=N_uc_63
+ SUM[22]=N_uc_62 SUM[21]=N_uc_61 SUM[20]=N_uc_60 SUM[19]=N_uc_59 SUM[18]=N_uc_58
+ SUM[17]=N_uc_57 SUM[16]=N_uc_56 SUM[15]=N_uc_55 SUM[14]=N_uc_54 SUM[13]=N_uc_53
+ SUM[12]=N_uc_52 SUM[11]=N_uc_51 SUM[10]=N_uc_50 SUM[9]=N_uc_49 SUM[8]=N_uc_48
+ SUM[7]=N_uc_47 SUM[6]=N_uc_46 SUM[5]=N_uc_45 SUM[4]=N_uc_44 SUM[3]=N_uc_43
+ SUM[2]=N_uc_42 SUM[1]=N_uc_41 SUM[0]=N_uc_40 VDD=VDD VSS=VSS
Xmult_28 unpu_pe_13_DW_mult_uns_0_DW_mult_uns_11 $PINS a[7]=weight_reg[7]
+ a[6]=weight_reg[6] a[5]=weight_reg[5] a[4]=weight_reg[4] a[3]=weight_reg[3]
+ a[2]=weight_reg[2] a[1]=weight_reg[1] a[0]=gre_a_INV_1651_3 b[7]=act_in[7]
+ b[6]=act_in[6] b[5]=act_in[5] b[4]=act_in[4] b[3]=act_in[3] b[2]=act_in[2]
+ b[1]=act_in[1] b[0]=act_in[0] product[15]=N_uc_20 product[14]=N_uc_19
+ product[13]=N_uc_18 product[12]=N_uc_17 product[11]=N_uc_16 product[10]=N_uc_15
+ product[9]=N_uc_14 product[8]=N_uc_13 product[7]=N_uc_12 product[6]=N_uc_11
+ product[5]=N_uc_10 product[4]=N_uc_9 product[3]=N_uc_8 product[2]=N_uc_7
+ product[1]=N_uc_6 product[0]=N_uc_5 VDD=VDD VSS=VSS
Xmult_30 unpu_pe_13_DW_mult_tc_0_DW_mult_tc_10 $PINS a[7]=weight_reg[7]
+ a[6]=weight_reg[6] a[5]=weight_reg[5] a[4]=weight_reg[4] a[3]=weight_reg[3]
+ a[2]=weight_reg[2] a[1]=weight_reg[1] a[0]=gre_a_INV_1651_3 b[7]=act_in[7]
+ b[6]=act_in[6] b[5]=act_in[5] b[4]=act_in[4] b[3]=act_in[3] b[2]=act_in[2]
+ b[1]=act_in[1] b[0]=act_in[0] product[15]=N_uc_36 product[14]=N_uc_35
+ product[13]=N_uc_34 product[12]=N_uc_33 product[11]=N_uc_32 product[10]=N_uc_31
+ product[9]=N_uc_30 product[8]=N_uc_29 product[7]=N_uc_28 product[6]=N_uc_27
+ product[5]=N_uc_26 product[4]=N_uc_25 product[3]=N_uc_24 product[2]=N_uc_23
+ product[1]=N_uc_22 product[0]=N_uc_21 VDD=VDD VSS=VSS
Xact_out_reg_3_ decrq1 $PINS D=copt_net_524 ENN=array_en CP=ZCTSNET_0
+ CDN=HFSNET_6 Q=act_out[3] VDD=VDD VSS=VSS
Xact_out_reg_2_ decrq1 $PINS D=copt_net_577 ENN=array_en CP=ZCTSNET_0
+ CDN=HFSNET_6 Q=act_out[2] VDD=VDD VSS=VSS
Xact_out_reg_1_ decrq1 $PINS D=copt_net_611 ENN=HFSNET_4 CP=ZCTSNET_11
+ CDN=HFSNET_7 Q=act_out[1] VDD=VDD VSS=VSS
Xact_out_reg_7_ decrq1 $PINS D=copt_net_432 ENN=HFSNET_4 CP=ZCTSNET_11
+ CDN=HFSNET_7 Q=act_out[7] VDD=VDD VSS=VSS
Xact_out_reg_6_ decrq1 $PINS D=copt_net_515 ENN=array_en CP=ZCTSNET_0
+ CDN=HFSNET_6 Q=act_out[6] VDD=VDD VSS=VSS
Xact_out_reg_5_ decrq1 $PINS D=copt_net_349 ENN=array_en CP=ZCTSNET_0
+ CDN=HFSNET_6 Q=act_out[5] VDD=VDD VSS=VSS
Xact_out_reg_4_ decrq1 $PINS D=copt_net_377 ENN=array_en CP=ZCTSNET_0
+ CDN=HFSNET_6 Q=act_out[4] VDD=VDD VSS=VSS
Xact_out_reg_0_ decrq1 $PINS D=copt_net_716 ENN=HFSNET_4 CP=ZCTSNET_11
+ CDN=HFSNET_7 Q=act_out[0] VDD=VDD VSS=VSS
Xpsum_out_reg_8_ decrq1 $PINS D=N_uc_48 ENN=HFSNET_4 CP=ZCTSNET_11 CDN=HFSNET_7
+ Q=psum_out[8] VDD=VDD VSS=VSS
Xpsum_out_reg_7_ decrq1 $PINS D=N_uc_47 ENN=HFSNET_4 CP=ZCTSNET_11 CDN=HFSNET_7
+ Q=psum_out[7] VDD=VDD VSS=VSS
Xpsum_out_reg_6_ decrq1 $PINS D=N_uc_46 ENN=HFSNET_4 CP=ZCTSNET_11 CDN=HFSNET_7
+ Q=psum_out[6] VDD=VDD VSS=VSS
Xpsum_out_reg_5_ decrq1 $PINS D=N_uc_45 ENN=HFSNET_4 CP=ZCTSNET_11 CDN=HFSNET_7
+ Q=psum_out[5] VDD=VDD VSS=VSS
Xpsum_out_reg_4_ decrq1 $PINS D=N_uc_44 ENN=HFSNET_4 CP=ZCTSNET_11 CDN=HFSNET_7
+ Q=psum_out[4] VDD=VDD VSS=VSS
Xpsum_out_reg_3_ decrq1 $PINS D=N_uc_43 ENN=HFSNET_4 CP=ZCTSNET_11 CDN=HFSNET_7
+ Q=psum_out[3] VDD=VDD VSS=VSS
Xpsum_out_reg_2_ decrq1 $PINS D=N_uc_42 ENN=HFSNET_4 CP=ZCTSNET_11 CDN=HFSNET_7
+ Q=psum_out[2] VDD=VDD VSS=VSS
Xpsum_out_reg_1_ decrq1 $PINS D=N_uc_41 ENN=HFSNET_4 CP=ZCTSNET_11 CDN=HFSNET_7
+ Q=psum_out[1] VDD=VDD VSS=VSS
Xpsum_out_reg_0_ decrq1 $PINS D=N_uc_40 ENN=HFSNET_4 CP=ZCTSNET_11 CDN=HFSNET_7
+ Q=psum_out[0] VDD=VDD VSS=VSS
Xpsum_out_reg_9_ decrq1 $PINS D=N_uc_49 ENN=HFSNET_4 CP=ZCTSNET_11 CDN=HFSNET_7
+ Q=psum_out[9] VDD=VDD VSS=VSS
Xpsum_out_reg_10_ decrq1 $PINS D=N_uc_50 ENN=HFSNET_4 CP=ZCTSNET_11
+ CDN=HFSNET_7 Q=psum_out[10] VDD=VDD VSS=VSS
Xpsum_out_reg_11_ decrq1 $PINS D=N_uc_51 ENN=HFSNET_4 CP=ZCTSNET_11
+ CDN=HFSNET_7 Q=psum_out[11] VDD=VDD VSS=VSS
Xweight_reg_reg_7_ decrq1 $PINS D=weight_in[7] ENN=n15 CP=ZCTSNET_1
+ CDN=HFSNET_6 Q=weight_reg[7] VDD=VDD VSS=VSS
Xweight_reg_reg_6_ decrq1 $PINS D=weight_in[6] ENN=n15 CP=ZCTSNET_0
+ CDN=HFSNET_6 Q=weight_reg[6] VDD=VDD VSS=VSS
Xweight_reg_reg_5_ decrq1 $PINS D=weight_in[5] ENN=n15 CP=ZCTSNET_11
+ CDN=HFSNET_7 Q=weight_reg[5] VDD=VDD VSS=VSS
Xweight_reg_reg_4_ decrq1 $PINS D=weight_in[4] ENN=n15 CP=ZCTSNET_0
+ CDN=HFSNET_7 Q=weight_reg[4] VDD=VDD VSS=VSS
Xweight_reg_reg_3_ decrq1 $PINS D=weight_in[3] ENN=n15 CP=ZCTSNET_0
+ CDN=HFSNET_7 Q=weight_reg[3] VDD=VDD VSS=VSS
Xweight_reg_reg_2_ decrq1 $PINS D=weight_in[2] ENN=n15 CP=ZCTSNET_1
+ CDN=HFSNET_6 Q=weight_reg[2] VDD=VDD VSS=VSS
Xweight_reg_reg_1_ decrq1 $PINS D=weight_in[1] ENN=n15 CP=ZCTSNET_11
+ CDN=HFSNET_7 Q=weight_reg[1] VDD=VDD VSS=VSS
Xweight_reg_reg_0_ decrq1 $PINS D=weight_in[0] ENN=n15 CP=ZCTSNET_11
+ CDN=HFSNET_7 Q=weight_reg[0] VDD=VDD VSS=VSS
Xpsum_out_reg_12_ decrq1 $PINS D=N_uc_52 ENN=HFSNET_4 CP=ZCTSNET_11
+ CDN=HFSNET_7 Q=psum_out[12] VDD=VDD VSS=VSS
Xpsum_out_reg_13_ decrq1 $PINS D=N_uc_53 ENN=HFSNET_4 CP=ZCTSNET_11
+ CDN=HFSNET_7 Q=psum_out[13] VDD=VDD VSS=VSS
Xpsum_out_reg_14_ decrq1 $PINS D=N_uc_54 ENN=HFSNET_4 CP=ZCTSNET_11
+ CDN=HFSNET_7 Q=psum_out[14] VDD=VDD VSS=VSS
Xpsum_out_reg_15_ decrq1 $PINS D=N_uc_55 ENN=HFSNET_4 CP=ZCTSNET_11
+ CDN=HFSNET_7 Q=psum_out[15] VDD=VDD VSS=VSS
Xpsum_out_reg_31_ decrq1 $PINS D=N_uc_71 ENN=array_en CP=ZCTSNET_11
+ CDN=HFSNET_6 Q=psum_out[31] VDD=VDD VSS=VSS
Xpsum_out_reg_30_ decrq1 $PINS D=N_uc_70 ENN=HFSNET_4 CP=ZCTSNET_11
+ CDN=HFSNET_7 Q=psum_out[30] VDD=VDD VSS=VSS
Xpsum_out_reg_29_ decrq1 $PINS D=N_uc_69 ENN=array_en CP=ZCTSNET_0 CDN=HFSNET_6
+ Q=psum_out[29] VDD=VDD VSS=VSS
Xpsum_out_reg_28_ decrq1 $PINS D=N_uc_68 ENN=HFSNET_4 CP=ZCTSNET_11
+ CDN=HFSNET_8 Q=psum_out[28] VDD=VDD VSS=VSS
Xpsum_out_reg_27_ decrq1 $PINS D=N_uc_67 ENN=HFSNET_4 CP=ZCTSNET_11
+ CDN=HFSNET_8 Q=psum_out[27] VDD=VDD VSS=VSS
Xpsum_out_reg_26_ decrq1 $PINS D=N_uc_66 ENN=HFSNET_4 CP=ZCTSNET_11
+ CDN=HFSNET_8 Q=psum_out[26] VDD=VDD VSS=VSS
Xpsum_out_reg_25_ decrq1 $PINS D=N_uc_65 ENN=HFSNET_4 CP=ZCTSNET_11
+ CDN=HFSNET_8 Q=psum_out[25] VDD=VDD VSS=VSS
Xpsum_out_reg_24_ decrq1 $PINS D=N_uc_64 ENN=HFSNET_4 CP=ZCTSNET_11
+ CDN=HFSNET_8 Q=psum_out[24] VDD=VDD VSS=VSS
Xpsum_out_reg_23_ decrq1 $PINS D=N_uc_63 ENN=HFSNET_4 CP=ZCTSNET_11
+ CDN=HFSNET_8 Q=psum_out[23] VDD=VDD VSS=VSS
Xpsum_out_reg_22_ decrq1 $PINS D=N_uc_62 ENN=HFSNET_4 CP=ZCTSNET_11
+ CDN=HFSNET_8 Q=psum_out[22] VDD=VDD VSS=VSS
Xpsum_out_reg_21_ decrq1 $PINS D=N_uc_61 ENN=HFSNET_4 CP=ZCTSNET_11
+ CDN=HFSNET_7 Q=psum_out[21] VDD=VDD VSS=VSS
Xpsum_out_reg_20_ decrq1 $PINS D=N_uc_60 ENN=HFSNET_4 CP=ZCTSNET_11
+ CDN=HFSNET_7 Q=psum_out[20] VDD=VDD VSS=VSS
Xpsum_out_reg_19_ decrq1 $PINS D=N_uc_59 ENN=HFSNET_4 CP=ZCTSNET_11
+ CDN=HFSNET_7 Q=psum_out[19] VDD=VDD VSS=VSS
Xpsum_out_reg_18_ decrq1 $PINS D=N_uc_58 ENN=HFSNET_4 CP=ZCTSNET_11
+ CDN=HFSNET_7 Q=psum_out[18] VDD=VDD VSS=VSS
Xpsum_out_reg_17_ decrq1 $PINS D=N_uc_57 ENN=HFSNET_4 CP=ZCTSNET_11 CDN=rst_n
+ Q=psum_out[17] VDD=VDD VSS=VSS
Xpsum_out_reg_16_ decrq1 $PINS D=N_uc_56 ENN=HFSNET_4 CP=ZCTSNET_11
+ CDN=HFSNET_7 Q=psum_out[16] VDD=VDD VSS=VSS
XU19 inv0d2 $PINS I=n16 ZN=n2 VDD=VDD VSS=VSS
Xcopt_h_inst_3179 dl02d1 $PINS I=act_in[5] Z=copt_net_349 VDD=VDD VSS=VSS
XHFSBUF_49136_561 buffd1 $PINS I=HFSNET_5 Z=HFSNET_4 VDD=VDD VSS=VSS
XHFSINV_2531_681 inv0d2 $PINS I=HFSNET_9 ZN=HFSNET_7 VDD=VDD VSS=VSS
XctmTdsLR_1_1337 nd12d1 $PINS A1=HFSNET_5 A2=weight_load ZN=n15 VDD=VDD VSS=VSS
Xcopt_h_inst_3207 dl02d1 $PINS I=act_in[4] Z=copt_net_377 VDD=VDD VSS=VSS
Xcopt_h_inst_3262 dl02d1 $PINS I=act_in[7] Z=copt_net_432 VDD=VDD VSS=VSS
Xcopt_h_inst_3345 dl02d1 $PINS I=act_in[6] Z=copt_net_515 VDD=VDD VSS=VSS
Xcopt_h_inst_3354 dl02d1 $PINS I=act_in[3] Z=copt_net_524 VDD=VDD VSS=VSS
Xcopt_h_inst_3407 dl02d1 $PINS I=act_in[2] Z=copt_net_577 VDD=VDD VSS=VSS
XU29 nd02d1 $PINS A1=N_uc_36 A2=mode_unsigned ZN=n16 VDD=VDD VSS=VSS
Xcopt_h_inst_3441 dl02d1 $PINS I=act_in[1] Z=copt_net_611 VDD=VDD VSS=VSS
Xcopt_h_inst_3546 dl02d1 $PINS I=act_in[0] Z=copt_net_716 VDD=VDD VSS=VSS
Xgre_a_INV_1651_inst_5803 inv0d1 $PINS I=weight_reg[0] ZN=gre_a_INV_1651_3
+ VDD=VDD VSS=VSS
.ENDS

.SUBCKT unpu_pe_14_DW_mult_tc_0_DW_mult_tc_11 a[7] a[6] a[5] a[4] a[3] a[2]
+ a[1] a[0] b[7] b[6] b[5] b[4] b[3] b[2] b[1] b[0] product[15] product[14]
+ product[13] product[12] product[11] product[10] product[9] product[8]
+ product[7] product[6] product[5] product[4] product[3] product[2] product[1]
+ product[0] VDD VSS gre_a_INV_1913_2 gre_a_INV_2086_2
XU2 ad01d0 $PINS A=n194 B=n61 CI=n2 CO=n1 S=product[14] VDD=VDD VSS=VSS
XU3 ad01d0 $PINS A=n17 B=n16 CI=n3 CO=n2 S=product[13] VDD=VDD VSS=VSS
XU4 ad01d0 $PINS A=n18 B=n19 CI=n4 CO=n3 S=product[12] VDD=VDD VSS=VSS
XU5 ad01d0 $PINS A=n20 B=n23 CI=n5 CO=n4 S=product[11] VDD=VDD VSS=VSS
XU6 ad01d0 $PINS A=n27 B=n24 CI=n6 CO=n5 S=product[10] VDD=VDD VSS=VSS
XU7 ad01d0 $PINS A=n33 B=n28 CI=n7 CO=n6 S=product[9] VDD=VDD VSS=VSS
XU8 ad01d0 $PINS A=n39 B=n34 CI=n8 CO=n7 S=product[8] VDD=VDD VSS=VSS
XU9 ad01d0 $PINS A=n45 B=n40 CI=n9 CO=n8 S=product[7] VDD=VDD VSS=VSS
XU10 ad01d0 $PINS A=n49 B=n46 CI=n10 CO=n9 S=product[6] VDD=VDD VSS=VSS
XU11 ad01d0 $PINS A=n53 B=n50 CI=n11 CO=n10 S=product[5] VDD=VDD VSS=VSS
XU12 ad01d0 $PINS A=n55 B=n54 CI=n12 CO=n11 S=product[4] VDD=VDD VSS=VSS
XU13 ad01d0 $PINS A=n59 B=n56 CI=n13 CO=n12 S=product[3] VDD=VDD VSS=VSS
XU14 ad01d0 $PINS A=n84 B=n91 CI=n14 CO=n13 S=product[2] VDD=VDD VSS=VSS
XctmTdsLR_1_2911 an02d1 $PINS A1=n58 A2=n75 Z=n51 VDD=VDD VSS=VSS
XU17 ad01d0 $PINS A=n197 B=n62 CI=n69 CO=n17 S=n18 VDD=VDD VSS=VSS
XU18 ad01d0 $PINS A=n63 B=n25 CI=n22 CO=n19 S=n20 VDD=VDD VSS=VSS
XU20 ad01d0 $PINS A=n64 B=n26 CI=n29 CO=n23 S=n24 VDD=VDD VSS=VSS
XU21 ad01d0 $PINS A=n200 B=n70 CI=n77 CO=n25 S=n26 VDD=VDD VSS=VSS
XU22 ad01d0 $PINS A=n32 B=n35 CI=n30 CO=n27 S=n28 VDD=VDD VSS=VSS
XU23 ad01d0 $PINS A=n71 B=n65 CI=n37 CO=n29 S=n30 VDD=VDD VSS=VSS
XU25 ad01d0 $PINS A=n38 B=n41 CI=n36 CO=n33 S=n34 VDD=VDD VSS=VSS
XU26 ad01d0 $PINS A=n72 B=n85 CI=n43 CO=n35 S=n36 VDD=VDD VSS=VSS
XU29 ad01d0 $PINS A=n44 B=n47 CI=n42 CO=n39 S=n40 VDD=VDD VSS=VSS
XU30 ad01d0 $PINS A=n86 B=n73 CI=n79 CO=n41 S=n42 VDD=VDD VSS=VSS
XU32 ad01d0 $PINS A=n74 B=n51 CI=n48 CO=n45 S=n46 VDD=VDD VSS=VSS
XU33 ad01d0 $PINS A=n68 B=n87 CI=n80 CO=n47 S=n48 VDD=VDD VSS=VSS
XU34 ad01d0 $PINS A=n88 B=n81 CI=n52 CO=n49 S=n50 VDD=VDD VSS=VSS
XU36 ad01d0 $PINS A=n76 B=n89 CI=n82 CO=n53 S=n54 VDD=VDD VSS=VSS
XU37 ah01d1 $PINS A=n83 B=n90 CO=n55 S=n56 VDD=VDD VSS=VSS
XU145 oai21d1 $PINS B1=n202 B2=n249 A=n222 ZN=n77 VDD=VDD VSS=VSS
XU146 oai21d1 $PINS B1=n199 B2=n250 A=n232 ZN=n69 VDD=VDD VSS=VSS
XU147 oai21d1 $PINS B1=n196 B2=n251 A=n242 ZN=n61 VDD=VDD VSS=VSS
XU148 inv0d0 $PINS I=n16 ZN=n194 VDD=VDD VSS=VSS
XU149 inv0d0 $PINS I=n223 ZN=n199 VDD=VDD VSS=VSS
XU150 inv0d0 $PINS I=n214 ZN=n202 VDD=VDD VSS=VSS
XU151 inv0d0 $PINS I=n233 ZN=n196 VDD=VDD VSS=VSS
XU152 inv0d0 $PINS I=n32 ZN=n200 VDD=VDD VSS=VSS
XU153 inv0d0 $PINS I=n22 ZN=n197 VDD=VDD VSS=VSS
XU154 nd02d1 $PINS A1=n214 A2=n249 ZN=n216 VDD=VDD VSS=VSS
XU155 xr02d1 $PINS A1=a[2] A2=n203 Z=n214 VDD=VDD VSS=VSS
XU156 inv0d1 $PINS I=a[1] ZN=n203 VDD=VDD VSS=VSS
XU157 nd02d1 $PINS A1=n223 A2=n250 ZN=n225 VDD=VDD VSS=VSS
XU158 xr02d1 $PINS A1=a[4] A2=n201 Z=n223 VDD=VDD VSS=VSS
XU159 inv0d1 $PINS I=a[3] ZN=n201 VDD=VDD VSS=VSS
XU160 nd02d1 $PINS A1=a[1] A2=n204 ZN=n206 VDD=VDD VSS=VSS
XU161 inv0d1 $PINS I=a[0] ZN=n204 VDD=VDD VSS=VSS
XU162 xr02d1 $PINS A1=a[6] A2=gre_a_INV_2086_2 Z=n233 VDD=VDD VSS=VSS
XU164 inv0d0 $PINS I=b[0] ZN=n205 VDD=VDD VSS=VSS
XU165 nd02d1 $PINS A1=n233 A2=n251 ZN=n235 VDD=VDD VSS=VSS
XU167 inv0d0 $PINS I=n1 ZN=product[15] VDD=VDD VSS=VSS
XU168 nr02d0 $PINS A1=n204 A2=n205 ZN=product[0] VDD=VDD VSS=VSS
XU169 oai22d1 $PINS A1=b[0] A2=n206 B1=n207 B2=n204 ZN=n92 VDD=VDD VSS=VSS
XU170 oai22d1 $PINS A1=n207 A2=n206 B1=n208 B2=n204 ZN=n91 VDD=VDD VSS=VSS
XU171 xr02d1 $PINS A1=b[1] A2=n203 Z=n207 VDD=VDD VSS=VSS
XU172 oai22d1 $PINS A1=n208 A2=n206 B1=n209 B2=n204 ZN=n90 VDD=VDD VSS=VSS
XU173 xr02d1 $PINS A1=b[2] A2=n203 Z=n208 VDD=VDD VSS=VSS
XU174 oai22d1 $PINS A1=n209 A2=n206 B1=n210 B2=n204 ZN=n89 VDD=VDD VSS=VSS
XU175 xr02d1 $PINS A1=b[3] A2=n203 Z=n209 VDD=VDD VSS=VSS
XU176 oai22d1 $PINS A1=n210 A2=n206 B1=n211 B2=n204 ZN=n88 VDD=VDD VSS=VSS
XU177 xr02d1 $PINS A1=b[4] A2=n203 Z=n210 VDD=VDD VSS=VSS
XU178 oai22d1 $PINS A1=n211 A2=n206 B1=n212 B2=n204 ZN=n87 VDD=VDD VSS=VSS
XU179 xr02d1 $PINS A1=b[5] A2=n203 Z=n211 VDD=VDD VSS=VSS
XU180 oai22d1 $PINS A1=n212 A2=n206 B1=n213 B2=n204 ZN=n86 VDD=VDD VSS=VSS
XU181 xr02d1 $PINS A1=b[6] A2=n203 Z=n212 VDD=VDD VSS=VSS
XU182 aor21d1 $PINS B1=n204 B2=n206 A=n213 Z=n85 VDD=VDD VSS=VSS
XU183 xr02d1 $PINS A1=b[7] A2=n203 Z=n213 VDD=VDD VSS=VSS
XU184 nr02d0 $PINS A1=n214 A2=n205 ZN=n84 VDD=VDD VSS=VSS
XU185 oai22d1 $PINS A1=n216 A2=n215 B1=n214 B2=n217 ZN=n83 VDD=VDD VSS=VSS
XctmTdsLR_1_2907 an02d1 $PINS A1=n92 A2=n60 Z=n14 VDD=VDD VSS=VSS
XU187 oai22d1 $PINS A1=n217 A2=n216 B1=n214 B2=n218 ZN=n82 VDD=VDD VSS=VSS
XU188 xr02d1 $PINS A1=b[1] A2=n201 Z=n217 VDD=VDD VSS=VSS
XU189 oai22d1 $PINS A1=n218 A2=n216 B1=n214 B2=n219 ZN=n81 VDD=VDD VSS=VSS
XU190 xr02d1 $PINS A1=b[2] A2=n201 Z=n218 VDD=VDD VSS=VSS
XU191 oai22d1 $PINS A1=n219 A2=n216 B1=n214 B2=n220 ZN=n80 VDD=VDD VSS=VSS
XU192 xr02d1 $PINS A1=b[3] A2=n201 Z=n219 VDD=VDD VSS=VSS
XU193 oai22d1 $PINS A1=n220 A2=n216 B1=n214 B2=n221 ZN=n79 VDD=VDD VSS=VSS
XU194 xr02d1 $PINS A1=b[4] A2=n201 Z=n220 VDD=VDD VSS=VSS
XU195 nr02d0 $PINS A1=n223 A2=n205 ZN=n76 VDD=VDD VSS=VSS
XU196 oai22d1 $PINS A1=n225 A2=n224 B1=n223 B2=n226 ZN=n75 VDD=VDD VSS=VSS
XctmTdsLR_2_2908 aoim21d1 $PINS B1=n92 B2=n60 A=n14 ZN=product[1] VDD=VDD
+ VSS=VSS
XU198 oai22d1 $PINS A1=n226 A2=n225 B1=n223 B2=n227 ZN=n74 VDD=VDD VSS=VSS
XU199 xr02d1 $PINS A1=b[1] A2=gre_a_INV_2086_2 Z=n226 VDD=VDD VSS=VSS
XU200 oai22d1 $PINS A1=n227 A2=n225 B1=n223 B2=n228 ZN=n73 VDD=VDD VSS=VSS
XU201 xr02d1 $PINS A1=b[2] A2=gre_a_INV_2086_2 Z=n227 VDD=VDD VSS=VSS
XU202 oai22d1 $PINS A1=n228 A2=n225 B1=n223 B2=n229 ZN=n72 VDD=VDD VSS=VSS
XU203 xr02d1 $PINS A1=b[3] A2=gre_a_INV_2086_2 Z=n228 VDD=VDD VSS=VSS
XU204 oai22d1 $PINS A1=n229 A2=n225 B1=n223 B2=n230 ZN=n71 VDD=VDD VSS=VSS
XU205 xr02d1 $PINS A1=b[4] A2=gre_a_INV_2086_2 Z=n229 VDD=VDD VSS=VSS
XU206 oai22d1 $PINS A1=n230 A2=n225 B1=n223 B2=n231 ZN=n70 VDD=VDD VSS=VSS
XU207 xr02d1 $PINS A1=b[5] A2=gre_a_INV_2086_2 Z=n230 VDD=VDD VSS=VSS
XU208 nr02d0 $PINS A1=n233 A2=n205 ZN=n68 VDD=VDD VSS=VSS
XU209 oai22d1 $PINS A1=n235 A2=n234 B1=n233 B2=n236 ZN=n67 VDD=VDD VSS=VSS
XctmTdsLR_2_2912 aoim21d1 $PINS B1=n58 B2=n75 A=n51 ZN=n52 VDD=VDD VSS=VSS
XU211 oai22d1 $PINS A1=n237 A2=n235 B1=n233 B2=n238 ZN=n65 VDD=VDD VSS=VSS
XU212 oai22d1 $PINS A1=n238 A2=n235 B1=n233 B2=n239 ZN=n64 VDD=VDD VSS=VSS
XU213 xr02d1 $PINS A1=b[3] A2=gre_a_INV_1913_2 Z=n238 VDD=VDD VSS=VSS
XU214 oai22d1 $PINS A1=n239 A2=n235 B1=n233 B2=n240 ZN=n63 VDD=VDD VSS=VSS
XU215 xr02d1 $PINS A1=b[4] A2=gre_a_INV_1913_2 Z=n239 VDD=VDD VSS=VSS
XU216 oai22d1 $PINS A1=n240 A2=n235 B1=n233 B2=n241 ZN=n62 VDD=VDD VSS=VSS
XU217 xr02d1 $PINS A1=b[5] A2=gre_a_INV_1913_2 Z=n240 VDD=VDD VSS=VSS
XU218 oai21d1 $PINS B1=n203 B2=b[0] A=n206 ZN=n60 VDD=VDD VSS=VSS
XU219 oai21d1 $PINS B1=n201 B2=n216 A=n243 ZN=n59 VDD=VDD VSS=VSS
XU220 nd03d0 $PINS A1=n202 A2=n205 A3=a[3] ZN=n243 VDD=VDD VSS=VSS
XU221 oai21d1 $PINS B1=gre_a_INV_2086_2 B2=n225 A=n244 ZN=n58 VDD=VDD VSS=VSS
XU222 nd03d0 $PINS A1=n199 A2=n205 A3=a[5] ZN=n244 VDD=VDD VSS=VSS
XU223 oai21d1 $PINS B1=gre_a_INV_1913_2 B2=n235 A=n245 ZN=n57 VDD=VDD VSS=VSS
XU224 nd03d0 $PINS A1=n196 A2=n205 A3=a[7] ZN=n245 VDD=VDD VSS=VSS
XU225 xn02d1 $PINS A1=n246 A2=n247 ZN=n38 VDD=VDD VSS=VSS
XU226 or02d0 $PINS A1=n247 A2=n246 Z=n37 VDD=VDD VSS=VSS
XU227 oai22d1 $PINS A1=n236 A2=n235 B1=n233 B2=n237 ZN=n246 VDD=VDD VSS=VSS
XU228 xr02d1 $PINS A1=b[2] A2=gre_a_INV_1913_2 Z=n237 VDD=VDD VSS=VSS
XU229 xr02d1 $PINS A1=b[1] A2=gre_a_INV_1913_2 Z=n236 VDD=VDD VSS=VSS
XU230 oai22d1 $PINS A1=n221 A2=n216 B1=n214 B2=n248 ZN=n247 VDD=VDD VSS=VSS
XU231 xr02d1 $PINS A1=b[5] A2=n201 Z=n221 VDD=VDD VSS=VSS
XU232 aoim22d1 $PINS A1=n202 A2=n222 B1=n248 B2=n216 Z=n32 VDD=VDD VSS=VSS
XU233 xr02d1 $PINS A1=a[3] A2=a[2] Z=n249 VDD=VDD VSS=VSS
XU234 xr02d1 $PINS A1=b[6] A2=n201 Z=n248 VDD=VDD VSS=VSS
XU235 xr02d1 $PINS A1=b[7] A2=a[3] Z=n222 VDD=VDD VSS=VSS
XU236 aoim22d1 $PINS A1=n199 A2=n232 B1=n231 B2=n225 Z=n22 VDD=VDD VSS=VSS
XU237 xr02d1 $PINS A1=a[5] A2=a[4] Z=n250 VDD=VDD VSS=VSS
XU238 xr02d1 $PINS A1=b[6] A2=gre_a_INV_2086_2 Z=n231 VDD=VDD VSS=VSS
XU239 xr02d1 $PINS A1=b[7] A2=a[5] Z=n232 VDD=VDD VSS=VSS
XU240 aoim22d1 $PINS A1=n196 A2=n242 B1=n241 B2=n235 Z=n16 VDD=VDD VSS=VSS
XU241 xr02d1 $PINS A1=a[7] A2=a[6] Z=n251 VDD=VDD VSS=VSS
XU242 xr02d1 $PINS A1=b[6] A2=gre_a_INV_1913_2 Z=n241 VDD=VDD VSS=VSS
XU243 xr02d1 $PINS A1=b[7] A2=a[7] Z=n242 VDD=VDD VSS=VSS
XctmTdsLR_1_1277 aoim22d1 $PINS A1=n201 A2=b[0] B1=n201 B2=b[0] Z=n215 VDD=VDD
+ VSS=VSS
XctmTdsLR_1_1278 aoim22d1 $PINS A1=gre_a_INV_2086_2 A2=b[0] B1=gre_a_INV_2086_2
+ B2=b[0] Z=n224 VDD=VDD VSS=VSS
XctmTdsLR_1_1279 aoim22d1 $PINS A1=gre_a_INV_1913_2 A2=b[0] B1=gre_a_INV_1913_2
+ B2=b[0] Z=n234 VDD=VDD VSS=VSS
XctmTdsLR_1_2913 an02d1 $PINS A1=n57 A2=n67 Z=n43 VDD=VDD VSS=VSS
XctmTdsLR_2_2914 aoim21d1 $PINS B1=n57 B2=n67 A=n43 ZN=n44 VDD=VDD VSS=VSS
.ENDS

.SUBCKT unpu_pe_14_DW_mult_uns_0_DW_mult_uns_12 a[7] a[6] a[5] a[4] a[3] a[2]
+ a[1] a[0] b[7] b[6] b[5] b[4] b[3] b[2] b[1] b[0] product[15] product[14]
+ product[13] product[12] product[11] product[10] product[9] product[8]
+ product[7] product[6] product[5] product[4] product[3] product[2] product[1]
+ product[0] VDD VSS
XU2 ad01d0 $PINS A=n99 B=n15 CI=n2 CO=product[15] S=product[14] VDD=VDD VSS=VSS
XU3 ad01d0 $PINS A=n16 B=n17 CI=n3 CO=n2 S=product[13] VDD=VDD VSS=VSS
XU4 ad01d0 $PINS A=n18 B=n21 CI=n4 CO=n3 S=product[12] VDD=VDD VSS=VSS
XU5 ad01d0 $PINS A=n27 B=n22 CI=n5 CO=n4 S=product[11] VDD=VDD VSS=VSS
XU6 ad01d0 $PINS A=n35 B=n28 CI=n6 CO=n5 S=product[10] VDD=VDD VSS=VSS
XU7 ad01d0 $PINS A=n45 B=n36 CI=n7 CO=n6 S=product[9] VDD=VDD VSS=VSS
XU8 ad01d0 $PINS A=n57 B=n46 CI=n8 CO=n7 S=product[8] VDD=VDD VSS=VSS
XU9 ad01d0 $PINS A=n69 B=n58 CI=n9 CO=n8 S=product[7] VDD=VDD VSS=VSS
XU10 ad01d0 $PINS A=n79 B=n70 CI=n10 CO=n9 S=product[6] VDD=VDD VSS=VSS
XU11 ad01d0 $PINS A=n87 B=n80 CI=n11 CO=n10 S=product[5] VDD=VDD VSS=VSS
XU12 ad01d0 $PINS A=n93 B=n88 CI=n12 CO=n11 S=product[4] VDD=VDD VSS=VSS
XU13 ad01d0 $PINS A=n96 B=n13 CI=n94 CO=n12 S=product[3] VDD=VDD VSS=VSS
XU14 ad01d0 $PINS A=n146 B=n14 CI=n98 CO=n13 S=product[2] VDD=VDD VSS=VSS
XU15 ah01d1 $PINS A=n161 B=n154 CO=n14 S=product[1] VDD=VDD VSS=VSS
XU16 ad01d0 $PINS A=n107 B=n100 CI=n19 CO=n15 S=n16 VDD=VDD VSS=VSS
XU17 ad01d0 $PINS A=n25 B=n20 CI=n23 CO=n17 S=n18 VDD=VDD VSS=VSS
XU18 ad01d0 $PINS A=n115 B=n101 CI=n108 CO=n19 S=n20 VDD=VDD VSS=VSS
XU19 ad01d0 $PINS A=n31 B=n24 CI=n29 CO=n21 S=n22 VDD=VDD VSS=VSS
XU20 ad01d0 $PINS A=n116 B=n33 CI=n26 CO=n23 S=n24 VDD=VDD VSS=VSS
XU21 ad01d0 $PINS A=n123 B=n102 CI=n109 CO=n25 S=n26 VDD=VDD VSS=VSS
XU22 ad01d0 $PINS A=n32 B=n37 CI=n30 CO=n27 S=n28 VDD=VDD VSS=VSS
XU23 ad01d0 $PINS A=n41 B=n34 CI=n39 CO=n29 S=n30 VDD=VDD VSS=VSS
XU24 ad01d0 $PINS A=n124 B=n117 CI=n43 CO=n31 S=n32 VDD=VDD VSS=VSS
XU25 ad01d0 $PINS A=n131 B=n103 CI=n110 CO=n33 S=n34 VDD=VDD VSS=VSS
XU26 ad01d0 $PINS A=n40 B=n47 CI=n38 CO=n35 S=n36 VDD=VDD VSS=VSS
XU27 ad01d0 $PINS A=n44 B=n51 CI=n49 CO=n37 S=n38 VDD=VDD VSS=VSS
XU28 ad01d0 $PINS A=n55 B=n53 CI=n42 CO=n39 S=n40 VDD=VDD VSS=VSS
XU29 ad01d0 $PINS A=n118 B=n125 CI=n132 CO=n41 S=n42 VDD=VDD VSS=VSS
XU30 ad01d0 $PINS A=n139 B=n104 CI=n111 CO=n43 S=n44 VDD=VDD VSS=VSS
XU31 ad01d0 $PINS A=n50 B=n59 CI=n48 CO=n45 S=n46 VDD=VDD VSS=VSS
XU32 ad01d0 $PINS A=n54 B=n52 CI=n61 CO=n47 S=n48 VDD=VDD VSS=VSS
XU33 ad01d0 $PINS A=n56 B=n65 CI=n63 CO=n49 S=n50 VDD=VDD VSS=VSS
XU34 ad01d0 $PINS A=n140 B=n133 CI=n67 CO=n51 S=n52 VDD=VDD VSS=VSS
XU35 ad01d0 $PINS A=n126 B=n119 CI=n147 CO=n53 S=n54 VDD=VDD VSS=VSS
XU36 ah01d1 $PINS A=n105 B=n112 CO=n55 S=n56 VDD=VDD VSS=VSS
XU37 ad01d0 $PINS A=n71 B=n62 CI=n60 CO=n57 S=n58 VDD=VDD VSS=VSS
XU38 ad01d0 $PINS A=n64 B=n66 CI=n73 CO=n59 S=n60 VDD=VDD VSS=VSS
XU39 ad01d0 $PINS A=n77 B=n68 CI=n75 CO=n61 S=n62 VDD=VDD VSS=VSS
XU40 ad01d0 $PINS A=n141 B=n127 CI=n134 CO=n63 S=n64 VDD=VDD VSS=VSS
XU41 ad01d0 $PINS A=n155 B=n120 CI=n148 CO=n65 S=n66 VDD=VDD VSS=VSS
XU42 ah01d1 $PINS A=n106 B=n113 CO=n67 S=n68 VDD=VDD VSS=VSS
XU43 ad01d0 $PINS A=n81 B=n74 CI=n72 CO=n69 S=n70 VDD=VDD VSS=VSS
XU44 ad01d0 $PINS A=n78 B=n83 CI=n76 CO=n71 S=n72 VDD=VDD VSS=VSS
XU45 ad01d0 $PINS A=n142 B=n135 CI=n85 CO=n73 S=n74 VDD=VDD VSS=VSS
XU46 ad01d0 $PINS A=n156 B=n128 CI=n149 CO=n75 S=n76 VDD=VDD VSS=VSS
XU47 ah01d1 $PINS A=n114 B=n121 CO=n77 S=n78 VDD=VDD VSS=VSS
XU48 ad01d0 $PINS A=n89 B=n84 CI=n82 CO=n79 S=n80 VDD=VDD VSS=VSS
XU49 ad01d0 $PINS A=n150 B=n91 CI=n86 CO=n81 S=n82 VDD=VDD VSS=VSS
XU50 ad01d0 $PINS A=n157 B=n136 CI=n143 CO=n83 S=n84 VDD=VDD VSS=VSS
XU51 ah01d1 $PINS A=n122 B=n129 CO=n85 S=n86 VDD=VDD VSS=VSS
XU52 ad01d0 $PINS A=n95 B=n92 CI=n90 CO=n87 S=n88 VDD=VDD VSS=VSS
XU53 ad01d0 $PINS A=n158 B=n144 CI=n151 CO=n89 S=n90 VDD=VDD VSS=VSS
XU54 ah01d1 $PINS A=n130 B=n137 CO=n91 S=n92 VDD=VDD VSS=VSS
XU55 ad01d0 $PINS A=n159 B=n152 CI=n97 CO=n93 S=n94 VDD=VDD VSS=VSS
XU56 ah01d1 $PINS A=n138 B=n145 CO=n95 S=n96 VDD=VDD VSS=VSS
XU57 ah01d1 $PINS A=n153 B=n160 CO=n97 S=n98 VDD=VDD VSS=VSS
XU140 inv0d0 $PINS I=b[4] ZN=n225 VDD=VDD VSS=VSS
XU141 inv0d0 $PINS I=a[1] ZN=n220 VDD=VDD VSS=VSS
XU142 inv0d0 $PINS I=b[2] ZN=n227 VDD=VDD VSS=VSS
XU143 inv0d0 $PINS I=a[0] ZN=n221 VDD=VDD VSS=VSS
XU144 inv0d0 $PINS I=a[2] ZN=n219 VDD=VDD VSS=VSS
XU145 inv0d0 $PINS I=b[3] ZN=n226 VDD=VDD VSS=VSS
XU147 inv0d0 $PINS I=b[1] ZN=n228 VDD=VDD VSS=VSS
XU148 inv0d0 $PINS I=b[0] ZN=n229 VDD=VDD VSS=VSS
XU149 inv0d0 $PINS I=a[4] ZN=n217 VDD=VDD VSS=VSS
XU150 inv0d0 $PINS I=b[6] ZN=n223 VDD=VDD VSS=VSS
XU151 inv0d0 $PINS I=a[3] ZN=n218 VDD=VDD VSS=VSS
XU152 inv0d0 $PINS I=b[5] ZN=n224 VDD=VDD VSS=VSS
XU153 inv0d0 $PINS I=b[7] ZN=n222 VDD=VDD VSS=VSS
XU154 inv0d0 $PINS I=a[6] ZN=n215 VDD=VDD VSS=VSS
XU156 nr02d0 $PINS A1=n221 A2=n229 ZN=product[0] VDD=VDD VSS=VSS
XU157 nr02d0 $PINS A1=a[7] A2=n222 ZN=n99 VDD=VDD VSS=VSS
XU158 nr02d0 $PINS A1=n221 A2=n228 ZN=n161 VDD=VDD VSS=VSS
XU159 nr02d0 $PINS A1=n221 A2=n227 ZN=n160 VDD=VDD VSS=VSS
XU160 nr02d0 $PINS A1=n221 A2=n226 ZN=n159 VDD=VDD VSS=VSS
XU161 nr02d0 $PINS A1=n221 A2=n225 ZN=n158 VDD=VDD VSS=VSS
XU162 nr02d0 $PINS A1=n221 A2=n224 ZN=n157 VDD=VDD VSS=VSS
XU163 nr02d0 $PINS A1=n221 A2=n223 ZN=n156 VDD=VDD VSS=VSS
XU164 nr02d0 $PINS A1=n221 A2=n222 ZN=n155 VDD=VDD VSS=VSS
XU165 nr02d0 $PINS A1=n229 A2=n220 ZN=n154 VDD=VDD VSS=VSS
XU166 nr02d0 $PINS A1=n228 A2=n220 ZN=n153 VDD=VDD VSS=VSS
XU167 nr02d0 $PINS A1=n227 A2=n220 ZN=n152 VDD=VDD VSS=VSS
XU168 nr02d0 $PINS A1=n226 A2=n220 ZN=n151 VDD=VDD VSS=VSS
XU169 nr02d0 $PINS A1=n225 A2=n220 ZN=n150 VDD=VDD VSS=VSS
XU170 nr02d0 $PINS A1=n224 A2=n220 ZN=n149 VDD=VDD VSS=VSS
XU171 nr02d0 $PINS A1=n223 A2=n220 ZN=n148 VDD=VDD VSS=VSS
XU172 nr02d0 $PINS A1=n222 A2=n220 ZN=n147 VDD=VDD VSS=VSS
XU173 nr02d0 $PINS A1=n229 A2=n219 ZN=n146 VDD=VDD VSS=VSS
XU174 nr02d0 $PINS A1=n228 A2=n219 ZN=n145 VDD=VDD VSS=VSS
XU175 nr02d0 $PINS A1=n227 A2=n219 ZN=n144 VDD=VDD VSS=VSS
XU176 nr02d0 $PINS A1=n226 A2=n219 ZN=n143 VDD=VDD VSS=VSS
XU177 nr02d0 $PINS A1=n225 A2=n219 ZN=n142 VDD=VDD VSS=VSS
XU178 nr02d0 $PINS A1=n224 A2=n219 ZN=n141 VDD=VDD VSS=VSS
XU179 nr02d0 $PINS A1=n223 A2=n219 ZN=n140 VDD=VDD VSS=VSS
XU180 nr02d0 $PINS A1=n222 A2=n219 ZN=n139 VDD=VDD VSS=VSS
XU181 nr02d0 $PINS A1=n229 A2=n218 ZN=n138 VDD=VDD VSS=VSS
XU182 nr02d0 $PINS A1=n228 A2=n218 ZN=n137 VDD=VDD VSS=VSS
XU183 nr02d0 $PINS A1=n227 A2=n218 ZN=n136 VDD=VDD VSS=VSS
XU184 nr02d0 $PINS A1=n226 A2=n218 ZN=n135 VDD=VDD VSS=VSS
XU185 nr02d0 $PINS A1=n225 A2=n218 ZN=n134 VDD=VDD VSS=VSS
XU186 nr02d0 $PINS A1=n224 A2=n218 ZN=n133 VDD=VDD VSS=VSS
XU187 nr02d0 $PINS A1=n223 A2=n218 ZN=n132 VDD=VDD VSS=VSS
XU188 nr02d0 $PINS A1=n222 A2=n218 ZN=n131 VDD=VDD VSS=VSS
XU189 nr02d0 $PINS A1=n229 A2=n217 ZN=n130 VDD=VDD VSS=VSS
XU190 nr02d0 $PINS A1=n228 A2=n217 ZN=n129 VDD=VDD VSS=VSS
XU191 nr02d0 $PINS A1=n227 A2=n217 ZN=n128 VDD=VDD VSS=VSS
XU192 nr02d0 $PINS A1=n226 A2=n217 ZN=n127 VDD=VDD VSS=VSS
XU193 nr02d0 $PINS A1=n225 A2=n217 ZN=n126 VDD=VDD VSS=VSS
XU194 nr02d0 $PINS A1=n224 A2=n217 ZN=n125 VDD=VDD VSS=VSS
XU195 nr02d0 $PINS A1=n223 A2=n217 ZN=n124 VDD=VDD VSS=VSS
XU196 nr02d0 $PINS A1=n222 A2=n217 ZN=n123 VDD=VDD VSS=VSS
XU197 nr02d0 $PINS A1=n229 A2=a[5] ZN=n122 VDD=VDD VSS=VSS
XU198 nr02d0 $PINS A1=n228 A2=a[5] ZN=n121 VDD=VDD VSS=VSS
XU199 nr02d0 $PINS A1=n227 A2=a[5] ZN=n120 VDD=VDD VSS=VSS
XU200 nr02d0 $PINS A1=n226 A2=a[5] ZN=n119 VDD=VDD VSS=VSS
XU201 nr02d0 $PINS A1=n225 A2=a[5] ZN=n118 VDD=VDD VSS=VSS
XU202 nr02d0 $PINS A1=n224 A2=a[5] ZN=n117 VDD=VDD VSS=VSS
XU203 nr02d0 $PINS A1=n223 A2=a[5] ZN=n116 VDD=VDD VSS=VSS
XU204 nr02d0 $PINS A1=n222 A2=a[5] ZN=n115 VDD=VDD VSS=VSS
XU205 nr02d0 $PINS A1=n229 A2=n215 ZN=n114 VDD=VDD VSS=VSS
XU206 nr02d0 $PINS A1=n228 A2=n215 ZN=n113 VDD=VDD VSS=VSS
XU207 nr02d0 $PINS A1=n227 A2=n215 ZN=n112 VDD=VDD VSS=VSS
XU208 nr02d0 $PINS A1=n226 A2=n215 ZN=n111 VDD=VDD VSS=VSS
XU209 nr02d0 $PINS A1=n225 A2=n215 ZN=n110 VDD=VDD VSS=VSS
XU210 nr02d0 $PINS A1=n224 A2=n215 ZN=n109 VDD=VDD VSS=VSS
XU211 nr02d0 $PINS A1=n223 A2=n215 ZN=n108 VDD=VDD VSS=VSS
XU212 nr02d0 $PINS A1=n222 A2=n215 ZN=n107 VDD=VDD VSS=VSS
XU213 nr02d0 $PINS A1=n229 A2=a[7] ZN=n106 VDD=VDD VSS=VSS
XU214 nr02d0 $PINS A1=a[7] A2=n228 ZN=n105 VDD=VDD VSS=VSS
XU215 nr02d0 $PINS A1=a[7] A2=n227 ZN=n104 VDD=VDD VSS=VSS
XU216 nr02d0 $PINS A1=a[7] A2=n226 ZN=n103 VDD=VDD VSS=VSS
XU217 nr02d0 $PINS A1=a[7] A2=n225 ZN=n102 VDD=VDD VSS=VSS
XU218 nr02d0 $PINS A1=a[7] A2=n224 ZN=n101 VDD=VDD VSS=VSS
XU219 nr02d0 $PINS A1=a[7] A2=n223 ZN=n100 VDD=VDD VSS=VSS
.ENDS

.SUBCKT unpu_pe_14_DW01_add_0_DW01_add_15 A[31] A[30] A[29] A[28] A[27] A[26]
+ A[25] A[24] A[23] A[22] A[21] A[20] A[19] A[18] A[17] A[16] A[15] A[14] A[13]
+ A[12] A[11] A[10] A[9] A[8] A[7] A[6] A[5] A[4] A[3] A[2] A[1] A[0] B[31]
+ B[30] B[29] B[28] B[27] B[26] B[25] B[24] B[23] B[22] B[21] B[20] B[19] B[18]
+ B[17] B[16] B[15] B[14] B[13] B[12] B[11] B[10] B[9] B[8] B[7] B[6] B[5] B[4]
+ B[3] B[2] B[1] B[0] CI SUM[31] SUM[30] SUM[29] SUM[28] SUM[27] SUM[26]
+ SUM[25] SUM[24] SUM[23] SUM[22] SUM[21] SUM[20] SUM[19] SUM[18] SUM[17]
+ SUM[16] SUM[15] SUM[14] SUM[13] SUM[12] SUM[11] SUM[10] SUM[9] SUM[8] SUM[7]
+ SUM[6] SUM[5] SUM[4] SUM[3] SUM[2] SUM[1] SUM[0] CO VDD VSS
*.CONNECT SUM[0] B[0]
XU1_31 ad01d0 $PINS A=A[31] B=B[31] CI=carry[31] S=SUM[31] VDD=VDD VSS=VSS
XU1_13 ad01d0 $PINS A=A[13] B=B[13] CI=carry[13] CO=carry[14] S=SUM[13] VDD=VDD
+ VSS=VSS
XU1_12 ad01d0 $PINS A=A[12] B=B[12] CI=carry[12] CO=carry[13] S=SUM[12] VDD=VDD
+ VSS=VSS
XU1_11 ad01d0 $PINS A=A[11] B=B[11] CI=carry[11] CO=carry[12] S=SUM[11] VDD=VDD
+ VSS=VSS
XU1_10 ad01d0 $PINS A=A[10] B=B[10] CI=carry[10] CO=carry[11] S=SUM[10] VDD=VDD
+ VSS=VSS
XU1_9 ad01d0 $PINS A=A[9] B=B[9] CI=carry[9] CO=carry[10] S=SUM[9] VDD=VDD
+ VSS=VSS
XU1_8 ad01d0 $PINS A=A[8] B=B[8] CI=carry[8] CO=carry[9] S=SUM[8] VDD=VDD
+ VSS=VSS
XU1_7 ad01d0 $PINS A=A[7] B=B[7] CI=carry[7] CO=carry[8] S=SUM[7] VDD=VDD
+ VSS=VSS
XU1_6 ad01d0 $PINS A=A[6] B=B[6] CI=carry[6] CO=carry[7] S=SUM[6] VDD=VDD
+ VSS=VSS
XU1_5 ad01d0 $PINS A=A[5] B=B[5] CI=carry[5] CO=carry[6] S=SUM[5] VDD=VDD
+ VSS=VSS
XU1_4 ad01d0 $PINS A=A[4] B=B[4] CI=carry[4] CO=carry[5] S=SUM[4] VDD=VDD
+ VSS=VSS
XU1_3 ad01d0 $PINS A=A[3] B=B[3] CI=carry[3] CO=carry[4] S=SUM[3] VDD=VDD
+ VSS=VSS
XU1_1 ad01d0 $PINS A=A[1] B=B[1] CI=VSS CO=carry[2] S=SUM[1] VDD=VDD VSS=VSS
XU1_2 ad01d0 $PINS A=A[2] B=B[2] CI=carry[2] CO=carry[3] S=SUM[2] VDD=VDD
+ VSS=VSS
XU1_14 ad01d0 $PINS A=A[14] B=B[14] CI=carry[14] CO=carry[15] S=SUM[14] VDD=VDD
+ VSS=VSS
XU1_15 ad01d0 $PINS A=A[15] B=B[15] CI=carry[15] CO=carry[16] S=SUM[15] VDD=VDD
+ VSS=VSS
XU1_30 ad01d0 $PINS A=A[30] B=B[30] CI=carry[30] CO=carry[31] S=SUM[30] VDD=VDD
+ VSS=VSS
XU1_29 ad01d0 $PINS A=A[29] B=B[29] CI=carry[29] CO=carry[30] S=SUM[29] VDD=VDD
+ VSS=VSS
XU1_28 ad01d0 $PINS A=A[28] B=B[28] CI=carry[28] CO=carry[29] S=SUM[28] VDD=VDD
+ VSS=VSS
XU1_27 ad01d0 $PINS A=A[27] B=B[27] CI=carry[27] CO=carry[28] S=SUM[27] VDD=VDD
+ VSS=VSS
XU1_26 ad01d0 $PINS A=A[26] B=B[26] CI=carry[26] CO=carry[27] S=SUM[26] VDD=VDD
+ VSS=VSS
XU1_25 ad01d0 $PINS A=A[25] B=B[25] CI=carry[25] CO=carry[26] S=SUM[25] VDD=VDD
+ VSS=VSS
XU1_24 ad01d0 $PINS A=A[24] B=B[24] CI=carry[24] CO=carry[25] S=SUM[24] VDD=VDD
+ VSS=VSS
XU1_23 ad01d0 $PINS A=A[23] B=B[23] CI=carry[23] CO=carry[24] S=SUM[23] VDD=VDD
+ VSS=VSS
XU1_22 ad01d0 $PINS A=A[22] B=B[22] CI=carry[22] CO=carry[23] S=SUM[22] VDD=VDD
+ VSS=VSS
XU1_21 ad01d0 $PINS A=A[21] B=B[21] CI=carry[21] CO=carry[22] S=SUM[21] VDD=VDD
+ VSS=VSS
XU1_20 ad01d0 $PINS A=A[20] B=B[20] CI=carry[20] CO=carry[21] S=SUM[20] VDD=VDD
+ VSS=VSS
XU1_19 ad01d0 $PINS A=A[19] B=B[19] CI=carry[19] CO=carry[20] S=SUM[19] VDD=VDD
+ VSS=VSS
XU1_18 ad01d0 $PINS A=A[18] B=B[18] CI=carry[18] CO=carry[19] S=SUM[18] VDD=VDD
+ VSS=VSS
XU1_17 ad01d0 $PINS A=A[17] B=B[17] CI=carry[17] CO=carry[18] S=SUM[17] VDD=VDD
+ VSS=VSS
XU1_16 ad01d0 $PINS A=A[16] B=B[16] CI=carry[16] CO=carry[17] S=SUM[16] VDD=VDD
+ VSS=VSS
.ENDS

.SUBCKT unpu_pe_14 ZCTSNET_8 rst_n array_en weight_load mode_unsigned
+ weight_in[7] weight_in[6] weight_in[5] weight_in[4] weight_in[3] weight_in[2]
+ weight_in[1] weight_in[0] act_in[7] act_in[6] act_in[5] act_in[4] act_in[3]
+ act_in[2] act_in[1] act_in[0] psum_in[31] psum_in[30] psum_in[29] psum_in[28]
+ psum_in[27] psum_in[26] psum_in[25] psum_in[24] psum_in[23] psum_in[22]
+ psum_in[21] psum_in[20] psum_in[19] psum_in[18] psum_in[17] psum_in[16]
+ psum_in[15] psum_in[14] psum_in[13] psum_in[12] psum_in[11] psum_in[10]
+ psum_in[9] psum_in[8] psum_in[7] psum_in[6] psum_in[5] psum_in[4] psum_in[3]
+ psum_in[2] psum_in[1] psum_in[0] act_out[7] act_out[6] act_out[5] act_out[4]
+ act_out[3] act_out[2] act_out[1] act_out[0] psum_out[31] psum_out[30]
+ psum_out[29] psum_out[28] psum_out[27] psum_out[26] psum_out[25] psum_out[24]
+ psum_out[23] psum_out[22] psum_out[21] psum_out[20] psum_out[19] psum_out[18]
+ psum_out[17] psum_out[16] psum_out[15] psum_out[14] psum_out[13] psum_out[12]
+ psum_out[11] psum_out[10] psum_out[9] psum_out[8] psum_out[7] psum_out[6]
+ psum_out[5] psum_out[4] psum_out[3] psum_out[2] psum_out[1] psum_out[0] VDD
+ VSS HFSNET_2 HFSNET_3 HFSNET_4 HFSNET_5 HFSNET_7 ZCTSNET_1
XU2 aor22d1 $PINS A1=N_uc_30 A2=mode_unsigned B1=HFSNET_1 B2=N_uc_14
+ Z=product[9] VDD=VDD VSS=VSS
XU3 aor22d1 $PINS A1=N_uc_29 A2=mode_unsigned B1=N_uc_13 B2=HFSNET_1
+ Z=product[8] VDD=VDD VSS=VSS
XU5 aor22d1 $PINS A1=N_uc_28 A2=mode_unsigned B1=N_uc_12 B2=HFSNET_1
+ Z=product[7] VDD=VDD VSS=VSS
XU6 aor22d1 $PINS A1=N_uc_27 A2=mode_unsigned B1=N_uc_11 B2=HFSNET_1
+ Z=product[6] VDD=VDD VSS=VSS
XU7 aor22d1 $PINS A1=N_uc_26 A2=mode_unsigned B1=N_uc_10 B2=HFSNET_1
+ Z=product[5] VDD=VDD VSS=VSS
XU8 aor22d1 $PINS A1=N_uc_9 A2=HFSNET_1 B1=N_uc_25 B2=mode_unsigned
+ Z=product[4] VDD=VDD VSS=VSS
XU9 aor22d1 $PINS A1=N_uc_8 A2=HFSNET_1 B1=N_uc_24 B2=mode_unsigned
+ Z=product[3] VDD=VDD VSS=VSS
XU10 aor22d1 $PINS A1=N_uc_7 A2=HFSNET_1 B1=N_uc_23 B2=mode_unsigned
+ Z=product[2] VDD=VDD VSS=VSS
XU11 aor22d1 $PINS A1=N_uc_6 A2=HFSNET_1 B1=N_uc_22 B2=mode_unsigned
+ Z=product[1] VDD=VDD VSS=VSS
XU12 oaim21d1 $PINS B1=N_uc_20 B2=HFSNET_1 A=n12 ZN=product[15] VDD=VDD VSS=VSS
XU13 aor22d1 $PINS A1=N_uc_35 A2=mode_unsigned B1=N_uc_19 B2=HFSNET_1
+ Z=product[14] VDD=VDD VSS=VSS
XU14 aor22d1 $PINS A1=N_uc_34 A2=mode_unsigned B1=N_uc_18 B2=HFSNET_1
+ Z=product[13] VDD=VDD VSS=VSS
XU15 aor22d1 $PINS A1=N_uc_33 A2=mode_unsigned B1=N_uc_17 B2=HFSNET_1
+ Z=product[12] VDD=VDD VSS=VSS
XU16 aor22d1 $PINS A1=N_uc_32 A2=mode_unsigned B1=N_uc_16 B2=HFSNET_1
+ Z=product[11] VDD=VDD VSS=VSS
XU17 aor22d1 $PINS A1=N_uc_31 A2=mode_unsigned B1=N_uc_15 B2=HFSNET_1
+ Z=product[10] VDD=VDD VSS=VSS
XU18 aor22d1 $PINS A1=N_uc_5 A2=HFSNET_1 B1=N_uc_21 B2=mode_unsigned
+ Z=product[0] VDD=VDD VSS=VSS
Xadd_42 unpu_pe_14_DW01_add_0_DW01_add_15 $PINS A[31]=psum_in[31]
+ A[30]=psum_in[30] A[29]=psum_in[29] A[28]=psum_in[28] A[27]=psum_in[27]
+ A[26]=psum_in[26] A[25]=psum_in[25] A[24]=psum_in[24] A[23]=psum_in[23]
+ A[22]=psum_in[22] A[21]=psum_in[21] A[20]=psum_in[20] A[19]=psum_in[19]
+ A[18]=psum_in[18] A[17]=psum_in[17] A[16]=psum_in[16] A[15]=psum_in[15]
+ A[14]=psum_in[14] A[13]=psum_in[13] A[12]=psum_in[12] A[11]=psum_in[11]
+ A[10]=psum_in[10] A[9]=psum_in[9] A[8]=psum_in[8] A[7]=psum_in[7]
+ A[6]=psum_in[6] A[5]=psum_in[5] A[4]=psum_in[4] A[3]=psum_in[3] A[2]=psum_in[2]
+ A[1]=psum_in[1] A[0]=psum_in[0] B[31]=n2 B[30]=n2 B[29]=n2 B[28]=n2 B[27]=n2
+ B[26]=n2 B[25]=n2 B[24]=n2 B[23]=n2 B[22]=n2 B[21]=n2 B[20]=n2 B[19]=n2
+ B[18]=n2 B[17]=n2 B[16]=n2 B[15]=product[15] B[14]=product[14]
+ B[13]=product[13] B[12]=product[12] B[11]=product[11] B[10]=product[10]
+ B[9]=product[9] B[8]=product[8] B[7]=product[7] B[6]=product[6] B[5]=product[5]
+ B[4]=product[4] B[3]=product[3] B[2]=product[2] B[1]=product[1] B[0]=product[0]
+ CI=VSS SUM[31]=N_uc_71 SUM[30]=N_uc_70 SUM[29]=N_uc_69 SUM[28]=N_uc_68
+ SUM[27]=N_uc_67 SUM[26]=N_uc_66 SUM[25]=N_uc_65 SUM[24]=N_uc_64 SUM[23]=N_uc_63
+ SUM[22]=N_uc_62 SUM[21]=N_uc_61 SUM[20]=N_uc_60 SUM[19]=N_uc_59 SUM[18]=N_uc_58
+ SUM[17]=N_uc_57 SUM[16]=N_uc_56 SUM[15]=N_uc_55 SUM[14]=N_uc_54 SUM[13]=N_uc_53
+ SUM[12]=N_uc_52 SUM[11]=N_uc_51 SUM[10]=N_uc_50 SUM[9]=N_uc_49 SUM[8]=N_uc_48
+ SUM[7]=N_uc_47 SUM[6]=N_uc_46 SUM[5]=N_uc_45 SUM[4]=N_uc_44 SUM[3]=N_uc_43
+ SUM[2]=N_uc_42 SUM[1]=N_uc_41 SUM[0]=N_uc_40 VDD=VDD VSS=VSS
Xmult_28 unpu_pe_14_DW_mult_uns_0_DW_mult_uns_12 $PINS a[7]=gre_a_INV_1913_3
+ a[6]=weight_reg[6] a[5]=gre_a_INV_2086_3 a[4]=weight_reg[4] a[3]=weight_reg[3]
+ a[2]=weight_reg[2] a[1]=weight_reg[1] a[0]=weight_reg[0] b[7]=act_in[7]
+ b[6]=act_in[6] b[5]=act_in[5] b[4]=act_in[4] b[3]=act_in[3] b[2]=act_in[2]
+ b[1]=act_in[1] b[0]=act_in[0] product[15]=N_uc_20 product[14]=N_uc_19
+ product[13]=N_uc_18 product[12]=N_uc_17 product[11]=N_uc_16 product[10]=N_uc_15
+ product[9]=N_uc_14 product[8]=N_uc_13 product[7]=N_uc_12 product[6]=N_uc_11
+ product[5]=N_uc_10 product[4]=N_uc_9 product[3]=N_uc_8 product[2]=N_uc_7
+ product[1]=N_uc_6 product[0]=N_uc_5 VDD=VDD VSS=VSS
Xmult_30 unpu_pe_14_DW_mult_tc_0_DW_mult_tc_11 $PINS a[7]=weight_reg[7]
+ a[6]=weight_reg[6] a[5]=weight_reg[5] a[4]=weight_reg[4] a[3]=weight_reg[3]
+ a[2]=weight_reg[2] a[1]=weight_reg[1] a[0]=weight_reg[0] b[7]=act_in[7]
+ b[6]=act_in[6] b[5]=act_in[5] b[4]=act_in[4] b[3]=act_in[3] b[2]=act_in[2]
+ b[1]=act_in[1] b[0]=act_in[0] product[15]=N_uc_36 product[14]=N_uc_35
+ product[13]=N_uc_34 product[12]=N_uc_33 product[11]=N_uc_32 product[10]=N_uc_31
+ product[9]=N_uc_30 product[8]=N_uc_29 product[7]=N_uc_28 product[6]=N_uc_27
+ product[5]=N_uc_26 product[4]=N_uc_25 product[3]=N_uc_24 product[2]=N_uc_23
+ product[1]=N_uc_22 product[0]=N_uc_21 VDD=VDD VSS=VSS
+ gre_a_INV_1913_2=gre_a_INV_1913_3 gre_a_INV_2086_2=gre_a_INV_2086_3
Xact_out_reg_3_ decrq1 $PINS D=act_in[3] ENN=HFSNET_3 CP=ZCTSNET_1 CDN=HFSNET_5
+ Q=act_out[3] VDD=VDD VSS=VSS
Xact_out_reg_2_ decrq1 $PINS D=act_in[2] ENN=HFSNET_3 CP=ZCTSNET_1 CDN=HFSNET_5
+ Q=act_out[2] VDD=VDD VSS=VSS
Xact_out_reg_1_ decrq1 $PINS D=copt_net_335 ENN=HFSNET_3 CP=ZCTSNET_1
+ CDN=HFSNET_6 Q=act_out[1] VDD=VDD VSS=VSS
Xact_out_reg_7_ decrq1 $PINS D=act_in[7] ENN=HFSNET_3 CP=ZCTSNET_1 CDN=HFSNET_5
+ Q=act_out[7] VDD=VDD VSS=VSS
Xact_out_reg_6_ decrq1 $PINS D=act_in[6] ENN=HFSNET_3 CP=ZCTSNET_1 CDN=HFSNET_6
+ Q=act_out[6] VDD=VDD VSS=VSS
Xact_out_reg_5_ decrq1 $PINS D=copt_net_742 ENN=HFSNET_3 CP=ZCTSNET_1
+ CDN=HFSNET_5 Q=act_out[5] VDD=VDD VSS=VSS
Xact_out_reg_4_ decrq1 $PINS D=act_in[4] ENN=HFSNET_3 CP=ZCTSNET_1 CDN=HFSNET_5
+ Q=act_out[4] VDD=VDD VSS=VSS
Xact_out_reg_0_ decrq1 $PINS D=copt_net_310 ENN=HFSNET_3 CP=ZCTSNET_1
+ CDN=HFSNET_6 Q=act_out[0] VDD=VDD VSS=VSS
Xpsum_out_reg_8_ decrq1 $PINS D=N_uc_48 ENN=array_en CP=ZCTSNET_8 CDN=rst_n
+ Q=psum_out[8] VDD=VDD VSS=VSS
Xpsum_out_reg_7_ decrq1 $PINS D=N_uc_47 ENN=array_en CP=ZCTSNET_8 CDN=rst_n
+ Q=psum_out[7] VDD=VDD VSS=VSS
Xpsum_out_reg_6_ decrq1 $PINS D=N_uc_46 ENN=array_en CP=ZCTSNET_8 CDN=rst_n
+ Q=psum_out[6] VDD=VDD VSS=VSS
Xpsum_out_reg_5_ decrq1 $PINS D=N_uc_45 ENN=array_en CP=ZCTSNET_8 CDN=rst_n
+ Q=psum_out[5] VDD=VDD VSS=VSS
Xpsum_out_reg_4_ decrq1 $PINS D=N_uc_44 ENN=array_en CP=ZCTSNET_8 CDN=rst_n
+ Q=psum_out[4] VDD=VDD VSS=VSS
Xpsum_out_reg_3_ decrq1 $PINS D=N_uc_43 ENN=array_en CP=ZCTSNET_8 CDN=rst_n
+ Q=psum_out[3] VDD=VDD VSS=VSS
Xpsum_out_reg_2_ decrq1 $PINS D=N_uc_42 ENN=array_en CP=ZCTSNET_8 CDN=rst_n
+ Q=psum_out[2] VDD=VDD VSS=VSS
Xpsum_out_reg_1_ decrq1 $PINS D=N_uc_41 ENN=array_en CP=ZCTSNET_8 CDN=HFSNET_6
+ Q=psum_out[1] VDD=VDD VSS=VSS
Xpsum_out_reg_0_ decrq1 $PINS D=N_uc_40 ENN=HFSNET_3 CP=ZCTSNET_1 CDN=HFSNET_6
+ Q=psum_out[0] VDD=VDD VSS=VSS
Xpsum_out_reg_9_ decrq1 $PINS D=N_uc_49 ENN=array_en CP=ZCTSNET_8 CDN=rst_n
+ Q=psum_out[9] VDD=VDD VSS=VSS
Xpsum_out_reg_10_ decrq1 $PINS D=N_uc_50 ENN=array_en CP=ZCTSNET_8 CDN=rst_n
+ Q=psum_out[10] VDD=VDD VSS=VSS
Xpsum_out_reg_11_ decrq1 $PINS D=N_uc_51 ENN=array_en CP=ZCTSNET_8 CDN=rst_n
+ Q=psum_out[11] VDD=VDD VSS=VSS
Xweight_reg_reg_7_ decrq1 $PINS D=weight_in[7] ENN=n11 CP=ZCTSNET_1
+ CDN=HFSNET_6 Q=weight_reg[7] VDD=VDD VSS=VSS
Xweight_reg_reg_6_ decrq1 $PINS D=weight_in[6] ENN=n11 CP=ZCTSNET_1
+ CDN=HFSNET_6 Q=weight_reg[6] VDD=VDD VSS=VSS
Xweight_reg_reg_5_ decrq1 $PINS D=weight_in[5] ENN=n11 CP=ZCTSNET_1
+ CDN=HFSNET_6 Q=weight_reg[5] VDD=VDD VSS=VSS
Xweight_reg_reg_4_ decrq1 $PINS D=weight_in[4] ENN=n11 CP=ZCTSNET_1
+ CDN=HFSNET_6 Q=weight_reg[4] VDD=VDD VSS=VSS
Xweight_reg_reg_3_ decrq1 $PINS D=weight_in[3] ENN=n11 CP=ZCTSNET_1
+ CDN=HFSNET_6 Q=weight_reg[3] VDD=VDD VSS=VSS
Xweight_reg_reg_2_ decrq1 $PINS D=weight_in[2] ENN=n11 CP=ZCTSNET_1
+ CDN=HFSNET_6 Q=weight_reg[2] VDD=VDD VSS=VSS
Xweight_reg_reg_1_ decrq1 $PINS D=weight_in[1] ENN=n11 CP=ZCTSNET_1
+ CDN=HFSNET_6 Q=weight_reg[1] VDD=VDD VSS=VSS
Xweight_reg_reg_0_ decrq1 $PINS D=weight_in[0] ENN=n11 CP=ZCTSNET_1
+ CDN=HFSNET_5 Q=weight_reg[0] VDD=VDD VSS=VSS
Xpsum_out_reg_12_ decrq1 $PINS D=N_uc_52 ENN=array_en CP=ZCTSNET_8 CDN=rst_n
+ Q=psum_out[12] VDD=VDD VSS=VSS
Xpsum_out_reg_13_ decrq1 $PINS D=N_uc_53 ENN=array_en CP=ZCTSNET_8 CDN=rst_n
+ Q=psum_out[13] VDD=VDD VSS=VSS
Xpsum_out_reg_14_ decrq1 $PINS D=N_uc_54 ENN=array_en CP=ZCTSNET_8 CDN=HFSNET_6
+ Q=psum_out[14] VDD=VDD VSS=VSS
Xpsum_out_reg_15_ decrq1 $PINS D=N_uc_55 ENN=array_en CP=ZCTSNET_8 CDN=rst_n
+ Q=psum_out[15] VDD=VDD VSS=VSS
Xpsum_out_reg_31_ decrq1 $PINS D=N_uc_71 ENN=HFSNET_3 CP=ZCTSNET_1 CDN=HFSNET_6
+ Q=psum_out[31] VDD=VDD VSS=VSS
Xpsum_out_reg_30_ decrq1 $PINS D=N_uc_70 ENN=HFSNET_3 CP=ZCTSNET_1 CDN=HFSNET_6
+ Q=psum_out[30] VDD=VDD VSS=VSS
Xpsum_out_reg_29_ decrq1 $PINS D=N_uc_69 ENN=array_en CP=ZCTSNET_8 CDN=HFSNET_6
+ Q=psum_out[29] VDD=VDD VSS=VSS
Xpsum_out_reg_28_ decrq1 $PINS D=N_uc_68 ENN=array_en CP=ZCTSNET_8 CDN=HFSNET_6
+ Q=psum_out[28] VDD=VDD VSS=VSS
Xpsum_out_reg_27_ decrq1 $PINS D=N_uc_67 ENN=array_en CP=ZCTSNET_8 CDN=rst_n
+ Q=psum_out[27] VDD=VDD VSS=VSS
Xpsum_out_reg_26_ decrq1 $PINS D=N_uc_66 ENN=HFSNET_3 CP=ZCTSNET_1 CDN=HFSNET_6
+ Q=psum_out[26] VDD=VDD VSS=VSS
Xpsum_out_reg_25_ decrq1 $PINS D=N_uc_65 ENN=HFSNET_3 CP=ZCTSNET_1 CDN=HFSNET_6
+ Q=psum_out[25] VDD=VDD VSS=VSS
Xpsum_out_reg_24_ decrq1 $PINS D=N_uc_64 ENN=HFSNET_3 CP=ZCTSNET_1 CDN=HFSNET_5
+ Q=psum_out[24] VDD=VDD VSS=VSS
Xpsum_out_reg_23_ decrq1 $PINS D=N_uc_63 ENN=HFSNET_3 CP=ZCTSNET_1 CDN=HFSNET_5
+ Q=psum_out[23] VDD=VDD VSS=VSS
Xpsum_out_reg_22_ decrq1 $PINS D=N_uc_62 ENN=HFSNET_3 CP=ZCTSNET_1 CDN=HFSNET_6
+ Q=psum_out[22] VDD=VDD VSS=VSS
Xpsum_out_reg_21_ decrq1 $PINS D=N_uc_61 ENN=HFSNET_3 CP=ZCTSNET_1 CDN=HFSNET_6
+ Q=psum_out[21] VDD=VDD VSS=VSS
Xpsum_out_reg_20_ decrq1 $PINS D=N_uc_60 ENN=array_en CP=ZCTSNET_8 CDN=rst_n
+ Q=psum_out[20] VDD=VDD VSS=VSS
Xpsum_out_reg_19_ decrq1 $PINS D=N_uc_59 ENN=array_en CP=ZCTSNET_8 CDN=rst_n
+ Q=psum_out[19] VDD=VDD VSS=VSS
Xpsum_out_reg_18_ decrq1 $PINS D=N_uc_58 ENN=array_en CP=ZCTSNET_8 CDN=rst_n
+ Q=psum_out[18] VDD=VDD VSS=VSS
Xpsum_out_reg_17_ decrq1 $PINS D=N_uc_57 ENN=array_en CP=ZCTSNET_8 CDN=HFSNET_6
+ Q=psum_out[17] VDD=VDD VSS=VSS
Xpsum_out_reg_16_ decrq1 $PINS D=N_uc_56 ENN=array_en CP=ZCTSNET_8 CDN=HFSNET_6
+ Q=psum_out[16] VDD=VDD VSS=VSS
XU19 inv0d2 $PINS I=n12 ZN=n2 VDD=VDD VSS=VSS
XHFSINV_1803_684 inv0d1 $PINS I=HFSNET_7 ZN=HFSNET_6 VDD=VDD VSS=VSS
XHFSINV_10992_547 inv0d1 $PINS I=HFSNET_2 ZN=HFSNET_1 VDD=VDD VSS=VSS
Xcopt_h_inst_3140 dl01d1 $PINS I=act_in[0] Z=copt_net_310 VDD=VDD VSS=VSS
Xcopt_h_inst_3165 dl01d1 $PINS I=act_in[1] Z=copt_net_335 VDD=VDD VSS=VSS
XU24 nd02d1 $PINS A1=N_uc_36 A2=mode_unsigned ZN=n12 VDD=VDD VSS=VSS
XU25 nd02d1 $PINS A1=weight_load A2=HFSNET_4 ZN=n11 VDD=VDD VSS=VSS
Xcopt_h_inst_3573 dl01d1 $PINS I=act_in[5] Z=copt_net_742 VDD=VDD VSS=VSS
Xgre_a_INV_1913_inst_5802 inv0d1 $PINS I=weight_reg[7] ZN=gre_a_INV_1913_3
+ VDD=VDD VSS=VSS
Xgre_a_INV_2086_inst_5831 inv0d1 $PINS I=weight_reg[5] ZN=gre_a_INV_2086_3
+ VDD=VDD VSS=VSS
.ENDS

.SUBCKT unpu_pe_15_DW_mult_tc_0_DW_mult_tc_15 a[7] a[6] a[5] a[4] a[3] a[2]
+ a[1] a[0] b[7] b[6] b[5] b[4] b[3] b[2] b[1] b[0] product[15] product[14]
+ product[13] product[12] product[11] product[10] product[9] product[8]
+ product[7] product[6] product[5] product[4] product[3] product[2] product[1]
+ product[0] VDD VSS
XU2 ad01d0 $PINS A=n194 B=n61 CI=n2 CO=n1 S=product[14] VDD=VDD VSS=VSS
XU3 ad01d0 $PINS A=n17 B=n16 CI=n3 CO=n2 S=product[13] VDD=VDD VSS=VSS
XU4 ad01d0 $PINS A=n18 B=n19 CI=n4 CO=n3 S=product[12] VDD=VDD VSS=VSS
XU5 ad01d0 $PINS A=n20 B=n23 CI=n5 CO=n4 S=product[11] VDD=VDD VSS=VSS
XU6 ad01d0 $PINS A=n27 B=n24 CI=n6 CO=n5 S=product[10] VDD=VDD VSS=VSS
XU7 ad01d0 $PINS A=n33 B=n28 CI=n7 CO=n6 S=product[9] VDD=VDD VSS=VSS
XU8 ad01d0 $PINS A=n39 B=n34 CI=n8 CO=n7 S=product[8] VDD=VDD VSS=VSS
XU9 ad01d0 $PINS A=n45 B=n40 CI=n9 CO=n8 S=product[7] VDD=VDD VSS=VSS
XU10 ad01d0 $PINS A=n49 B=n46 CI=n10 CO=n9 S=product[6] VDD=VDD VSS=VSS
XU11 ad01d0 $PINS A=n53 B=n50 CI=n11 CO=n10 S=product[5] VDD=VDD VSS=VSS
XU12 ad01d0 $PINS A=n55 B=n54 CI=n12 CO=n11 S=product[4] VDD=VDD VSS=VSS
XU13 ad01d0 $PINS A=n59 B=n56 CI=n13 CO=n12 S=product[3] VDD=VDD VSS=VSS
XU14 ad01d0 $PINS A=n84 B=n91 CI=n14 CO=n13 S=product[2] VDD=VDD VSS=VSS
XctmTdsLR_1_2903 an02d1 $PINS A1=n83 A2=n90 Z=n55 VDD=VDD VSS=VSS
XU17 ad01d0 $PINS A=n197 B=n62 CI=n69 CO=n17 S=n18 VDD=VDD VSS=VSS
XU18 ad01d0 $PINS A=n63 B=n25 CI=n22 CO=n19 S=n20 VDD=VDD VSS=VSS
XU20 ad01d0 $PINS A=n64 B=n26 CI=n29 CO=n23 S=n24 VDD=VDD VSS=VSS
XU21 ad01d0 $PINS A=n200 B=n70 CI=n77 CO=n25 S=n26 VDD=VDD VSS=VSS
XU22 ad01d0 $PINS A=n32 B=n35 CI=n30 CO=n27 S=n28 VDD=VDD VSS=VSS
XU23 ad01d0 $PINS A=n71 B=n65 CI=n37 CO=n29 S=n30 VDD=VDD VSS=VSS
XU25 ad01d0 $PINS A=n38 B=n41 CI=n36 CO=n33 S=n34 VDD=VDD VSS=VSS
XU26 ad01d0 $PINS A=n72 B=n85 CI=n43 CO=n35 S=n36 VDD=VDD VSS=VSS
XU29 ad01d0 $PINS A=n44 B=n47 CI=n42 CO=n39 S=n40 VDD=VDD VSS=VSS
XU30 ad01d0 $PINS A=n86 B=n73 CI=n79 CO=n41 S=n42 VDD=VDD VSS=VSS
XU31 ah01d1 $PINS A=n57 B=n67 CO=n43 S=n44 VDD=VDD VSS=VSS
XU32 ad01d0 $PINS A=n74 B=n51 CI=n48 CO=n45 S=n46 VDD=VDD VSS=VSS
XU33 ad01d0 $PINS A=n68 B=n87 CI=n80 CO=n47 S=n48 VDD=VDD VSS=VSS
XU34 ad01d0 $PINS A=n88 B=n81 CI=n52 CO=n49 S=n50 VDD=VDD VSS=VSS
XU35 ah01d1 $PINS A=n58 B=n75 CO=n51 S=n52 VDD=VDD VSS=VSS
XU36 ad01d0 $PINS A=n76 B=n89 CI=n82 CO=n53 S=n54 VDD=VDD VSS=VSS
XU145 oai21d1 $PINS B1=n202 B2=n249 A=n222 ZN=n77 VDD=VDD VSS=VSS
XU146 oai21d1 $PINS B1=n199 B2=n250 A=n232 ZN=n69 VDD=VDD VSS=VSS
XU147 oai21d1 $PINS B1=n196 B2=n251 A=n242 ZN=n61 VDD=VDD VSS=VSS
XU148 inv0d0 $PINS I=b[0] ZN=n205 VDD=VDD VSS=VSS
XU149 inv0d0 $PINS I=n16 ZN=n194 VDD=VDD VSS=VSS
XU150 inv0d0 $PINS I=n32 ZN=n200 VDD=VDD VSS=VSS
XU151 inv0d0 $PINS I=n22 ZN=n197 VDD=VDD VSS=VSS
XU152 inv0d0 $PINS I=n223 ZN=n199 VDD=VDD VSS=VSS
XU153 inv0d0 $PINS I=n214 ZN=n202 VDD=VDD VSS=VSS
XU154 inv0d0 $PINS I=n233 ZN=n196 VDD=VDD VSS=VSS
XU155 nd02d1 $PINS A1=n214 A2=n249 ZN=n216 VDD=VDD VSS=VSS
XU156 xr02d1 $PINS A1=a[2] A2=n203 Z=n214 VDD=VDD VSS=VSS
XU157 inv0d1 $PINS I=a[1] ZN=n203 VDD=VDD VSS=VSS
XU158 nd02d1 $PINS A1=n223 A2=n250 ZN=n225 VDD=VDD VSS=VSS
XU159 xr02d1 $PINS A1=a[4] A2=n201 Z=n223 VDD=VDD VSS=VSS
XU160 inv0d1 $PINS I=a[3] ZN=n201 VDD=VDD VSS=VSS
XU161 nd02d1 $PINS A1=a[1] A2=n204 ZN=n206 VDD=VDD VSS=VSS
XU162 inv0d1 $PINS I=a[0] ZN=n204 VDD=VDD VSS=VSS
XU163 xr02d1 $PINS A1=a[6] A2=n198 Z=n233 VDD=VDD VSS=VSS
XU164 inv0d1 $PINS I=a[5] ZN=n198 VDD=VDD VSS=VSS
XU165 nd02d1 $PINS A1=n233 A2=n251 ZN=n235 VDD=VDD VSS=VSS
XU166 inv0d1 $PINS I=a[7] ZN=n195 VDD=VDD VSS=VSS
XU167 inv0d0 $PINS I=n1 ZN=product[15] VDD=VDD VSS=VSS
XU168 nr02d0 $PINS A1=n204 A2=n205 ZN=product[0] VDD=VDD VSS=VSS
XU169 oai22d1 $PINS A1=b[0] A2=n206 B1=n207 B2=n204 ZN=n92 VDD=VDD VSS=VSS
XU170 oai22d1 $PINS A1=n207 A2=n206 B1=n208 B2=n204 ZN=n91 VDD=VDD VSS=VSS
XU171 xr02d1 $PINS A1=b[1] A2=n203 Z=n207 VDD=VDD VSS=VSS
XU172 oai22d1 $PINS A1=n208 A2=n206 B1=n209 B2=n204 ZN=n90 VDD=VDD VSS=VSS
XU173 xr02d1 $PINS A1=b[2] A2=n203 Z=n208 VDD=VDD VSS=VSS
XU174 oai22d1 $PINS A1=n209 A2=n206 B1=n210 B2=n204 ZN=n89 VDD=VDD VSS=VSS
XU175 xr02d1 $PINS A1=b[3] A2=n203 Z=n209 VDD=VDD VSS=VSS
XU176 oai22d1 $PINS A1=n210 A2=n206 B1=n211 B2=n204 ZN=n88 VDD=VDD VSS=VSS
XU177 xr02d1 $PINS A1=b[4] A2=n203 Z=n210 VDD=VDD VSS=VSS
XU178 oai22d1 $PINS A1=n211 A2=n206 B1=n212 B2=n204 ZN=n87 VDD=VDD VSS=VSS
XU179 xr02d1 $PINS A1=b[5] A2=n203 Z=n211 VDD=VDD VSS=VSS
XU180 oai22d1 $PINS A1=n212 A2=n206 B1=n213 B2=n204 ZN=n86 VDD=VDD VSS=VSS
XU181 xr02d1 $PINS A1=b[6] A2=n203 Z=n212 VDD=VDD VSS=VSS
XU182 aor21d1 $PINS B1=n204 B2=n206 A=n213 Z=n85 VDD=VDD VSS=VSS
XU183 xr02d1 $PINS A1=b[7] A2=n203 Z=n213 VDD=VDD VSS=VSS
XU184 nr02d0 $PINS A1=n214 A2=n205 ZN=n84 VDD=VDD VSS=VSS
XU185 oai22d1 $PINS A1=n215 A2=n216 B1=n217 B2=n214 ZN=n83 VDD=VDD VSS=VSS
XctmTdsLR_1_2901 an02d1 $PINS A1=n60 A2=n92 Z=n14 VDD=VDD VSS=VSS
XU187 oai22d1 $PINS A1=n217 A2=n216 B1=n214 B2=n218 ZN=n82 VDD=VDD VSS=VSS
XU188 xr02d1 $PINS A1=b[1] A2=n201 Z=n217 VDD=VDD VSS=VSS
XU189 oai22d1 $PINS A1=n218 A2=n216 B1=n214 B2=n219 ZN=n81 VDD=VDD VSS=VSS
XU190 xr02d1 $PINS A1=b[2] A2=n201 Z=n218 VDD=VDD VSS=VSS
XU191 oai22d1 $PINS A1=n219 A2=n216 B1=n214 B2=n220 ZN=n80 VDD=VDD VSS=VSS
XU192 xr02d1 $PINS A1=b[3] A2=n201 Z=n219 VDD=VDD VSS=VSS
XU193 oai22d1 $PINS A1=n220 A2=n216 B1=n214 B2=n221 ZN=n79 VDD=VDD VSS=VSS
XU194 xr02d1 $PINS A1=b[4] A2=n201 Z=n220 VDD=VDD VSS=VSS
XU195 nr02d0 $PINS A1=n223 A2=n205 ZN=n76 VDD=VDD VSS=VSS
XU196 oai22d1 $PINS A1=n224 A2=n225 B1=n226 B2=n223 ZN=n75 VDD=VDD VSS=VSS
XctmTdsLR_2_2902 aoim21d1 $PINS B1=n92 B2=n60 A=n14 ZN=product[1] VDD=VDD
+ VSS=VSS
XU198 oai22d1 $PINS A1=n226 A2=n225 B1=n223 B2=n227 ZN=n74 VDD=VDD VSS=VSS
XU199 xr02d1 $PINS A1=b[1] A2=n198 Z=n226 VDD=VDD VSS=VSS
XU200 oai22d1 $PINS A1=n227 A2=n225 B1=n223 B2=n228 ZN=n73 VDD=VDD VSS=VSS
XU201 xr02d1 $PINS A1=b[2] A2=n198 Z=n227 VDD=VDD VSS=VSS
XU202 oai22d1 $PINS A1=n228 A2=n225 B1=n223 B2=n229 ZN=n72 VDD=VDD VSS=VSS
XU203 xr02d1 $PINS A1=b[3] A2=n198 Z=n228 VDD=VDD VSS=VSS
XU204 oai22d1 $PINS A1=n229 A2=n225 B1=n223 B2=n230 ZN=n71 VDD=VDD VSS=VSS
XU205 xr02d1 $PINS A1=b[4] A2=n198 Z=n229 VDD=VDD VSS=VSS
XU206 oai22d1 $PINS A1=n230 A2=n225 B1=n223 B2=n231 ZN=n70 VDD=VDD VSS=VSS
XU207 xr02d1 $PINS A1=b[5] A2=n198 Z=n230 VDD=VDD VSS=VSS
XU208 nr02d0 $PINS A1=n233 A2=n205 ZN=n68 VDD=VDD VSS=VSS
XU209 oai22d1 $PINS A1=n234 A2=n235 B1=n236 B2=n233 ZN=n67 VDD=VDD VSS=VSS
XctmTdsLR_2_2904 aoim21d1 $PINS B1=n83 B2=n90 A=n55 ZN=n56 VDD=VDD VSS=VSS
XU211 oai22d1 $PINS A1=n237 A2=n235 B1=n233 B2=n238 ZN=n65 VDD=VDD VSS=VSS
XU212 oai22d1 $PINS A1=n238 A2=n235 B1=n233 B2=n239 ZN=n64 VDD=VDD VSS=VSS
XU213 xr02d1 $PINS A1=b[3] A2=n195 Z=n238 VDD=VDD VSS=VSS
XU214 oai22d1 $PINS A1=n239 A2=n235 B1=n233 B2=n240 ZN=n63 VDD=VDD VSS=VSS
XU215 xr02d1 $PINS A1=b[4] A2=n195 Z=n239 VDD=VDD VSS=VSS
XU216 oai22d1 $PINS A1=n240 A2=n235 B1=n233 B2=n241 ZN=n62 VDD=VDD VSS=VSS
XU217 xr02d1 $PINS A1=b[5] A2=n195 Z=n240 VDD=VDD VSS=VSS
XU218 oai21d1 $PINS B1=b[0] B2=n203 A=n206 ZN=n60 VDD=VDD VSS=VSS
XU219 oai21d1 $PINS B1=n201 B2=n216 A=n243 ZN=n59 VDD=VDD VSS=VSS
XU220 nd03d0 $PINS A1=n202 A2=n205 A3=a[3] ZN=n243 VDD=VDD VSS=VSS
XU221 oai21d1 $PINS B1=n198 B2=n225 A=n244 ZN=n58 VDD=VDD VSS=VSS
XU222 nd03d0 $PINS A1=n199 A2=n205 A3=a[5] ZN=n244 VDD=VDD VSS=VSS
XU223 oai21d1 $PINS B1=n195 B2=n235 A=n245 ZN=n57 VDD=VDD VSS=VSS
XU224 nd03d0 $PINS A1=n196 A2=n205 A3=a[7] ZN=n245 VDD=VDD VSS=VSS
XU225 xn02d1 $PINS A1=n246 A2=n247 ZN=n38 VDD=VDD VSS=VSS
XU226 or02d0 $PINS A1=n247 A2=n246 Z=n37 VDD=VDD VSS=VSS
XU227 oai22d1 $PINS A1=n236 A2=n235 B1=n237 B2=n233 ZN=n246 VDD=VDD VSS=VSS
XU228 xr02d1 $PINS A1=b[2] A2=n195 Z=n237 VDD=VDD VSS=VSS
XU229 xr02d1 $PINS A1=b[1] A2=n195 Z=n236 VDD=VDD VSS=VSS
XU230 oai22d1 $PINS A1=n221 A2=n216 B1=n248 B2=n214 ZN=n247 VDD=VDD VSS=VSS
XU231 xr02d1 $PINS A1=b[5] A2=n201 Z=n221 VDD=VDD VSS=VSS
XU232 aoim22d1 $PINS A1=n222 A2=n202 B1=n248 B2=n216 Z=n32 VDD=VDD VSS=VSS
XU233 xr02d1 $PINS A1=a[3] A2=a[2] Z=n249 VDD=VDD VSS=VSS
XU234 xr02d1 $PINS A1=b[6] A2=n201 Z=n248 VDD=VDD VSS=VSS
XU235 xr02d1 $PINS A1=b[7] A2=a[3] Z=n222 VDD=VDD VSS=VSS
XU236 aoim22d1 $PINS A1=n232 A2=n199 B1=n231 B2=n225 Z=n22 VDD=VDD VSS=VSS
XU237 xr02d1 $PINS A1=a[5] A2=a[4] Z=n250 VDD=VDD VSS=VSS
XU238 xr02d1 $PINS A1=b[6] A2=n198 Z=n231 VDD=VDD VSS=VSS
XU239 xr02d1 $PINS A1=b[7] A2=a[5] Z=n232 VDD=VDD VSS=VSS
XU240 aoim22d1 $PINS A1=n242 A2=n196 B1=n241 B2=n235 Z=n16 VDD=VDD VSS=VSS
XU241 xr02d1 $PINS A1=a[7] A2=a[6] Z=n251 VDD=VDD VSS=VSS
XU242 xr02d1 $PINS A1=b[6] A2=n195 Z=n241 VDD=VDD VSS=VSS
XU243 xr02d1 $PINS A1=b[7] A2=a[7] Z=n242 VDD=VDD VSS=VSS
XctmTdsLR_1_1248 aoim22d1 $PINS A1=n201 A2=b[0] B1=n201 B2=b[0] Z=n215 VDD=VDD
+ VSS=VSS
XctmTdsLR_1_1249 aoim22d1 $PINS A1=n198 A2=b[0] B1=n198 B2=b[0] Z=n224 VDD=VDD
+ VSS=VSS
XctmTdsLR_1_1250 aoim22d1 $PINS A1=n195 A2=b[0] B1=n195 B2=b[0] Z=n234 VDD=VDD
+ VSS=VSS
.ENDS

.SUBCKT unpu_pe_15_DW_mult_uns_0_DW_mult_uns_16 a[7] a[6] a[5] a[4] a[3] a[2]
+ a[1] a[0] b[7] b[6] b[5] b[4] b[3] b[2] b[1] b[0] product[15] product[14]
+ product[13] product[12] product[11] product[10] product[9] product[8]
+ product[7] product[6] product[5] product[4] product[3] product[2] product[1]
+ product[0] VDD VSS
XU2 ad01d0 $PINS A=n99 B=n15 CI=n2 CO=product[15] S=product[14] VDD=VDD VSS=VSS
XU3 ad01d0 $PINS A=n16 B=n17 CI=n3 CO=n2 S=product[13] VDD=VDD VSS=VSS
XU4 ad01d0 $PINS A=n18 B=n21 CI=n4 CO=n3 S=product[12] VDD=VDD VSS=VSS
XU5 ad01d0 $PINS A=n27 B=n22 CI=n5 CO=n4 S=product[11] VDD=VDD VSS=VSS
XU6 ad01d0 $PINS A=n35 B=n28 CI=n6 CO=n5 S=product[10] VDD=VDD VSS=VSS
XU7 ad01d0 $PINS A=n45 B=n36 CI=n7 CO=n6 S=product[9] VDD=VDD VSS=VSS
XU8 ad01d0 $PINS A=n57 B=n46 CI=n8 CO=n7 S=product[8] VDD=VDD VSS=VSS
XU9 ad01d0 $PINS A=n69 B=n58 CI=n9 CO=n8 S=product[7] VDD=VDD VSS=VSS
XU10 ad01d0 $PINS A=n79 B=n70 CI=n10 CO=n9 S=product[6] VDD=VDD VSS=VSS
XU11 ad01d0 $PINS A=n87 B=n80 CI=n11 CO=n10 S=product[5] VDD=VDD VSS=VSS
XU12 ad01d0 $PINS A=n93 B=n88 CI=n12 CO=n11 S=product[4] VDD=VDD VSS=VSS
XU13 ad01d0 $PINS A=n96 B=n13 CI=n94 CO=n12 S=product[3] VDD=VDD VSS=VSS
XU14 ad01d0 $PINS A=n146 B=n14 CI=n98 CO=n13 S=product[2] VDD=VDD VSS=VSS
XU15 ah01d1 $PINS A=n161 B=n154 CO=n14 S=product[1] VDD=VDD VSS=VSS
XU16 ad01d0 $PINS A=n107 B=n100 CI=n19 CO=n15 S=n16 VDD=VDD VSS=VSS
XU17 ad01d0 $PINS A=n25 B=n20 CI=n23 CO=n17 S=n18 VDD=VDD VSS=VSS
XU18 ad01d0 $PINS A=n115 B=n101 CI=n108 CO=n19 S=n20 VDD=VDD VSS=VSS
XU19 ad01d0 $PINS A=n31 B=n24 CI=n29 CO=n21 S=n22 VDD=VDD VSS=VSS
XU20 ad01d0 $PINS A=n116 B=n33 CI=n26 CO=n23 S=n24 VDD=VDD VSS=VSS
XU21 ad01d0 $PINS A=n123 B=n102 CI=n109 CO=n25 S=n26 VDD=VDD VSS=VSS
XU22 ad01d0 $PINS A=n32 B=n37 CI=n30 CO=n27 S=n28 VDD=VDD VSS=VSS
XU23 ad01d0 $PINS A=n41 B=n34 CI=n39 CO=n29 S=n30 VDD=VDD VSS=VSS
XU24 ad01d0 $PINS A=n124 B=n117 CI=n43 CO=n31 S=n32 VDD=VDD VSS=VSS
XU25 ad01d0 $PINS A=n131 B=n103 CI=n110 CO=n33 S=n34 VDD=VDD VSS=VSS
XU26 ad01d0 $PINS A=n40 B=n47 CI=n38 CO=n35 S=n36 VDD=VDD VSS=VSS
XU27 ad01d0 $PINS A=n44 B=n51 CI=n49 CO=n37 S=n38 VDD=VDD VSS=VSS
XU28 ad01d0 $PINS A=n55 B=n53 CI=n42 CO=n39 S=n40 VDD=VDD VSS=VSS
XU29 ad01d0 $PINS A=n118 B=n125 CI=n132 CO=n41 S=n42 VDD=VDD VSS=VSS
XU30 ad01d0 $PINS A=n139 B=n104 CI=n111 CO=n43 S=n44 VDD=VDD VSS=VSS
XU31 ad01d0 $PINS A=n50 B=n59 CI=n48 CO=n45 S=n46 VDD=VDD VSS=VSS
XU32 ad01d0 $PINS A=n54 B=n52 CI=n61 CO=n47 S=n48 VDD=VDD VSS=VSS
XU33 ad01d0 $PINS A=n56 B=n65 CI=n63 CO=n49 S=n50 VDD=VDD VSS=VSS
XU34 ad01d0 $PINS A=n140 B=n133 CI=n67 CO=n51 S=n52 VDD=VDD VSS=VSS
XU35 ad01d0 $PINS A=n126 B=n119 CI=n147 CO=n53 S=n54 VDD=VDD VSS=VSS
XU36 ah01d1 $PINS A=n105 B=n112 CO=n55 S=n56 VDD=VDD VSS=VSS
XU37 ad01d0 $PINS A=n71 B=n62 CI=n60 CO=n57 S=n58 VDD=VDD VSS=VSS
XU38 ad01d0 $PINS A=n64 B=n66 CI=n73 CO=n59 S=n60 VDD=VDD VSS=VSS
XU39 ad01d0 $PINS A=n77 B=n68 CI=n75 CO=n61 S=n62 VDD=VDD VSS=VSS
XU40 ad01d0 $PINS A=n141 B=n127 CI=n134 CO=n63 S=n64 VDD=VDD VSS=VSS
XU41 ad01d0 $PINS A=n155 B=n120 CI=n148 CO=n65 S=n66 VDD=VDD VSS=VSS
XU42 ah01d1 $PINS A=n106 B=n113 CO=n67 S=n68 VDD=VDD VSS=VSS
XU43 ad01d0 $PINS A=n81 B=n74 CI=n72 CO=n69 S=n70 VDD=VDD VSS=VSS
XU44 ad01d0 $PINS A=n78 B=n83 CI=n76 CO=n71 S=n72 VDD=VDD VSS=VSS
XU45 ad01d0 $PINS A=n142 B=n135 CI=n85 CO=n73 S=n74 VDD=VDD VSS=VSS
XU46 ad01d0 $PINS A=n156 B=n128 CI=n149 CO=n75 S=n76 VDD=VDD VSS=VSS
XU47 ah01d1 $PINS A=n114 B=n121 CO=n77 S=n78 VDD=VDD VSS=VSS
XU48 ad01d0 $PINS A=n89 B=n84 CI=n82 CO=n79 S=n80 VDD=VDD VSS=VSS
XU49 ad01d0 $PINS A=n150 B=n91 CI=n86 CO=n81 S=n82 VDD=VDD VSS=VSS
XU50 ad01d0 $PINS A=n157 B=n136 CI=n143 CO=n83 S=n84 VDD=VDD VSS=VSS
XU51 ah01d1 $PINS A=n122 B=n129 CO=n85 S=n86 VDD=VDD VSS=VSS
XU52 ad01d0 $PINS A=n95 B=n92 CI=n90 CO=n87 S=n88 VDD=VDD VSS=VSS
XU53 ad01d0 $PINS A=n158 B=n144 CI=n151 CO=n89 S=n90 VDD=VDD VSS=VSS
XU54 ah01d1 $PINS A=n130 B=n137 CO=n91 S=n92 VDD=VDD VSS=VSS
XU55 ad01d0 $PINS A=n159 B=n152 CI=n97 CO=n93 S=n94 VDD=VDD VSS=VSS
XU56 ah01d1 $PINS A=n138 B=n145 CO=n95 S=n96 VDD=VDD VSS=VSS
XU57 ah01d1 $PINS A=n153 B=n160 CO=n97 S=n98 VDD=VDD VSS=VSS
XU140 inv0d0 $PINS I=b[4] ZN=n225 VDD=VDD VSS=VSS
XU141 inv0d0 $PINS I=b[2] ZN=n227 VDD=VDD VSS=VSS
XU142 inv0d0 $PINS I=b[3] ZN=n226 VDD=VDD VSS=VSS
XU143 inv0d0 $PINS I=b[1] ZN=n228 VDD=VDD VSS=VSS
XU144 inv0d0 $PINS I=b[0] ZN=n229 VDD=VDD VSS=VSS
XU145 inv0d0 $PINS I=b[6] ZN=n223 VDD=VDD VSS=VSS
XU146 inv0d0 $PINS I=b[5] ZN=n224 VDD=VDD VSS=VSS
XU147 inv0d0 $PINS I=b[7] ZN=n222 VDD=VDD VSS=VSS
XU148 inv0d0 $PINS I=a[1] ZN=n220 VDD=VDD VSS=VSS
XU149 inv0d0 $PINS I=a[0] ZN=n221 VDD=VDD VSS=VSS
XU150 inv0d0 $PINS I=a[2] ZN=n219 VDD=VDD VSS=VSS
XU151 inv0d0 $PINS I=a[5] ZN=n216 VDD=VDD VSS=VSS
XU152 inv0d0 $PINS I=a[4] ZN=n217 VDD=VDD VSS=VSS
XU153 inv0d0 $PINS I=a[3] ZN=n218 VDD=VDD VSS=VSS
XU154 inv0d0 $PINS I=a[6] ZN=n215 VDD=VDD VSS=VSS
XU155 inv0d0 $PINS I=a[7] ZN=n214 VDD=VDD VSS=VSS
XU156 nr02d0 $PINS A1=n221 A2=n229 ZN=product[0] VDD=VDD VSS=VSS
XU157 nr02d0 $PINS A1=n214 A2=n222 ZN=n99 VDD=VDD VSS=VSS
XU158 nr02d0 $PINS A1=n221 A2=n228 ZN=n161 VDD=VDD VSS=VSS
XU159 nr02d0 $PINS A1=n221 A2=n227 ZN=n160 VDD=VDD VSS=VSS
XU160 nr02d0 $PINS A1=n221 A2=n226 ZN=n159 VDD=VDD VSS=VSS
XU161 nr02d0 $PINS A1=n221 A2=n225 ZN=n158 VDD=VDD VSS=VSS
XU162 nr02d0 $PINS A1=n221 A2=n224 ZN=n157 VDD=VDD VSS=VSS
XU163 nr02d0 $PINS A1=n221 A2=n223 ZN=n156 VDD=VDD VSS=VSS
XU164 nr02d0 $PINS A1=n221 A2=n222 ZN=n155 VDD=VDD VSS=VSS
XU165 nr02d0 $PINS A1=n229 A2=n220 ZN=n154 VDD=VDD VSS=VSS
XU166 nr02d0 $PINS A1=n228 A2=n220 ZN=n153 VDD=VDD VSS=VSS
XU167 nr02d0 $PINS A1=n227 A2=n220 ZN=n152 VDD=VDD VSS=VSS
XU168 nr02d0 $PINS A1=n226 A2=n220 ZN=n151 VDD=VDD VSS=VSS
XU169 nr02d0 $PINS A1=n225 A2=n220 ZN=n150 VDD=VDD VSS=VSS
XU170 nr02d0 $PINS A1=n224 A2=n220 ZN=n149 VDD=VDD VSS=VSS
XU171 nr02d0 $PINS A1=n223 A2=n220 ZN=n148 VDD=VDD VSS=VSS
XU172 nr02d0 $PINS A1=n222 A2=n220 ZN=n147 VDD=VDD VSS=VSS
XU173 nr02d0 $PINS A1=n229 A2=n219 ZN=n146 VDD=VDD VSS=VSS
XU174 nr02d0 $PINS A1=n228 A2=n219 ZN=n145 VDD=VDD VSS=VSS
XU175 nr02d0 $PINS A1=n227 A2=n219 ZN=n144 VDD=VDD VSS=VSS
XU176 nr02d0 $PINS A1=n226 A2=n219 ZN=n143 VDD=VDD VSS=VSS
XU177 nr02d0 $PINS A1=n225 A2=n219 ZN=n142 VDD=VDD VSS=VSS
XU178 nr02d0 $PINS A1=n224 A2=n219 ZN=n141 VDD=VDD VSS=VSS
XU179 nr02d0 $PINS A1=n223 A2=n219 ZN=n140 VDD=VDD VSS=VSS
XU180 nr02d0 $PINS A1=n222 A2=n219 ZN=n139 VDD=VDD VSS=VSS
XU181 nr02d0 $PINS A1=n229 A2=n218 ZN=n138 VDD=VDD VSS=VSS
XU182 nr02d0 $PINS A1=n228 A2=n218 ZN=n137 VDD=VDD VSS=VSS
XU183 nr02d0 $PINS A1=n227 A2=n218 ZN=n136 VDD=VDD VSS=VSS
XU184 nr02d0 $PINS A1=n226 A2=n218 ZN=n135 VDD=VDD VSS=VSS
XU185 nr02d0 $PINS A1=n225 A2=n218 ZN=n134 VDD=VDD VSS=VSS
XU186 nr02d0 $PINS A1=n224 A2=n218 ZN=n133 VDD=VDD VSS=VSS
XU187 nr02d0 $PINS A1=n223 A2=n218 ZN=n132 VDD=VDD VSS=VSS
XU188 nr02d0 $PINS A1=n222 A2=n218 ZN=n131 VDD=VDD VSS=VSS
XU189 nr02d0 $PINS A1=n229 A2=n217 ZN=n130 VDD=VDD VSS=VSS
XU190 nr02d0 $PINS A1=n228 A2=n217 ZN=n129 VDD=VDD VSS=VSS
XU191 nr02d0 $PINS A1=n227 A2=n217 ZN=n128 VDD=VDD VSS=VSS
XU192 nr02d0 $PINS A1=n226 A2=n217 ZN=n127 VDD=VDD VSS=VSS
XU193 nr02d0 $PINS A1=n225 A2=n217 ZN=n126 VDD=VDD VSS=VSS
XU194 nr02d0 $PINS A1=n224 A2=n217 ZN=n125 VDD=VDD VSS=VSS
XU195 nr02d0 $PINS A1=n223 A2=n217 ZN=n124 VDD=VDD VSS=VSS
XU196 nr02d0 $PINS A1=n222 A2=n217 ZN=n123 VDD=VDD VSS=VSS
XU197 nr02d0 $PINS A1=n229 A2=n216 ZN=n122 VDD=VDD VSS=VSS
XU198 nr02d0 $PINS A1=n228 A2=n216 ZN=n121 VDD=VDD VSS=VSS
XU199 nr02d0 $PINS A1=n227 A2=n216 ZN=n120 VDD=VDD VSS=VSS
XU200 nr02d0 $PINS A1=n226 A2=n216 ZN=n119 VDD=VDD VSS=VSS
XU201 nr02d0 $PINS A1=n225 A2=n216 ZN=n118 VDD=VDD VSS=VSS
XU202 nr02d0 $PINS A1=n224 A2=n216 ZN=n117 VDD=VDD VSS=VSS
XU203 nr02d0 $PINS A1=n223 A2=n216 ZN=n116 VDD=VDD VSS=VSS
XU204 nr02d0 $PINS A1=n222 A2=n216 ZN=n115 VDD=VDD VSS=VSS
XU205 nr02d0 $PINS A1=n229 A2=n215 ZN=n114 VDD=VDD VSS=VSS
XU206 nr02d0 $PINS A1=n228 A2=n215 ZN=n113 VDD=VDD VSS=VSS
XU207 nr02d0 $PINS A1=n227 A2=n215 ZN=n112 VDD=VDD VSS=VSS
XU208 nr02d0 $PINS A1=n226 A2=n215 ZN=n111 VDD=VDD VSS=VSS
XU209 nr02d0 $PINS A1=n225 A2=n215 ZN=n110 VDD=VDD VSS=VSS
XU210 nr02d0 $PINS A1=n224 A2=n215 ZN=n109 VDD=VDD VSS=VSS
XU211 nr02d0 $PINS A1=n223 A2=n215 ZN=n108 VDD=VDD VSS=VSS
XU212 nr02d0 $PINS A1=n222 A2=n215 ZN=n107 VDD=VDD VSS=VSS
XU213 nr02d0 $PINS A1=n229 A2=n214 ZN=n106 VDD=VDD VSS=VSS
XU214 nr02d0 $PINS A1=n214 A2=n228 ZN=n105 VDD=VDD VSS=VSS
XU215 nr02d0 $PINS A1=n214 A2=n227 ZN=n104 VDD=VDD VSS=VSS
XU216 nr02d0 $PINS A1=n214 A2=n226 ZN=n103 VDD=VDD VSS=VSS
XU217 nr02d0 $PINS A1=n214 A2=n225 ZN=n102 VDD=VDD VSS=VSS
XU218 nr02d0 $PINS A1=n214 A2=n224 ZN=n101 VDD=VDD VSS=VSS
XU219 nr02d0 $PINS A1=n214 A2=n223 ZN=n100 VDD=VDD VSS=VSS
.ENDS

.SUBCKT unpu_pe_15_DW01_add_0_DW01_add_16 A[31] A[30] A[29] A[28] A[27] A[26]
+ A[25] A[24] A[23] A[22] A[21] A[20] A[19] A[18] A[17] A[16] A[15] A[14] A[13]
+ A[12] A[11] A[10] A[9] A[8] A[7] A[6] A[5] A[4] A[3] A[2] A[1] A[0] B[31]
+ B[30] B[29] B[28] B[27] B[26] B[25] B[24] B[23] B[22] B[21] B[20] B[19] B[18]
+ B[17] B[16] B[15] B[14] B[13] B[12] B[11] B[10] B[9] B[8] B[7] B[6] B[5] B[4]
+ B[3] B[2] B[1] B[0] CI SUM[31] SUM[30] SUM[29] SUM[28] SUM[27] SUM[26]
+ SUM[25] SUM[24] SUM[23] SUM[22] SUM[21] SUM[20] SUM[19] SUM[18] SUM[17]
+ SUM[16] SUM[15] SUM[14] SUM[13] SUM[12] SUM[11] SUM[10] SUM[9] SUM[8] SUM[7]
+ SUM[6] SUM[5] SUM[4] SUM[3] SUM[2] SUM[1] SUM[0] CO VDD VSS
*.CONNECT SUM[0] B[0]
XU1_31 ad01d0 $PINS A=A[31] B=B[31] CI=carry[31] S=SUM[31] VDD=VDD VSS=VSS
XU1_13 ad01d0 $PINS A=A[13] B=B[13] CI=carry[13] CO=carry[14] S=SUM[13] VDD=VDD
+ VSS=VSS
XU1_12 ad01d0 $PINS A=A[12] B=B[12] CI=carry[12] CO=carry[13] S=SUM[12] VDD=VDD
+ VSS=VSS
XU1_11 ad01d0 $PINS A=A[11] B=B[11] CI=carry[11] CO=carry[12] S=SUM[11] VDD=VDD
+ VSS=VSS
XU1_10 ad01d0 $PINS A=A[10] B=B[10] CI=carry[10] CO=carry[11] S=SUM[10] VDD=VDD
+ VSS=VSS
XU1_9 ad01d0 $PINS A=A[9] B=B[9] CI=carry[9] CO=carry[10] S=SUM[9] VDD=VDD
+ VSS=VSS
XU1_8 ad01d0 $PINS A=A[8] B=B[8] CI=carry[8] CO=carry[9] S=SUM[8] VDD=VDD
+ VSS=VSS
XU1_7 ad01d0 $PINS A=A[7] B=B[7] CI=carry[7] CO=carry[8] S=SUM[7] VDD=VDD
+ VSS=VSS
XU1_6 ad01d0 $PINS A=A[6] B=B[6] CI=carry[6] CO=carry[7] S=SUM[6] VDD=VDD
+ VSS=VSS
XU1_5 ad01d0 $PINS A=A[5] B=B[5] CI=carry[5] CO=carry[6] S=SUM[5] VDD=VDD
+ VSS=VSS
XU1_4 ad01d0 $PINS A=A[4] B=B[4] CI=carry[4] CO=carry[5] S=SUM[4] VDD=VDD
+ VSS=VSS
XU1_3 ad01d0 $PINS A=A[3] B=B[3] CI=carry[3] CO=carry[4] S=SUM[3] VDD=VDD
+ VSS=VSS
XU1_1 ad01d0 $PINS A=A[1] B=B[1] CI=VSS CO=carry[2] S=SUM[1] VDD=VDD VSS=VSS
XU1_2 ad01d0 $PINS A=A[2] B=B[2] CI=carry[2] CO=carry[3] S=SUM[2] VDD=VDD
+ VSS=VSS
XU1_15 ad01d0 $PINS A=A[15] B=B[15] CI=carry[15] CO=carry[16] S=SUM[15] VDD=VDD
+ VSS=VSS
XU1_14 ad01d0 $PINS A=A[14] B=B[14] CI=carry[14] CO=carry[15] S=SUM[14] VDD=VDD
+ VSS=VSS
XU1_30 ad01d0 $PINS A=A[30] B=B[30] CI=carry[30] CO=carry[31] S=SUM[30] VDD=VDD
+ VSS=VSS
XU1_29 ad01d0 $PINS A=A[29] B=B[29] CI=carry[29] CO=carry[30] S=SUM[29] VDD=VDD
+ VSS=VSS
XU1_28 ad01d0 $PINS A=A[28] B=B[28] CI=carry[28] CO=carry[29] S=SUM[28] VDD=VDD
+ VSS=VSS
XU1_27 ad01d0 $PINS A=A[27] B=B[27] CI=carry[27] CO=carry[28] S=SUM[27] VDD=VDD
+ VSS=VSS
XU1_26 ad01d0 $PINS A=A[26] B=B[26] CI=carry[26] CO=carry[27] S=SUM[26] VDD=VDD
+ VSS=VSS
XU1_25 ad01d0 $PINS A=A[25] B=B[25] CI=carry[25] CO=carry[26] S=SUM[25] VDD=VDD
+ VSS=VSS
XU1_24 ad01d0 $PINS A=A[24] B=B[24] CI=carry[24] CO=carry[25] S=SUM[24] VDD=VDD
+ VSS=VSS
XU1_23 ad01d0 $PINS A=A[23] B=B[23] CI=carry[23] CO=carry[24] S=SUM[23] VDD=VDD
+ VSS=VSS
XU1_22 ad01d0 $PINS A=A[22] B=B[22] CI=carry[22] CO=carry[23] S=SUM[22] VDD=VDD
+ VSS=VSS
XU1_21 ad01d0 $PINS A=A[21] B=B[21] CI=carry[21] CO=carry[22] S=SUM[21] VDD=VDD
+ VSS=VSS
XU1_20 ad01d0 $PINS A=A[20] B=B[20] CI=carry[20] CO=carry[21] S=SUM[20] VDD=VDD
+ VSS=VSS
XU1_19 ad01d0 $PINS A=A[19] B=B[19] CI=carry[19] CO=carry[20] S=SUM[19] VDD=VDD
+ VSS=VSS
XU1_18 ad01d0 $PINS A=A[18] B=B[18] CI=carry[18] CO=carry[19] S=SUM[18] VDD=VDD
+ VSS=VSS
XU1_17 ad01d0 $PINS A=A[17] B=B[17] CI=carry[17] CO=carry[18] S=SUM[17] VDD=VDD
+ VSS=VSS
XU1_16 ad01d0 $PINS A=A[16] B=B[16] CI=carry[16] CO=carry[17] S=SUM[16] VDD=VDD
+ VSS=VSS
.ENDS

.SUBCKT unpu_pe_15 rst_n array_en weight_load mode_unsigned weight_in[7]
+ weight_in[6] weight_in[5] weight_in[4] weight_in[3] weight_in[2] weight_in[1]
+ weight_in[0] act_in[7] act_in[6] act_in[5] act_in[4] act_in[3] act_in[2]
+ act_in[1] act_in[0] psum_in[31] psum_in[30] psum_in[29] psum_in[28]
+ psum_in[27] psum_in[26] psum_in[25] psum_in[24] psum_in[23] psum_in[22]
+ psum_in[21] psum_in[20] psum_in[19] psum_in[18] psum_in[17] psum_in[16]
+ psum_in[15] psum_in[14] psum_in[13] psum_in[12] psum_in[11] psum_in[10]
+ psum_in[9] psum_in[8] psum_in[7] psum_in[6] psum_in[5] psum_in[4] psum_in[3]
+ psum_in[2] psum_in[1] psum_in[0] act_out[7] act_out[6] act_out[5] act_out[4]
+ act_out[3] act_out[2] act_out[1] act_out[0] psum_out[31] psum_out[30]
+ psum_out[29] psum_out[28] psum_out[27] psum_out[26] psum_out[25] psum_out[24]
+ psum_out[23] psum_out[22] psum_out[21] psum_out[20] psum_out[19] psum_out[18]
+ psum_out[17] psum_out[16] psum_out[15] psum_out[14] psum_out[13] psum_out[12]
+ psum_out[11] psum_out[10] psum_out[9] psum_out[8] psum_out[7] psum_out[6]
+ psum_out[5] psum_out[4] psum_out[3] psum_out[2] psum_out[1] psum_out[0] VDD
+ VSS ZCTSNET_0 HFSNET_2 HFSNET_4 HFSNET_6 HFSNET_7 HFSNET_9 ZCTSNET_1
XU2 aor22d1 $PINS A1=N_uc_30 A2=mode_unsigned B1=HFSNET_1 B2=N_uc_14
+ Z=product[9] VDD=VDD VSS=VSS
XU3 aor22d1 $PINS A1=N_uc_29 A2=mode_unsigned B1=N_uc_13 B2=HFSNET_1
+ Z=product[8] VDD=VDD VSS=VSS
XU5 aor22d1 $PINS A1=N_uc_28 A2=mode_unsigned B1=N_uc_12 B2=HFSNET_1
+ Z=product[7] VDD=VDD VSS=VSS
XU6 aor22d1 $PINS A1=N_uc_27 A2=mode_unsigned B1=N_uc_11 B2=HFSNET_1
+ Z=product[6] VDD=VDD VSS=VSS
XU7 aor22d1 $PINS A1=N_uc_26 A2=mode_unsigned B1=N_uc_10 B2=HFSNET_1
+ Z=product[5] VDD=VDD VSS=VSS
XU8 aor22d1 $PINS A1=N_uc_9 A2=HFSNET_1 B1=N_uc_25 B2=mode_unsigned
+ Z=product[4] VDD=VDD VSS=VSS
XU9 aor22d1 $PINS A1=N_uc_8 A2=HFSNET_1 B1=N_uc_24 B2=mode_unsigned
+ Z=product[3] VDD=VDD VSS=VSS
XU10 aor22d1 $PINS A1=N_uc_7 A2=HFSNET_1 B1=N_uc_23 B2=mode_unsigned
+ Z=product[2] VDD=VDD VSS=VSS
XU11 aor22d1 $PINS A1=N_uc_6 A2=HFSNET_1 B1=N_uc_22 B2=mode_unsigned
+ Z=product[1] VDD=VDD VSS=VSS
XU12 oaim21d1 $PINS B1=N_uc_20 B2=HFSNET_1 A=n4 ZN=product[15] VDD=VDD VSS=VSS
XU13 aor22d1 $PINS A1=N_uc_35 A2=mode_unsigned B1=N_uc_19 B2=HFSNET_1
+ Z=product[14] VDD=VDD VSS=VSS
XU14 aor22d1 $PINS A1=N_uc_34 A2=mode_unsigned B1=N_uc_18 B2=HFSNET_1
+ Z=product[13] VDD=VDD VSS=VSS
XU15 aor22d1 $PINS A1=N_uc_33 A2=mode_unsigned B1=N_uc_17 B2=HFSNET_1
+ Z=product[12] VDD=VDD VSS=VSS
XU16 aor22d1 $PINS A1=N_uc_32 A2=mode_unsigned B1=N_uc_16 B2=HFSNET_1
+ Z=product[11] VDD=VDD VSS=VSS
XU17 aor22d1 $PINS A1=N_uc_31 A2=mode_unsigned B1=N_uc_15 B2=HFSNET_1
+ Z=product[10] VDD=VDD VSS=VSS
XU18 aor22d1 $PINS A1=N_uc_5 A2=HFSNET_1 B1=N_uc_21 B2=mode_unsigned
+ Z=product[0] VDD=VDD VSS=VSS
XU19 aor22d1 $PINS A1=copt_net_309 A2=HFSNET_5 B1=HFSNET_3 B2=act_in[0] Z=n8
+ VDD=VDD VSS=VSS
XU20 aor22d1 $PINS A1=copt_net_334 A2=HFSNET_5 B1=act_in[1] B2=HFSNET_3 Z=n9
+ VDD=VDD VSS=VSS
XU21 aor22d1 $PINS A1=act_out[2] A2=HFSNET_5 B1=act_in[2] B2=HFSNET_3 Z=n10
+ VDD=VDD VSS=VSS
XU22 aor22d1 $PINS A1=act_out[3] A2=HFSNET_4 B1=act_in[3] B2=HFSNET_6 Z=n11
+ VDD=VDD VSS=VSS
XU23 aor22d1 $PINS A1=act_out[4] A2=HFSNET_5 B1=act_in[4] B2=HFSNET_3 Z=n12
+ VDD=VDD VSS=VSS
XU24 aor22d1 $PINS A1=copt_net_741 A2=array_en B1=act_in[5] B2=HFSNET_3 Z=n13
+ VDD=VDD VSS=VSS
XU25 aor22d4 $PINS A1=act_out[6] A2=HFSNET_5 B1=act_in[6] B2=HFSNET_3 Z=n14
+ VDD=VDD VSS=VSS
XU26 aor22d1 $PINS A1=act_out[7] A2=HFSNET_5 B1=act_in[7] B2=HFSNET_3 Z=n15
+ VDD=VDD VSS=VSS
XU27 aor22d1 $PINS A1=psum_out[0] A2=HFSNET_5 B1=N_uc_40 B2=HFSNET_3 Z=n16
+ VDD=VDD VSS=VSS
XU28 aor22d1 $PINS A1=psum_out[1] A2=HFSNET_5 B1=N_uc_41 B2=HFSNET_3 Z=n17
+ VDD=VDD VSS=VSS
XU29 aor22d1 $PINS A1=psum_out[2] A2=HFSNET_5 B1=N_uc_42 B2=HFSNET_3 Z=n18
+ VDD=VDD VSS=VSS
XU30 aor22d1 $PINS A1=psum_out[3] A2=HFSNET_5 B1=N_uc_43 B2=HFSNET_3 Z=n19
+ VDD=VDD VSS=VSS
XU31 aor22d1 $PINS A1=psum_out[4] A2=HFSNET_5 B1=N_uc_44 B2=HFSNET_3 Z=n20
+ VDD=VDD VSS=VSS
XU32 aor22d1 $PINS A1=psum_out[5] A2=HFSNET_5 B1=N_uc_45 B2=HFSNET_3 Z=n21
+ VDD=VDD VSS=VSS
XU33 aor22d1 $PINS A1=psum_out[6] A2=HFSNET_5 B1=N_uc_46 B2=HFSNET_3 Z=n22
+ VDD=VDD VSS=VSS
XU34 aor22d1 $PINS A1=psum_out[7] A2=HFSNET_5 B1=N_uc_47 B2=HFSNET_3 Z=n23
+ VDD=VDD VSS=VSS
XU35 aor22d1 $PINS A1=psum_out[8] A2=HFSNET_5 B1=N_uc_48 B2=HFSNET_3 Z=n24
+ VDD=VDD VSS=VSS
XU36 aor22d1 $PINS A1=psum_out[9] A2=HFSNET_5 B1=N_uc_49 B2=HFSNET_3 Z=n25
+ VDD=VDD VSS=VSS
XU37 aor22d1 $PINS A1=psum_out[10] A2=HFSNET_5 B1=N_uc_50 B2=HFSNET_3 Z=n26
+ VDD=VDD VSS=VSS
XU38 aor22d1 $PINS A1=psum_out[11] A2=HFSNET_5 B1=N_uc_51 B2=HFSNET_3 Z=n27
+ VDD=VDD VSS=VSS
XU39 aor22d1 $PINS A1=psum_out[12] A2=HFSNET_5 B1=N_uc_52 B2=HFSNET_3 Z=n28
+ VDD=VDD VSS=VSS
XU40 aor22d1 $PINS A1=psum_out[13] A2=HFSNET_5 B1=N_uc_53 B2=HFSNET_3 Z=n29
+ VDD=VDD VSS=VSS
XU41 aor22d1 $PINS A1=psum_out[14] A2=HFSNET_5 B1=N_uc_54 B2=HFSNET_3 Z=n30
+ VDD=VDD VSS=VSS
XU42 aor22d1 $PINS A1=psum_out[15] A2=HFSNET_5 B1=N_uc_55 B2=HFSNET_3 Z=n31
+ VDD=VDD VSS=VSS
XU43 aor22d1 $PINS A1=psum_out[16] A2=HFSNET_5 B1=N_uc_56 B2=HFSNET_3 Z=n32
+ VDD=VDD VSS=VSS
XU44 aor22d1 $PINS A1=psum_out[17] A2=HFSNET_5 B1=N_uc_57 B2=HFSNET_3 Z=n33
+ VDD=VDD VSS=VSS
XU45 aor22d1 $PINS A1=psum_out[18] A2=HFSNET_5 B1=N_uc_58 B2=HFSNET_3 Z=n34
+ VDD=VDD VSS=VSS
XU46 aor22d1 $PINS A1=psum_out[19] A2=HFSNET_5 B1=N_uc_59 B2=HFSNET_3 Z=n35
+ VDD=VDD VSS=VSS
XU47 aor22d1 $PINS A1=psum_out[20] A2=HFSNET_5 B1=N_uc_60 B2=HFSNET_3 Z=n36
+ VDD=VDD VSS=VSS
XU48 aor22d1 $PINS A1=psum_out[21] A2=array_en B1=N_uc_61 B2=HFSNET_3 Z=n37
+ VDD=VDD VSS=VSS
XU49 aor22d1 $PINS A1=psum_out[22] A2=array_en B1=N_uc_62 B2=HFSNET_3 Z=n38
+ VDD=VDD VSS=VSS
XU50 aor22d1 $PINS A1=psum_out[23] A2=array_en B1=N_uc_63 B2=HFSNET_3 Z=n39
+ VDD=VDD VSS=VSS
XU51 aor22d1 $PINS A1=psum_out[24] A2=array_en B1=N_uc_64 B2=HFSNET_3 Z=n40
+ VDD=VDD VSS=VSS
XU52 aor22d1 $PINS A1=psum_out[25] A2=array_en B1=N_uc_65 B2=HFSNET_3 Z=n41
+ VDD=VDD VSS=VSS
XU53 aor22d1 $PINS A1=psum_out[26] A2=array_en B1=N_uc_66 B2=HFSNET_3 Z=n42
+ VDD=VDD VSS=VSS
XU54 aor22d1 $PINS A1=psum_out[27] A2=array_en B1=N_uc_67 B2=HFSNET_3 Z=n43
+ VDD=VDD VSS=VSS
XU55 aor22d1 $PINS A1=copt_net_323 A2=array_en B1=N_uc_68 B2=HFSNET_3 Z=n44
+ VDD=VDD VSS=VSS
XU56 aor22d1 $PINS A1=psum_out[29] A2=array_en B1=N_uc_69 B2=HFSNET_3 Z=n45
+ VDD=VDD VSS=VSS
XU57 aor22d1 $PINS A1=psum_out[30] A2=array_en B1=N_uc_70 B2=HFSNET_3 Z=n46
+ VDD=VDD VSS=VSS
XU58 aor22d1 $PINS A1=psum_out[31] A2=array_en B1=N_uc_71 B2=HFSNET_3 Z=n47
+ VDD=VDD VSS=VSS
XU63 aor22d1 $PINS A1=copt_net_1280 A2=n6 B1=weight_in[0] B2=n64 Z=n49 VDD=VDD
+ VSS=VSS
XU64 aor22d1 $PINS A1=copt_net_1211 A2=n6 B1=weight_in[1] B2=n64 Z=n50 VDD=VDD
+ VSS=VSS
XU65 aor22d1 $PINS A1=copt_net_1416 A2=n6 B1=weight_in[2] B2=n64 Z=n51 VDD=VDD
+ VSS=VSS
XU66 aor22d1 $PINS A1=copt_net_1177 A2=n6 B1=weight_in[3] B2=n64 Z=n52 VDD=VDD
+ VSS=VSS
XU67 aor22d1 $PINS A1=copt_net_1959 A2=n6 B1=weight_in[4] B2=n64 Z=n53 VDD=VDD
+ VSS=VSS
XU68 aor22d1 $PINS A1=copt_net_1983 A2=n6 B1=weight_in[5] B2=n64 Z=n54 VDD=VDD
+ VSS=VSS
XU69 aor22d1 $PINS A1=copt_net_1516 A2=n6 B1=weight_in[6] B2=n64 Z=n55 VDD=VDD
+ VSS=VSS
XU70 aor22d1 $PINS A1=copt_net_1204 A2=n6 B1=weight_in[7] B2=n64 Z=n56 VDD=VDD
+ VSS=VSS
Xadd_42 unpu_pe_15_DW01_add_0_DW01_add_16 $PINS A[31]=psum_in[31]
+ A[30]=psum_in[30] A[29]=psum_in[29] A[28]=psum_in[28] A[27]=psum_in[27]
+ A[26]=psum_in[26] A[25]=psum_in[25] A[24]=psum_in[24] A[23]=psum_in[23]
+ A[22]=psum_in[22] A[21]=psum_in[21] A[20]=psum_in[20] A[19]=psum_in[19]
+ A[18]=psum_in[18] A[17]=psum_in[17] A[16]=psum_in[16] A[15]=psum_in[15]
+ A[14]=psum_in[14] A[13]=psum_in[13] A[12]=psum_in[12] A[11]=psum_in[11]
+ A[10]=psum_in[10] A[9]=psum_in[9] A[8]=psum_in[8] A[7]=psum_in[7]
+ A[6]=psum_in[6] A[5]=psum_in[5] A[4]=psum_in[4] A[3]=psum_in[3] A[2]=psum_in[2]
+ A[1]=psum_in[1] A[0]=psum_in[0] B[31]=n2 B[30]=n2 B[29]=n2 B[28]=n2 B[27]=n2
+ B[26]=n2 B[25]=n2 B[24]=n2 B[23]=n2 B[22]=n2 B[21]=n2 B[20]=n2 B[19]=n2
+ B[18]=n2 B[17]=n2 B[16]=n2 B[15]=product[15] B[14]=product[14]
+ B[13]=product[13] B[12]=product[12] B[11]=product[11] B[10]=product[10]
+ B[9]=product[9] B[8]=product[8] B[7]=product[7] B[6]=product[6] B[5]=product[5]
+ B[4]=product[4] B[3]=product[3] B[2]=product[2] B[1]=product[1] B[0]=product[0]
+ CI=VSS SUM[31]=N_uc_71 SUM[30]=N_uc_70 SUM[29]=N_uc_69 SUM[28]=N_uc_68
+ SUM[27]=N_uc_67 SUM[26]=N_uc_66 SUM[25]=N_uc_65 SUM[24]=N_uc_64 SUM[23]=N_uc_63
+ SUM[22]=N_uc_62 SUM[21]=N_uc_61 SUM[20]=N_uc_60 SUM[19]=N_uc_59 SUM[18]=N_uc_58
+ SUM[17]=N_uc_57 SUM[16]=N_uc_56 SUM[15]=N_uc_55 SUM[14]=N_uc_54 SUM[13]=N_uc_53
+ SUM[12]=N_uc_52 SUM[11]=N_uc_51 SUM[10]=N_uc_50 SUM[9]=N_uc_49 SUM[8]=N_uc_48
+ SUM[7]=N_uc_47 SUM[6]=N_uc_46 SUM[5]=N_uc_45 SUM[4]=N_uc_44 SUM[3]=N_uc_43
+ SUM[2]=N_uc_42 SUM[1]=N_uc_41 SUM[0]=N_uc_40 VDD=VDD VSS=VSS
Xmult_28 unpu_pe_15_DW_mult_uns_0_DW_mult_uns_16 $PINS a[7]=weight_reg[7]
+ a[6]=weight_reg[6] a[5]=weight_reg[5] a[4]=weight_reg[4] a[3]=weight_reg[3]
+ a[2]=weight_reg[2] a[1]=weight_reg[1] a[0]=weight_reg[0] b[7]=act_in[7]
+ b[6]=act_in[6] b[5]=act_in[5] b[4]=act_in[4] b[3]=act_in[3] b[2]=act_in[2]
+ b[1]=act_in[1] b[0]=act_in[0] product[15]=N_uc_20 product[14]=N_uc_19
+ product[13]=N_uc_18 product[12]=N_uc_17 product[11]=N_uc_16 product[10]=N_uc_15
+ product[9]=N_uc_14 product[8]=N_uc_13 product[7]=N_uc_12 product[6]=N_uc_11
+ product[5]=N_uc_10 product[4]=N_uc_9 product[3]=N_uc_8 product[2]=N_uc_7
+ product[1]=N_uc_6 product[0]=N_uc_5 VDD=VDD VSS=VSS
Xmult_30 unpu_pe_15_DW_mult_tc_0_DW_mult_tc_15 $PINS a[7]=weight_reg[7]
+ a[6]=weight_reg[6] a[5]=weight_reg[5] a[4]=weight_reg[4] a[3]=weight_reg[3]
+ a[2]=weight_reg[2] a[1]=weight_reg[1] a[0]=weight_reg[0] b[7]=act_in[7]
+ b[6]=act_in[6] b[5]=act_in[5] b[4]=act_in[4] b[3]=act_in[3] b[2]=act_in[2]
+ b[1]=act_in[1] b[0]=act_in[0] product[15]=N_uc_36 product[14]=N_uc_35
+ product[13]=N_uc_34 product[12]=N_uc_33 product[11]=N_uc_32 product[10]=N_uc_31
+ product[9]=N_uc_30 product[8]=N_uc_29 product[7]=N_uc_28 product[6]=N_uc_27
+ product[5]=N_uc_26 product[4]=N_uc_25 product[3]=N_uc_24 product[2]=N_uc_23
+ product[1]=N_uc_22 product[0]=N_uc_21 VDD=VDD VSS=VSS
Xpsum_out_reg_31_ dfcrq2 $PINS D=n47 CP=ZCTSNET_1 CDN=rst_n Q=aps_rename_47_
+ VDD=VDD VSS=VSS
Xpsum_out_reg_30_ dfcrq2 $PINS D=n46 CP=ZCTSNET_1 CDN=rst_n Q=aps_rename_48_
+ VDD=VDD VSS=VSS
Xpsum_out_reg_29_ dfcrq2 $PINS D=n45 CP=ZCTSNET_1 CDN=rst_n Q=aps_rename_49_
+ VDD=VDD VSS=VSS
Xpsum_out_reg_28_ dfcrq2 $PINS D=n44 CP=ZCTSNET_1 CDN=rst_n Q=psum_out[28]
+ VDD=VDD VSS=VSS
Xpsum_out_reg_27_ dfcrq2 $PINS D=n43 CP=ZCTSNET_1 CDN=rst_n Q=aps_rename_50_
+ VDD=VDD VSS=VSS
Xpsum_out_reg_26_ dfcrq2 $PINS D=n42 CP=ZCTSNET_1 CDN=HFSNET_8 Q=aps_rename_51_
+ VDD=VDD VSS=VSS
Xpsum_out_reg_25_ dfcrq2 $PINS D=n41 CP=ZCTSNET_0 CDN=rst_n Q=aps_rename_52_
+ VDD=VDD VSS=VSS
Xpsum_out_reg_24_ dfcrq2 $PINS D=n40 CP=ZCTSNET_0 CDN=HFSNET_7 Q=aps_rename_53_
+ VDD=VDD VSS=VSS
Xpsum_out_reg_23_ dfcrq2 $PINS D=n39 CP=ZCTSNET_0 CDN=HFSNET_7 Q=aps_rename_54_
+ VDD=VDD VSS=VSS
Xpsum_out_reg_22_ dfcrq2 $PINS D=n38 CP=ZCTSNET_1 CDN=HFSNET_8 Q=aps_rename_55_
+ VDD=VDD VSS=VSS
Xpsum_out_reg_21_ dfcrq2 $PINS D=n37 CP=ZCTSNET_1 CDN=HFSNET_8 Q=aps_rename_56_
+ VDD=VDD VSS=VSS
Xpsum_out_reg_20_ dfcrq2 $PINS D=n36 CP=ZCTSNET_1 CDN=HFSNET_8 Q=aps_rename_57_
+ VDD=VDD VSS=VSS
Xpsum_out_reg_19_ dfcrq2 $PINS D=n35 CP=ZCTSNET_1 CDN=HFSNET_8 Q=aps_rename_58_
+ VDD=VDD VSS=VSS
Xpsum_out_reg_18_ dfcrq2 $PINS D=n34 CP=ZCTSNET_1 CDN=HFSNET_8 Q=aps_rename_59_
+ VDD=VDD VSS=VSS
Xpsum_out_reg_17_ dfcrq2 $PINS D=n33 CP=ZCTSNET_1 CDN=HFSNET_8 Q=aps_rename_60_
+ VDD=VDD VSS=VSS
Xweight_reg_reg_7_ dfcrq2 $PINS D=n56 CP=ZCTSNET_1 CDN=HFSNET_8 Q=weight_reg[7]
+ VDD=VDD VSS=VSS
Xpsum_out_reg_16_ dfcrq2 $PINS D=n32 CP=ZCTSNET_1 CDN=HFSNET_8 Q=aps_rename_61_
+ VDD=VDD VSS=VSS
Xact_out_reg_7_ dfcrq2 $PINS D=n15 CP=ZCTSNET_1 CDN=HFSNET_7 Q=aps_rename_42_
+ VDD=VDD VSS=VSS
Xweight_reg_reg_6_ dfcrq2 $PINS D=n55 CP=ZCTSNET_1 CDN=HFSNET_8 Q=weight_reg[6]
+ VDD=VDD VSS=VSS
Xpsum_out_reg_15_ dfcrq2 $PINS D=n31 CP=ZCTSNET_1 CDN=HFSNET_8 Q=aps_rename_62_
+ VDD=VDD VSS=VSS
Xact_out_reg_5_ dfcrq2 $PINS D=n13 CP=ZCTSNET_1 CDN=HFSNET_8 Q=act_out[5]
+ VDD=VDD VSS=VSS
Xact_out_reg_6_ dfcrq2 $PINS D=n14 CP=ZCTSNET_1 CDN=HFSNET_8 Q=aps_rename_43_
+ VDD=VDD VSS=VSS
Xact_out_reg_0_ dfcrq2 $PINS D=n8 CP=ZCTSNET_1 CDN=HFSNET_8 Q=act_out[0]
+ VDD=VDD VSS=VSS
Xact_out_reg_1_ dfcrq2 $PINS D=n9 CP=ZCTSNET_1 CDN=HFSNET_8 Q=act_out[1]
+ VDD=VDD VSS=VSS
Xact_out_reg_3_ dfcrq2 $PINS D=n11 CP=ZCTSNET_1 CDN=HFSNET_7 Q=aps_rename_45_
+ VDD=VDD VSS=VSS
Xact_out_reg_2_ dfcrq2 $PINS D=n10 CP=ZCTSNET_1 CDN=HFSNET_8 Q=aps_rename_46_
+ VDD=VDD VSS=VSS
Xweight_reg_reg_0_ dfcrq2 $PINS D=n49 CP=ZCTSNET_1 CDN=rst_n Q=weight_reg[0]
+ VDD=VDD VSS=VSS
Xact_out_reg_4_ dfcrq2 $PINS D=n12 CP=ZCTSNET_1 CDN=HFSNET_8 Q=aps_rename_44_
+ VDD=VDD VSS=VSS
Xweight_reg_reg_5_ dfcrq2 $PINS D=n54 CP=ZCTSNET_1 CDN=rst_n Q=weight_reg[5]
+ VDD=VDD VSS=VSS
Xpsum_out_reg_14_ dfcrq2 $PINS D=n30 CP=ZCTSNET_1 CDN=HFSNET_8 Q=aps_rename_63_
+ VDD=VDD VSS=VSS
Xweight_reg_reg_4_ dfcrq2 $PINS D=n53 CP=ZCTSNET_1 CDN=HFSNET_8 Q=weight_reg[4]
+ VDD=VDD VSS=VSS
Xweight_reg_reg_3_ dfcrq2 $PINS D=n52 CP=ZCTSNET_1 CDN=HFSNET_7 Q=weight_reg[3]
+ VDD=VDD VSS=VSS
Xweight_reg_reg_2_ dfcrq2 $PINS D=n51 CP=ZCTSNET_1 CDN=rst_n Q=weight_reg[2]
+ VDD=VDD VSS=VSS
Xweight_reg_reg_1_ dfcrq2 $PINS D=n50 CP=ZCTSNET_1 CDN=HFSNET_8 Q=weight_reg[1]
+ VDD=VDD VSS=VSS
Xpsum_out_reg_13_ dfcrq2 $PINS D=n29 CP=ZCTSNET_1 CDN=HFSNET_7 Q=aps_rename_64_
+ VDD=VDD VSS=VSS
Xpsum_out_reg_12_ dfcrq2 $PINS D=n28 CP=ZCTSNET_1 CDN=HFSNET_7 Q=aps_rename_65_
+ VDD=VDD VSS=VSS
Xpsum_out_reg_11_ dfcrq2 $PINS D=n27 CP=ZCTSNET_1 CDN=HFSNET_7 Q=aps_rename_66_
+ VDD=VDD VSS=VSS
Xpsum_out_reg_10_ dfcrq2 $PINS D=n26 CP=ZCTSNET_1 CDN=HFSNET_7 Q=aps_rename_67_
+ VDD=VDD VSS=VSS
Xpsum_out_reg_9_ dfcrq2 $PINS D=n25 CP=ZCTSNET_1 CDN=HFSNET_7 Q=aps_rename_68_
+ VDD=VDD VSS=VSS
Xpsum_out_reg_8_ dfcrq2 $PINS D=n24 CP=ZCTSNET_1 CDN=HFSNET_7 Q=aps_rename_69_
+ VDD=VDD VSS=VSS
Xpsum_out_reg_7_ dfcrq2 $PINS D=n23 CP=ZCTSNET_1 CDN=HFSNET_7 Q=aps_rename_70_
+ VDD=VDD VSS=VSS
Xpsum_out_reg_6_ dfcrq2 $PINS D=n22 CP=ZCTSNET_1 CDN=HFSNET_7 Q=aps_rename_71_
+ VDD=VDD VSS=VSS
Xpsum_out_reg_5_ dfcrq2 $PINS D=n21 CP=ZCTSNET_1 CDN=HFSNET_7 Q=aps_rename_72_
+ VDD=VDD VSS=VSS
Xpsum_out_reg_4_ dfcrq2 $PINS D=n20 CP=ZCTSNET_1 CDN=HFSNET_7 Q=aps_rename_73_
+ VDD=VDD VSS=VSS
Xpsum_out_reg_3_ dfcrq2 $PINS D=n19 CP=ZCTSNET_1 CDN=HFSNET_7 Q=aps_rename_74_
+ VDD=VDD VSS=VSS
Xpsum_out_reg_2_ dfcrq2 $PINS D=n18 CP=ZCTSNET_1 CDN=HFSNET_8 Q=aps_rename_75_
+ VDD=VDD VSS=VSS
Xpsum_out_reg_1_ dfcrq2 $PINS D=n17 CP=ZCTSNET_1 CDN=HFSNET_8 Q=aps_rename_76_
+ VDD=VDD VSS=VSS
Xpsum_out_reg_0_ dfcrq2 $PINS D=n16 CP=ZCTSNET_1 CDN=HFSNET_7 Q=aps_rename_77_
+ VDD=VDD VSS=VSS
XU59 inv0d2 $PINS I=n4 ZN=n2 VDD=VDD VSS=VSS
XHFSBUF_26718_586 bufbd1 $PINS I=HFSNET_6 Z=HFSNET_3 VDD=VDD VSS=VSS
XHFSINV_26510_594 inv0d1 $PINS I=HFSNET_6 ZN=HFSNET_5 VDD=VDD VSS=VSS
XHFSINV_15943_669 inv0d2 $PINS I=HFSNET_9 ZN=HFSNET_8 VDD=VDD VSS=VSS
XU71 inv0d0 $PINS I=n6 ZN=n64 VDD=VDD VSS=VSS
Xcopt_h_inst_3086 dl02d1 $PINS I=aps_rename_77_ Z=psum_out[0] VDD=VDD VSS=VSS
Xcopt_h_inst_3124 dl02d1 $PINS I=aps_rename_54_ Z=psum_out[23] VDD=VDD VSS=VSS
XU74 nd02d1 $PINS A1=weight_load A2=HFSNET_3 ZN=n6 VDD=VDD VSS=VSS
Xcopt_h_inst_3139 dl01d1 $PINS I=act_out[0] Z=copt_net_309 VDD=VDD VSS=VSS
Xcopt_h_inst_3143 dl02d1 $PINS I=aps_rename_53_ Z=psum_out[24] VDD=VDD VSS=VSS
Xcopt_h_inst_3144 dl02d1 $PINS I=aps_rename_55_ Z=psum_out[22] VDD=VDD VSS=VSS
XU78 nd02d1 $PINS A1=N_uc_36 A2=mode_unsigned ZN=n4 VDD=VDD VSS=VSS
XHFSINV_16286_546 inv0d1 $PINS I=HFSNET_2 ZN=HFSNET_1 VDD=VDD VSS=VSS
Xcopt_h_inst_3145 dl01d1 $PINS I=aps_rename_50_ Z=psum_out[27] VDD=VDD VSS=VSS
Xcopt_h_inst_3146 dl02d1 $PINS I=aps_rename_56_ Z=psum_out[21] VDD=VDD VSS=VSS
Xcopt_h_inst_3148 dl02d1 $PINS I=aps_rename_48_ Z=psum_out[30] VDD=VDD VSS=VSS
Xcopt_h_inst_3150 dl02d1 $PINS I=aps_rename_63_ Z=psum_out[14] VDD=VDD VSS=VSS
Xcopt_h_inst_3152 dl02d1 $PINS I=aps_rename_58_ Z=psum_out[19] VDD=VDD VSS=VSS
Xcopt_h_inst_3153 dl02d1 $PINS I=psum_out[28] Z=copt_net_323 VDD=VDD VSS=VSS
Xcopt_h_inst_3155 dl02d1 $PINS I=aps_rename_52_ Z=psum_out[25] VDD=VDD VSS=VSS
Xcopt_h_inst_3156 dl02d1 $PINS I=aps_rename_64_ Z=psum_out[13] VDD=VDD VSS=VSS
Xcopt_h_inst_3157 dl01d1 $PINS I=aps_rename_47_ Z=psum_out[31] VDD=VDD VSS=VSS
Xcopt_h_inst_3158 dl01d1 $PINS I=aps_rename_57_ Z=psum_out[20] VDD=VDD VSS=VSS
Xcopt_h_inst_3159 dl01d1 $PINS I=aps_rename_75_ Z=psum_out[2] VDD=VDD VSS=VSS
Xcopt_h_inst_3161 dl02d1 $PINS I=aps_rename_68_ Z=psum_out[9] VDD=VDD VSS=VSS
Xcopt_h_inst_3162 dl01d1 $PINS I=aps_rename_49_ Z=psum_out[29] VDD=VDD VSS=VSS
Xcopt_h_inst_3163 dl01d1 $PINS I=aps_rename_60_ Z=psum_out[17] VDD=VDD VSS=VSS
Xcopt_h_inst_3164 dl02d1 $PINS I=act_out[1] Z=copt_net_334 VDD=VDD VSS=VSS
Xcopt_h_inst_3168 dl02d1 $PINS I=aps_rename_59_ Z=psum_out[18] VDD=VDD VSS=VSS
Xcopt_h_inst_3169 dl02d1 $PINS I=aps_rename_66_ Z=psum_out[11] VDD=VDD VSS=VSS
Xcopt_h_inst_3172 dl02d1 $PINS I=aps_rename_61_ Z=psum_out[16] VDD=VDD VSS=VSS
Xcopt_h_inst_3173 dl02d1 $PINS I=aps_rename_65_ Z=psum_out[12] VDD=VDD VSS=VSS
Xcopt_h_inst_3174 dl01d1 $PINS I=aps_rename_67_ Z=psum_out[10] VDD=VDD VSS=VSS
Xcopt_h_inst_3175 dl01d1 $PINS I=aps_rename_71_ Z=psum_out[6] VDD=VDD VSS=VSS
Xcopt_h_inst_3176 dl02d1 $PINS I=aps_rename_62_ Z=psum_out[15] VDD=VDD VSS=VSS
Xcopt_h_inst_3177 dl01d1 $PINS I=aps_rename_70_ Z=psum_out[7] VDD=VDD VSS=VSS
Xcopt_h_inst_3178 dl01d1 $PINS I=aps_rename_69_ Z=psum_out[8] VDD=VDD VSS=VSS
Xcopt_h_inst_3181 dl01d1 $PINS I=aps_rename_73_ Z=psum_out[4] VDD=VDD VSS=VSS
Xcopt_h_inst_3182 dl01d1 $PINS I=aps_rename_74_ Z=psum_out[3] VDD=VDD VSS=VSS
Xcopt_h_inst_3189 dl01d1 $PINS I=aps_rename_72_ Z=psum_out[5] VDD=VDD VSS=VSS
Xcopt_h_inst_3288 dl02d1 $PINS I=aps_rename_51_ Z=psum_out[26] VDD=VDD VSS=VSS
Xcopt_h_inst_3395 dl01d1 $PINS I=aps_rename_76_ Z=psum_out[1] VDD=VDD VSS=VSS
Xcopt_h_inst_3445 dl01d1 $PINS I=aps_rename_43_ Z=act_out[6] VDD=VDD VSS=VSS
Xcopt_h_inst_3452 dl01d1 $PINS I=aps_rename_45_ Z=act_out[3] VDD=VDD VSS=VSS
Xcopt_h_inst_3533 dl01d1 $PINS I=aps_rename_46_ Z=act_out[2] VDD=VDD VSS=VSS
Xcopt_h_inst_3542 dl01d1 $PINS I=aps_rename_44_ Z=act_out[4] VDD=VDD VSS=VSS
Xcopt_h_inst_3572 dl01d1 $PINS I=act_out[5] Z=copt_net_741 VDD=VDD VSS=VSS
Xcopt_h_inst_3640 dl01d1 $PINS I=aps_rename_42_ Z=act_out[7] VDD=VDD VSS=VSS
Xcopt_h_inst_4009 dl02d1 $PINS I=weight_reg[3] Z=copt_net_1177 VDD=VDD VSS=VSS
Xcopt_h_inst_4036 dl02d1 $PINS I=weight_reg[7] Z=copt_net_1204 VDD=VDD VSS=VSS
Xcopt_h_inst_4043 dl02d1 $PINS I=weight_reg[1] Z=copt_net_1211 VDD=VDD VSS=VSS
Xcopt_h_inst_4112 dl02d1 $PINS I=weight_reg[0] Z=copt_net_1280 VDD=VDD VSS=VSS
Xcopt_h_inst_4248 dl02d1 $PINS I=weight_reg[2] Z=copt_net_1416 VDD=VDD VSS=VSS
Xcopt_h_inst_4348 dl02d1 $PINS I=weight_reg[6] Z=copt_net_1516 VDD=VDD VSS=VSS
Xcopt_h_inst_4792 dl02d1 $PINS I=weight_reg[4] Z=copt_net_1959 VDD=VDD VSS=VSS
Xcopt_h_inst_4816 dl02d1 $PINS I=weight_reg[5] Z=copt_net_1983 VDD=VDD VSS=VSS
.ENDS

.SUBCKT unpu_grid ZCTSNET_107 rst_n array_en mode_unsigned weight_load[15]
+ weight_load[14] weight_load[13] weight_load[12] weight_load[11]
+ weight_load[10] weight_load[9] weight_load[8] weight_load[7] weight_load[6]
+ weight_load[5] weight_load[4] weight_load[3] weight_load[2] weight_load[1]
+ weight_load[0] weight_in[127] weight_in[126] weight_in[125] weight_in[124]
+ weight_in[123] weight_in[122] weight_in[121] weight_in[120] weight_in[119]
+ weight_in[118] weight_in[117] weight_in[116] weight_in[115] weight_in[114]
+ weight_in[113] weight_in[112] weight_in[111] weight_in[110] weight_in[109]
+ weight_in[108] weight_in[107] weight_in[106] weight_in[105] weight_in[104]
+ weight_in[103] weight_in[102] weight_in[101] weight_in[100] weight_in[99]
+ weight_in[98] weight_in[97] weight_in[96] weight_in[95] weight_in[94]
+ weight_in[93] weight_in[92] weight_in[91] weight_in[90] weight_in[89]
+ weight_in[88] weight_in[87] weight_in[86] weight_in[85] weight_in[84]
+ weight_in[83] weight_in[82] weight_in[81] weight_in[80] weight_in[79]
+ weight_in[78] weight_in[77] weight_in[76] weight_in[75] weight_in[74]
+ weight_in[73] weight_in[72] weight_in[71] weight_in[70] weight_in[69]
+ weight_in[68] weight_in[67] weight_in[66] weight_in[65] weight_in[64]
+ weight_in[63] weight_in[62] weight_in[61] weight_in[60] weight_in[59]
+ weight_in[58] weight_in[57] weight_in[56] weight_in[55] weight_in[54]
+ weight_in[53] weight_in[52] weight_in[51] weight_in[50] weight_in[49]
+ weight_in[48] weight_in[47] weight_in[46] weight_in[45] weight_in[44]
+ weight_in[43] weight_in[42] weight_in[41] weight_in[40] weight_in[39]
+ weight_in[38] weight_in[37] weight_in[36] weight_in[35] weight_in[34]
+ weight_in[33] weight_in[32] weight_in[31] weight_in[30] weight_in[29]
+ weight_in[28] weight_in[27] weight_in[26] weight_in[25] weight_in[24]
+ weight_in[23] weight_in[22] weight_in[21] weight_in[20] weight_in[19]
+ weight_in[18] weight_in[17] weight_in[16] weight_in[15] weight_in[14]
+ weight_in[13] weight_in[12] weight_in[11] weight_in[10] weight_in[9]
+ weight_in[8] weight_in[7] weight_in[6] weight_in[5] weight_in[4] weight_in[3]
+ weight_in[2] weight_in[1] weight_in[0] act_in[31] act_in[30] act_in[29]
+ act_in[28] act_in[27] act_in[26] act_in[25] act_in[24] act_in[23] act_in[22]
+ act_in[21] act_in[20] act_in[19] act_in[18] act_in[17] act_in[16] act_in[15]
+ act_in[14] act_in[13] act_in[12] act_in[11] act_in[10] act_in[9] act_in[8]
+ act_in[7] act_in[6] act_in[5] act_in[4] act_in[3] act_in[2] act_in[1]
+ act_in[0] psum_in[127] psum_in[126] psum_in[125] psum_in[124] psum_in[123]
+ psum_in[122] psum_in[121] psum_in[120] psum_in[119] psum_in[118] psum_in[117]
+ psum_in[116] psum_in[115] psum_in[114] psum_in[113] psum_in[112] psum_in[111]
+ psum_in[110] psum_in[109] psum_in[108] psum_in[107] psum_in[106] psum_in[105]
+ psum_in[104] psum_in[103] psum_in[102] psum_in[101] psum_in[100] psum_in[99]
+ psum_in[98] psum_in[97] psum_in[96] psum_in[95] psum_in[94] psum_in[93]
+ psum_in[92] psum_in[91] psum_in[90] psum_in[89] psum_in[88] psum_in[87]
+ psum_in[86] psum_in[85] psum_in[84] psum_in[83] psum_in[82] psum_in[81]
+ psum_in[80] psum_in[79] psum_in[78] psum_in[77] psum_in[76] psum_in[75]
+ psum_in[74] psum_in[73] psum_in[72] psum_in[71] psum_in[70] psum_in[69]
+ psum_in[68] psum_in[67] psum_in[66] psum_in[65] psum_in[64] psum_in[63]
+ psum_in[62] psum_in[61] psum_in[60] psum_in[59] psum_in[58] psum_in[57]
+ psum_in[56] psum_in[55] psum_in[54] psum_in[53] psum_in[52] psum_in[51]
+ psum_in[50] psum_in[49] psum_in[48] psum_in[47] psum_in[46] psum_in[45]
+ psum_in[44] psum_in[43] psum_in[42] psum_in[41] psum_in[40] psum_in[39]
+ psum_in[38] psum_in[37] psum_in[36] psum_in[35] psum_in[34] psum_in[33]
+ psum_in[32] psum_in[31] psum_in[30] psum_in[29] psum_in[28] psum_in[27]
+ psum_in[26] psum_in[25] psum_in[24] psum_in[23] psum_in[22] psum_in[21]
+ psum_in[20] psum_in[19] psum_in[18] psum_in[17] psum_in[16] psum_in[15]
+ psum_in[14] psum_in[13] psum_in[12] psum_in[11] psum_in[10] psum_in[9]
+ psum_in[8] psum_in[7] psum_in[6] psum_in[5] psum_in[4] psum_in[3] psum_in[2]
+ psum_in[1] psum_in[0] act_out[31] act_out[30] act_out[29] act_out[28]
+ act_out[27] act_out[26] act_out[25] act_out[24] act_out[23] act_out[22]
+ act_out[21] act_out[20] act_out[19] act_out[18] act_out[17] act_out[16]
+ act_out[15] act_out[14] act_out[13] act_out[12] act_out[11] act_out[10]
+ act_out[9] act_out[8] act_out[7] act_out[6] act_out[5] act_out[4] act_out[3]
+ act_out[2] act_out[1] act_out[0] psum_out[127] psum_out[126] psum_out[125]
+ psum_out[124] psum_out[123] psum_out[122] psum_out[121] psum_out[120]
+ psum_out[119] psum_out[118] psum_out[117] psum_out[116] psum_out[115]
+ psum_out[114] psum_out[113] psum_out[112] psum_out[111] psum_out[110]
+ psum_out[109] psum_out[108] psum_out[107] psum_out[106] psum_out[105]
+ psum_out[104] psum_out[103] psum_out[102] psum_out[101] psum_out[100]
+ psum_out[99] psum_out[98] psum_out[97] psum_out[96] psum_out[95] psum_out[94]
+ psum_out[93] psum_out[92] psum_out[91] psum_out[90] psum_out[89] psum_out[88]
+ psum_out[87] psum_out[86] psum_out[85] psum_out[84] psum_out[83] psum_out[82]
+ psum_out[81] psum_out[80] psum_out[79] psum_out[78] psum_out[77] psum_out[76]
+ psum_out[75] psum_out[74] psum_out[73] psum_out[72] psum_out[71] psum_out[70]
+ psum_out[69] psum_out[68] psum_out[67] psum_out[66] psum_out[65] psum_out[64]
+ psum_out[63] psum_out[62] psum_out[61] psum_out[60] psum_out[59] psum_out[58]
+ psum_out[57] psum_out[56] psum_out[55] psum_out[54] psum_out[53] psum_out[52]
+ psum_out[51] psum_out[50] psum_out[49] psum_out[48] psum_out[47] psum_out[46]
+ psum_out[45] psum_out[44] psum_out[43] psum_out[42] psum_out[41] psum_out[40]
+ psum_out[39] psum_out[38] psum_out[37] psum_out[36] psum_out[35] psum_out[34]
+ psum_out[33] psum_out[32] psum_out[31] psum_out[30] psum_out[29] psum_out[28]
+ psum_out[27] psum_out[26] psum_out[25] psum_out[24] psum_out[23] psum_out[22]
+ psum_out[21] psum_out[20] psum_out[19] psum_out[18] psum_out[17] psum_out[16]
+ psum_out[15] psum_out[14] psum_out[13] psum_out[12] psum_out[11] psum_out[10]
+ psum_out[9] psum_out[8] psum_out[7] psum_out[6] psum_out[5] psum_out[4]
+ psum_out[3] psum_out[2] psum_out[1] psum_out[0] VDD VSS ZCTSNET_109
+ ZCTSNET_111 ZCTSNET_113 ZCTSNET_116 ZCTSNET_117 ZCTSNET_118 ZCTSNET_119
+ ZCTSNET_120 ZCTSNET_125 ZCTSNET_130 ctosc_gls_1 ctosc_gls_3 HFSNET_43
+ HFSNET_58 HFSNET_59 HFSNET_60 HFSNET_61 HFSNET_66 HFSNET_67 HFSNET_68
+ HFSNET_69 HFSNET_70 HFSNET_71 HFSNET_72 HFSNET_73 HFSNET_74 HFSNET_76
+ HFSNET_77 HFSNET_79 HFSNET_80 HFSNET_84 HFSNET_85 HFSNET_88 HFSNET_89
+ HFSNET_90 HFSNET_94 HFSNET_95 HFSNET_96 HFSNET_97 HFSNET_98 HFSNET_99
+ HFSNET_100 HFSNET_101 ZCTSNET_1 ZCTSNET_2 ZCTSNET_11 ZCTSNET_14 ZCTSNET_24
+ ZCTSNET_25 ZCTSNET_27 ZCTSNET_28 ZCTSNET_30
Xg_row_0__g_col_0__pe unpu_pe_15 $PINS rst_n=HFSNET_78 array_en=HFSNET_63
+ weight_load=weight_load[0] mode_unsigned=HFSNET_37 weight_in[7]=weight_in[7]
+ weight_in[6]=weight_in[6] weight_in[5]=weight_in[5] weight_in[4]=weight_in[4]
+ weight_in[3]=weight_in[3] weight_in[2]=weight_in[2] weight_in[1]=weight_in[1]
+ weight_in[0]=weight_in[0] act_in[7]=act_in[7] act_in[6]=act_in[6]
+ act_in[5]=act_in[5] act_in[4]=act_in[4] act_in[3]=act_in[3] act_in[2]=act_in[2]
+ act_in[1]=act_in[1] act_in[0]=act_in[0] psum_in[31]=psum_in[31]
+ psum_in[30]=psum_in[30] psum_in[29]=psum_in[29] psum_in[28]=psum_in[28]
+ psum_in[27]=psum_in[27] psum_in[26]=psum_in[26] psum_in[25]=psum_in[25]
+ psum_in[24]=psum_in[24] psum_in[23]=psum_in[23] psum_in[22]=psum_in[22]
+ psum_in[21]=psum_in[21] psum_in[20]=psum_in[20] psum_in[19]=psum_in[19]
+ psum_in[18]=psum_in[18] psum_in[17]=psum_in[17] psum_in[16]=psum_in[16]
+ psum_in[15]=psum_in[15] psum_in[14]=psum_in[14] psum_in[13]=psum_in[13]
+ psum_in[12]=psum_in[12] psum_in[11]=psum_in[11] psum_in[10]=psum_in[10]
+ psum_in[9]=psum_in[9] psum_in[8]=psum_in[8] psum_in[7]=psum_in[7]
+ psum_in[6]=psum_in[6] psum_in[5]=psum_in[5] psum_in[4]=psum_in[4]
+ psum_in[3]=psum_in[3] psum_in[2]=psum_in[2] psum_in[1]=psum_in[1]
+ psum_in[0]=psum_in[0] act_out[7]=g_row_0__g_col_1__pe_act_in[7]
+ act_out[6]=g_row_0__g_col_1__pe_act_in[6]
+ act_out[5]=g_row_0__g_col_1__pe_act_in[5]
+ act_out[4]=g_row_0__g_col_1__pe_act_in[4]
+ act_out[3]=g_row_0__g_col_1__pe_act_in[3]
+ act_out[2]=g_row_0__g_col_1__pe_act_in[2]
+ act_out[1]=g_row_0__g_col_1__pe_act_in[1]
+ act_out[0]=g_row_0__g_col_1__pe_act_in[0]
+ psum_out[31]=g_row_1__g_col_0__pe_psum_in[31]
+ psum_out[30]=g_row_1__g_col_0__pe_psum_in[30]
+ psum_out[29]=g_row_1__g_col_0__pe_psum_in[29]
+ psum_out[28]=g_row_1__g_col_0__pe_psum_in[28]
+ psum_out[27]=g_row_1__g_col_0__pe_psum_in[27]
+ psum_out[26]=g_row_1__g_col_0__pe_psum_in[26]
+ psum_out[25]=g_row_1__g_col_0__pe_psum_in[25]
+ psum_out[24]=g_row_1__g_col_0__pe_psum_in[24]
+ psum_out[23]=g_row_1__g_col_0__pe_psum_in[23]
+ psum_out[22]=g_row_1__g_col_0__pe_psum_in[22]
+ psum_out[21]=g_row_1__g_col_0__pe_psum_in[21]
+ psum_out[20]=g_row_1__g_col_0__pe_psum_in[20]
+ psum_out[19]=g_row_1__g_col_0__pe_psum_in[19]
+ psum_out[18]=g_row_1__g_col_0__pe_psum_in[18]
+ psum_out[17]=g_row_1__g_col_0__pe_psum_in[17]
+ psum_out[16]=g_row_1__g_col_0__pe_psum_in[16]
+ psum_out[15]=g_row_1__g_col_0__pe_psum_in[15]
+ psum_out[14]=g_row_1__g_col_0__pe_psum_in[14]
+ psum_out[13]=g_row_1__g_col_0__pe_psum_in[13]
+ psum_out[12]=g_row_1__g_col_0__pe_psum_in[12]
+ psum_out[11]=g_row_1__g_col_0__pe_psum_in[11]
+ psum_out[10]=g_row_1__g_col_0__pe_psum_in[10]
+ psum_out[9]=g_row_1__g_col_0__pe_psum_in[9]
+ psum_out[8]=g_row_1__g_col_0__pe_psum_in[8]
+ psum_out[7]=g_row_1__g_col_0__pe_psum_in[7]
+ psum_out[6]=g_row_1__g_col_0__pe_psum_in[6]
+ psum_out[5]=g_row_1__g_col_0__pe_psum_in[5]
+ psum_out[4]=g_row_1__g_col_0__pe_psum_in[4]
+ psum_out[3]=g_row_1__g_col_0__pe_psum_in[3]
+ psum_out[2]=g_row_1__g_col_0__pe_psum_in[2]
+ psum_out[1]=g_row_1__g_col_0__pe_psum_in[1]
+ psum_out[0]=g_row_1__g_col_0__pe_psum_in[0] VDD=VDD VSS=VSS
+ ZCTSNET_0=ZCTSNET_109 HFSNET_2=HFSNET_38 HFSNET_4=HFSNET_64 HFSNET_6=HFSNET_61
+ HFSNET_7=HFSNET_82 HFSNET_9=HFSNET_80 ZCTSNET_1=ZCTSNET_113
Xg_row_0__g_col_1__pe unpu_pe_14 $PINS ZCTSNET_8=ZCTSNET_1 rst_n=HFSNET_91
+ array_en=HFSNET_47 weight_load=weight_load[1] mode_unsigned=HFSNET_37
+ weight_in[7]=weight_in[15] weight_in[6]=weight_in[14]
+ weight_in[5]=weight_in[13] weight_in[4]=weight_in[12]
+ weight_in[3]=weight_in[11] weight_in[2]=weight_in[10] weight_in[1]=weight_in[9]
+ weight_in[0]=weight_in[8] act_in[7]=g_row_0__g_col_1__pe_act_in[7]
+ act_in[6]=g_row_0__g_col_1__pe_act_in[6]
+ act_in[5]=g_row_0__g_col_1__pe_act_in[5]
+ act_in[4]=g_row_0__g_col_1__pe_act_in[4]
+ act_in[3]=g_row_0__g_col_1__pe_act_in[3]
+ act_in[2]=g_row_0__g_col_1__pe_act_in[2]
+ act_in[1]=g_row_0__g_col_1__pe_act_in[1]
+ act_in[0]=g_row_0__g_col_1__pe_act_in[0] psum_in[31]=psum_in[63]
+ psum_in[30]=psum_in[62] psum_in[29]=psum_in[61] psum_in[28]=psum_in[60]
+ psum_in[27]=psum_in[59] psum_in[26]=psum_in[58] psum_in[25]=psum_in[57]
+ psum_in[24]=psum_in[56] psum_in[23]=psum_in[55] psum_in[22]=psum_in[54]
+ psum_in[21]=psum_in[53] psum_in[20]=psum_in[52] psum_in[19]=psum_in[51]
+ psum_in[18]=psum_in[50] psum_in[17]=psum_in[49] psum_in[16]=psum_in[48]
+ psum_in[15]=psum_in[47] psum_in[14]=psum_in[46] psum_in[13]=psum_in[45]
+ psum_in[12]=psum_in[44] psum_in[11]=psum_in[43] psum_in[10]=psum_in[42]
+ psum_in[9]=psum_in[41] psum_in[8]=psum_in[40] psum_in[7]=psum_in[39]
+ psum_in[6]=psum_in[38] psum_in[5]=psum_in[37] psum_in[4]=psum_in[36]
+ psum_in[3]=psum_in[35] psum_in[2]=psum_in[34] psum_in[1]=psum_in[33]
+ psum_in[0]=psum_in[32] act_out[7]=g_row_0__g_col_2__pe_act_in[7]
+ act_out[6]=g_row_0__g_col_2__pe_act_in[6]
+ act_out[5]=g_row_0__g_col_2__pe_act_in[5]
+ act_out[4]=g_row_0__g_col_2__pe_act_in[4]
+ act_out[3]=g_row_0__g_col_2__pe_act_in[3]
+ act_out[2]=g_row_0__g_col_2__pe_act_in[2]
+ act_out[1]=g_row_0__g_col_2__pe_act_in[1]
+ act_out[0]=g_row_0__g_col_2__pe_act_in[0]
+ psum_out[31]=g_row_1__g_col_1__pe_psum_in[31]
+ psum_out[30]=g_row_1__g_col_1__pe_psum_in[30]
+ psum_out[29]=g_row_1__g_col_1__pe_psum_in[29]
+ psum_out[28]=g_row_1__g_col_1__pe_psum_in[28]
+ psum_out[27]=g_row_1__g_col_1__pe_psum_in[27]
+ psum_out[26]=g_row_1__g_col_1__pe_psum_in[26]
+ psum_out[25]=g_row_1__g_col_1__pe_psum_in[25]
+ psum_out[24]=g_row_1__g_col_1__pe_psum_in[24]
+ psum_out[23]=g_row_1__g_col_1__pe_psum_in[23]
+ psum_out[22]=g_row_1__g_col_1__pe_psum_in[22]
+ psum_out[21]=g_row_1__g_col_1__pe_psum_in[21]
+ psum_out[20]=g_row_1__g_col_1__pe_psum_in[20]
+ psum_out[19]=g_row_1__g_col_1__pe_psum_in[19]
+ psum_out[18]=g_row_1__g_col_1__pe_psum_in[18]
+ psum_out[17]=g_row_1__g_col_1__pe_psum_in[17]
+ psum_out[16]=g_row_1__g_col_1__pe_psum_in[16]
+ psum_out[15]=g_row_1__g_col_1__pe_psum_in[15]
+ psum_out[14]=g_row_1__g_col_1__pe_psum_in[14]
+ psum_out[13]=g_row_1__g_col_1__pe_psum_in[13]
+ psum_out[12]=g_row_1__g_col_1__pe_psum_in[12]
+ psum_out[11]=g_row_1__g_col_1__pe_psum_in[11]
+ psum_out[10]=g_row_1__g_col_1__pe_psum_in[10]
+ psum_out[9]=g_row_1__g_col_1__pe_psum_in[9]
+ psum_out[8]=g_row_1__g_col_1__pe_psum_in[8]
+ psum_out[7]=g_row_1__g_col_1__pe_psum_in[7]
+ psum_out[6]=g_row_1__g_col_1__pe_psum_in[6]
+ psum_out[5]=g_row_1__g_col_1__pe_psum_in[5]
+ psum_out[4]=g_row_1__g_col_1__pe_psum_in[4]
+ psum_out[3]=g_row_1__g_col_1__pe_psum_in[3]
+ psum_out[2]=g_row_1__g_col_1__pe_psum_in[2]
+ psum_out[1]=g_row_1__g_col_1__pe_psum_in[1]
+ psum_out[0]=g_row_1__g_col_1__pe_psum_in[0] VDD=VDD VSS=VSS HFSNET_2=HFSNET_38
+ HFSNET_3=HFSNET_49 HFSNET_4=HFSNET_61 HFSNET_5=HFSNET_93 HFSNET_7=HFSNET_100
+ ZCTSNET_1=ZCTSNET_15
Xg_row_0__g_col_2__pe unpu_pe_13 $PINS rst_n=HFSNET_88 array_en=HFSNET_48
+ weight_load=weight_load[2] mode_unsigned=HFSNET_41 weight_in[7]=weight_in[23]
+ weight_in[6]=weight_in[22] weight_in[5]=weight_in[21]
+ weight_in[4]=weight_in[20] weight_in[3]=weight_in[19]
+ weight_in[2]=weight_in[18] weight_in[1]=weight_in[17]
+ weight_in[0]=weight_in[16] act_in[7]=g_row_0__g_col_2__pe_act_in[7]
+ act_in[6]=g_row_0__g_col_2__pe_act_in[6]
+ act_in[5]=g_row_0__g_col_2__pe_act_in[5]
+ act_in[4]=g_row_0__g_col_2__pe_act_in[4]
+ act_in[3]=g_row_0__g_col_2__pe_act_in[3]
+ act_in[2]=g_row_0__g_col_2__pe_act_in[2]
+ act_in[1]=g_row_0__g_col_2__pe_act_in[1]
+ act_in[0]=g_row_0__g_col_2__pe_act_in[0] psum_in[31]=psum_in[95]
+ psum_in[30]=psum_in[94] psum_in[29]=psum_in[93] psum_in[28]=psum_in[92]
+ psum_in[27]=psum_in[91] psum_in[26]=psum_in[90] psum_in[25]=psum_in[89]
+ psum_in[24]=psum_in[88] psum_in[23]=psum_in[87] psum_in[22]=psum_in[86]
+ psum_in[21]=psum_in[85] psum_in[20]=psum_in[84] psum_in[19]=psum_in[83]
+ psum_in[18]=psum_in[82] psum_in[17]=psum_in[81] psum_in[16]=psum_in[80]
+ psum_in[15]=psum_in[79] psum_in[14]=psum_in[78] psum_in[13]=psum_in[77]
+ psum_in[12]=psum_in[76] psum_in[11]=psum_in[75] psum_in[10]=psum_in[74]
+ psum_in[9]=psum_in[73] psum_in[8]=psum_in[72] psum_in[7]=psum_in[71]
+ psum_in[6]=psum_in[70] psum_in[5]=psum_in[69] psum_in[4]=psum_in[68]
+ psum_in[3]=psum_in[67] psum_in[2]=psum_in[66] psum_in[1]=psum_in[65]
+ psum_in[0]=psum_in[64] act_out[7]=g_row_0__g_col_3__pe_act_in[7]
+ act_out[6]=g_row_0__g_col_3__pe_act_in[6]
+ act_out[5]=g_row_0__g_col_3__pe_act_in[5]
+ act_out[4]=g_row_0__g_col_3__pe_act_in[4]
+ act_out[3]=g_row_0__g_col_3__pe_act_in[3]
+ act_out[2]=g_row_0__g_col_3__pe_act_in[2]
+ act_out[1]=g_row_0__g_col_3__pe_act_in[1]
+ act_out[0]=g_row_0__g_col_3__pe_act_in[0]
+ psum_out[31]=g_row_1__g_col_2__pe_psum_in[31]
+ psum_out[30]=g_row_1__g_col_2__pe_psum_in[30]
+ psum_out[29]=g_row_1__g_col_2__pe_psum_in[29]
+ psum_out[28]=g_row_1__g_col_2__pe_psum_in[28]
+ psum_out[27]=g_row_1__g_col_2__pe_psum_in[27]
+ psum_out[26]=g_row_1__g_col_2__pe_psum_in[26]
+ psum_out[25]=g_row_1__g_col_2__pe_psum_in[25]
+ psum_out[24]=g_row_1__g_col_2__pe_psum_in[24]
+ psum_out[23]=g_row_1__g_col_2__pe_psum_in[23]
+ psum_out[22]=g_row_1__g_col_2__pe_psum_in[22]
+ psum_out[21]=g_row_1__g_col_2__pe_psum_in[21]
+ psum_out[20]=g_row_1__g_col_2__pe_psum_in[20]
+ psum_out[19]=g_row_1__g_col_2__pe_psum_in[19]
+ psum_out[18]=g_row_1__g_col_2__pe_psum_in[18]
+ psum_out[17]=g_row_1__g_col_2__pe_psum_in[17]
+ psum_out[16]=g_row_1__g_col_2__pe_psum_in[16]
+ psum_out[15]=g_row_1__g_col_2__pe_psum_in[15]
+ psum_out[14]=g_row_1__g_col_2__pe_psum_in[14]
+ psum_out[13]=g_row_1__g_col_2__pe_psum_in[13]
+ psum_out[12]=g_row_1__g_col_2__pe_psum_in[12]
+ psum_out[11]=g_row_1__g_col_2__pe_psum_in[11]
+ psum_out[10]=g_row_1__g_col_2__pe_psum_in[10]
+ psum_out[9]=g_row_1__g_col_2__pe_psum_in[9]
+ psum_out[8]=g_row_1__g_col_2__pe_psum_in[8]
+ psum_out[7]=g_row_1__g_col_2__pe_psum_in[7]
+ psum_out[6]=g_row_1__g_col_2__pe_psum_in[6]
+ psum_out[5]=g_row_1__g_col_2__pe_psum_in[5]
+ psum_out[4]=g_row_1__g_col_2__pe_psum_in[4]
+ psum_out[3]=g_row_1__g_col_2__pe_psum_in[3]
+ psum_out[2]=g_row_1__g_col_2__pe_psum_in[2]
+ psum_out[1]=g_row_1__g_col_2__pe_psum_in[1]
+ psum_out[0]=g_row_1__g_col_2__pe_psum_in[0] VDD=VDD VSS=VSS
+ ZCTSNET_11=ZCTSNET_125 HFSNET_2=HFSNET_42 HFSNET_5=HFSNET_49 HFSNET_6=HFSNET_90
+ HFSNET_8=HFSNET_94 HFSNET_9=HFSNET_100 ZCTSNET_0=ZCTSNET_111
+ ZCTSNET_1=ZCTSNET_2
Xg_row_0__g_col_3__pe unpu_pe_12 $PINS ZCTSNET_7=ZCTSNET_120 rst_n=HFSNET_86
+ array_en=HFSNET_51 weight_load=weight_load[3] mode_unsigned=HFSNET_29
+ weight_in[7]=weight_in[31] weight_in[6]=weight_in[30]
+ weight_in[5]=weight_in[29] weight_in[4]=weight_in[28]
+ weight_in[3]=weight_in[27] weight_in[2]=weight_in[26]
+ weight_in[1]=weight_in[25] weight_in[0]=weight_in[24]
+ act_in[7]=g_row_0__g_col_3__pe_act_in[7]
+ act_in[6]=g_row_0__g_col_3__pe_act_in[6]
+ act_in[5]=g_row_0__g_col_3__pe_act_in[5]
+ act_in[4]=g_row_0__g_col_3__pe_act_in[4]
+ act_in[3]=g_row_0__g_col_3__pe_act_in[3]
+ act_in[2]=g_row_0__g_col_3__pe_act_in[2]
+ act_in[1]=g_row_0__g_col_3__pe_act_in[1]
+ act_in[0]=g_row_0__g_col_3__pe_act_in[0] psum_in[31]=psum_in[127]
+ psum_in[30]=psum_in[126] psum_in[29]=psum_in[125] psum_in[28]=psum_in[124]
+ psum_in[27]=psum_in[123] psum_in[26]=psum_in[122] psum_in[25]=psum_in[121]
+ psum_in[24]=psum_in[120] psum_in[23]=psum_in[119] psum_in[22]=psum_in[118]
+ psum_in[21]=psum_in[117] psum_in[20]=psum_in[116] psum_in[19]=psum_in[115]
+ psum_in[18]=psum_in[114] psum_in[17]=psum_in[113] psum_in[16]=psum_in[112]
+ psum_in[15]=psum_in[111] psum_in[14]=psum_in[110] psum_in[13]=psum_in[109]
+ psum_in[12]=psum_in[108] psum_in[11]=psum_in[107] psum_in[10]=psum_in[106]
+ psum_in[9]=psum_in[105] psum_in[8]=psum_in[104] psum_in[7]=psum_in[103]
+ psum_in[6]=psum_in[102] psum_in[5]=psum_in[101] psum_in[4]=psum_in[100]
+ psum_in[3]=psum_in[99] psum_in[2]=psum_in[98] psum_in[1]=psum_in[97]
+ psum_in[0]=psum_in[96] psum_out[31]=g_row_1__g_col_3__pe_psum_in[31]
+ psum_out[30]=g_row_1__g_col_3__pe_psum_in[30]
+ psum_out[29]=g_row_1__g_col_3__pe_psum_in[29]
+ psum_out[28]=g_row_1__g_col_3__pe_psum_in[28]
+ psum_out[27]=g_row_1__g_col_3__pe_psum_in[27]
+ psum_out[26]=g_row_1__g_col_3__pe_psum_in[26]
+ psum_out[25]=g_row_1__g_col_3__pe_psum_in[25]
+ psum_out[24]=g_row_1__g_col_3__pe_psum_in[24]
+ psum_out[23]=g_row_1__g_col_3__pe_psum_in[23]
+ psum_out[22]=g_row_1__g_col_3__pe_psum_in[22]
+ psum_out[21]=g_row_1__g_col_3__pe_psum_in[21]
+ psum_out[20]=g_row_1__g_col_3__pe_psum_in[20]
+ psum_out[19]=g_row_1__g_col_3__pe_psum_in[19]
+ psum_out[18]=g_row_1__g_col_3__pe_psum_in[18]
+ psum_out[17]=g_row_1__g_col_3__pe_psum_in[17]
+ psum_out[16]=g_row_1__g_col_3__pe_psum_in[16]
+ psum_out[15]=g_row_1__g_col_3__pe_psum_in[15]
+ psum_out[14]=g_row_1__g_col_3__pe_psum_in[14]
+ psum_out[13]=g_row_1__g_col_3__pe_psum_in[13]
+ psum_out[12]=g_row_1__g_col_3__pe_psum_in[12]
+ psum_out[11]=g_row_1__g_col_3__pe_psum_in[11]
+ psum_out[10]=g_row_1__g_col_3__pe_psum_in[10]
+ psum_out[9]=g_row_1__g_col_3__pe_psum_in[9]
+ psum_out[8]=g_row_1__g_col_3__pe_psum_in[8]
+ psum_out[7]=g_row_1__g_col_3__pe_psum_in[7]
+ psum_out[6]=g_row_1__g_col_3__pe_psum_in[6]
+ psum_out[5]=g_row_1__g_col_3__pe_psum_in[5]
+ psum_out[4]=g_row_1__g_col_3__pe_psum_in[4]
+ psum_out[3]=g_row_1__g_col_3__pe_psum_in[3]
+ psum_out[2]=g_row_1__g_col_3__pe_psum_in[2]
+ psum_out[1]=g_row_1__g_col_3__pe_psum_in[1]
+ psum_out[0]=g_row_1__g_col_3__pe_psum_in[0] VDD=VDD VSS=VSS
+ ZCTSNET_0=ZCTSNET_18 HFSNET_1=HFSNET_32 HFSNET_2=HFSNET_53 HFSNET_3=HFSNET_55
+ HFSNET_4=HFSNET_58 HFSNET_5=HFSNET_87 HFSNET_6=HFSNET_104 ZCTSNET_1=ZCTSNET_20
+ ZCTSNET_3=ZCTSNET_27
Xg_row_1__g_col_0__pe unpu_pe_11 $PINS rst_n=HFSNET_78 array_en=HFSNET_62
+ weight_load=weight_load[4] mode_unsigned=HFSNET_34 weight_in[7]=weight_in[39]
+ weight_in[6]=weight_in[38] weight_in[5]=weight_in[37]
+ weight_in[4]=weight_in[36] weight_in[3]=weight_in[35]
+ weight_in[2]=weight_in[34] weight_in[1]=weight_in[33]
+ weight_in[0]=weight_in[32] act_in[7]=act_in[15] act_in[6]=act_in[14]
+ act_in[5]=act_in[13] act_in[4]=act_in[12] act_in[3]=act_in[11]
+ act_in[2]=act_in[10] act_in[1]=act_in[9] act_in[0]=act_in[8]
+ psum_in[31]=g_row_1__g_col_0__pe_psum_in[31]
+ psum_in[30]=g_row_1__g_col_0__pe_psum_in[30]
+ psum_in[29]=g_row_1__g_col_0__pe_psum_in[29]
+ psum_in[28]=g_row_1__g_col_0__pe_psum_in[28]
+ psum_in[27]=g_row_1__g_col_0__pe_psum_in[27]
+ psum_in[26]=g_row_1__g_col_0__pe_psum_in[26]
+ psum_in[25]=g_row_1__g_col_0__pe_psum_in[25]
+ psum_in[24]=g_row_1__g_col_0__pe_psum_in[24]
+ psum_in[23]=g_row_1__g_col_0__pe_psum_in[23]
+ psum_in[22]=g_row_1__g_col_0__pe_psum_in[22]
+ psum_in[21]=g_row_1__g_col_0__pe_psum_in[21]
+ psum_in[20]=g_row_1__g_col_0__pe_psum_in[20]
+ psum_in[19]=g_row_1__g_col_0__pe_psum_in[19]
+ psum_in[18]=g_row_1__g_col_0__pe_psum_in[18]
+ psum_in[17]=g_row_1__g_col_0__pe_psum_in[17]
+ psum_in[16]=g_row_1__g_col_0__pe_psum_in[16]
+ psum_in[15]=g_row_1__g_col_0__pe_psum_in[15]
+ psum_in[14]=g_row_1__g_col_0__pe_psum_in[14]
+ psum_in[13]=g_row_1__g_col_0__pe_psum_in[13]
+ psum_in[12]=g_row_1__g_col_0__pe_psum_in[12]
+ psum_in[11]=g_row_1__g_col_0__pe_psum_in[11]
+ psum_in[10]=g_row_1__g_col_0__pe_psum_in[10]
+ psum_in[9]=g_row_1__g_col_0__pe_psum_in[9]
+ psum_in[8]=g_row_1__g_col_0__pe_psum_in[8]
+ psum_in[7]=g_row_1__g_col_0__pe_psum_in[7]
+ psum_in[6]=g_row_1__g_col_0__pe_psum_in[6]
+ psum_in[5]=g_row_1__g_col_0__pe_psum_in[5]
+ psum_in[4]=g_row_1__g_col_0__pe_psum_in[4]
+ psum_in[3]=g_row_1__g_col_0__pe_psum_in[3]
+ psum_in[2]=g_row_1__g_col_0__pe_psum_in[2]
+ psum_in[1]=g_row_1__g_col_0__pe_psum_in[1]
+ psum_in[0]=g_row_1__g_col_0__pe_psum_in[0]
+ act_out[7]=g_row_1__g_col_1__pe_act_in[7]
+ act_out[6]=g_row_1__g_col_1__pe_act_in[6]
+ act_out[5]=g_row_1__g_col_1__pe_act_in[5]
+ act_out[4]=g_row_1__g_col_1__pe_act_in[4]
+ act_out[3]=g_row_1__g_col_1__pe_act_in[3]
+ act_out[2]=g_row_1__g_col_1__pe_act_in[2]
+ act_out[1]=g_row_1__g_col_1__pe_act_in[1]
+ act_out[0]=g_row_1__g_col_1__pe_act_in[0]
+ psum_out[31]=g_row_2__g_col_0__pe_psum_in[31]
+ psum_out[30]=g_row_2__g_col_0__pe_psum_in[30]
+ psum_out[29]=g_row_2__g_col_0__pe_psum_in[29]
+ psum_out[28]=g_row_2__g_col_0__pe_psum_in[28]
+ psum_out[27]=g_row_2__g_col_0__pe_psum_in[27]
+ psum_out[26]=g_row_2__g_col_0__pe_psum_in[26]
+ psum_out[25]=g_row_2__g_col_0__pe_psum_in[25]
+ psum_out[24]=g_row_2__g_col_0__pe_psum_in[24]
+ psum_out[23]=g_row_2__g_col_0__pe_psum_in[23]
+ psum_out[22]=g_row_2__g_col_0__pe_psum_in[22]
+ psum_out[21]=g_row_2__g_col_0__pe_psum_in[21]
+ psum_out[20]=g_row_2__g_col_0__pe_psum_in[20]
+ psum_out[19]=g_row_2__g_col_0__pe_psum_in[19]
+ psum_out[18]=g_row_2__g_col_0__pe_psum_in[18]
+ psum_out[17]=g_row_2__g_col_0__pe_psum_in[17]
+ psum_out[16]=g_row_2__g_col_0__pe_psum_in[16]
+ psum_out[15]=g_row_2__g_col_0__pe_psum_in[15]
+ psum_out[14]=g_row_2__g_col_0__pe_psum_in[14]
+ psum_out[13]=g_row_2__g_col_0__pe_psum_in[13]
+ psum_out[12]=g_row_2__g_col_0__pe_psum_in[12]
+ psum_out[11]=g_row_2__g_col_0__pe_psum_in[11]
+ psum_out[10]=g_row_2__g_col_0__pe_psum_in[10]
+ psum_out[9]=g_row_2__g_col_0__pe_psum_in[9]
+ psum_out[8]=g_row_2__g_col_0__pe_psum_in[8]
+ psum_out[7]=g_row_2__g_col_0__pe_psum_in[7]
+ psum_out[6]=g_row_2__g_col_0__pe_psum_in[6]
+ psum_out[5]=g_row_2__g_col_0__pe_psum_in[5]
+ psum_out[4]=g_row_2__g_col_0__pe_psum_in[4]
+ psum_out[3]=g_row_2__g_col_0__pe_psum_in[3]
+ psum_out[2]=g_row_2__g_col_0__pe_psum_in[2]
+ psum_out[1]=g_row_2__g_col_0__pe_psum_in[1]
+ psum_out[0]=g_row_2__g_col_0__pe_psum_in[0] VDD=VDD VSS=VSS
+ ZCTSNET_0=ZCTSNET_109 HFSNET_2=HFSNET_36 HFSNET_3=HFSNET_37 HFSNET_4=HFSNET_63
+ HFSNET_5=HFSNET_64 HFSNET_7=HFSNET_65 HFSNET_8=HFSNET_61 HFSNET_9=HFSNET_81
+ HFSNET_10=HFSNET_82 HFSNET_11=HFSNET_83 ZCTSNET_1=ZCTSNET_113
Xg_row_1__g_col_1__pe unpu_pe_10 $PINS ZCTSNET_10=ZCTSNET_1 rst_n=HFSNET_91
+ array_en=HFSNET_44 weight_load=weight_load[5] mode_unsigned=HFSNET_35
+ weight_in[7]=weight_in[47] weight_in[6]=weight_in[46]
+ weight_in[5]=weight_in[45] weight_in[4]=weight_in[44]
+ weight_in[3]=weight_in[43] weight_in[2]=weight_in[42]
+ weight_in[1]=weight_in[41] weight_in[0]=weight_in[40]
+ act_in[7]=g_row_1__g_col_1__pe_act_in[7]
+ act_in[6]=g_row_1__g_col_1__pe_act_in[6]
+ act_in[5]=g_row_1__g_col_1__pe_act_in[5]
+ act_in[4]=g_row_1__g_col_1__pe_act_in[4]
+ act_in[3]=g_row_1__g_col_1__pe_act_in[3]
+ act_in[2]=g_row_1__g_col_1__pe_act_in[2]
+ act_in[1]=g_row_1__g_col_1__pe_act_in[1]
+ act_in[0]=g_row_1__g_col_1__pe_act_in[0]
+ psum_in[31]=g_row_1__g_col_1__pe_psum_in[31]
+ psum_in[30]=g_row_1__g_col_1__pe_psum_in[30]
+ psum_in[29]=g_row_1__g_col_1__pe_psum_in[29]
+ psum_in[28]=g_row_1__g_col_1__pe_psum_in[28]
+ psum_in[27]=g_row_1__g_col_1__pe_psum_in[27]
+ psum_in[26]=g_row_1__g_col_1__pe_psum_in[26]
+ psum_in[25]=g_row_1__g_col_1__pe_psum_in[25]
+ psum_in[24]=g_row_1__g_col_1__pe_psum_in[24]
+ psum_in[23]=g_row_1__g_col_1__pe_psum_in[23]
+ psum_in[22]=g_row_1__g_col_1__pe_psum_in[22]
+ psum_in[21]=g_row_1__g_col_1__pe_psum_in[21]
+ psum_in[20]=g_row_1__g_col_1__pe_psum_in[20]
+ psum_in[19]=g_row_1__g_col_1__pe_psum_in[19]
+ psum_in[18]=g_row_1__g_col_1__pe_psum_in[18]
+ psum_in[17]=g_row_1__g_col_1__pe_psum_in[17]
+ psum_in[16]=g_row_1__g_col_1__pe_psum_in[16]
+ psum_in[15]=g_row_1__g_col_1__pe_psum_in[15]
+ psum_in[14]=g_row_1__g_col_1__pe_psum_in[14]
+ psum_in[13]=g_row_1__g_col_1__pe_psum_in[13]
+ psum_in[12]=g_row_1__g_col_1__pe_psum_in[12]
+ psum_in[11]=g_row_1__g_col_1__pe_psum_in[11]
+ psum_in[10]=g_row_1__g_col_1__pe_psum_in[10]
+ psum_in[9]=g_row_1__g_col_1__pe_psum_in[9]
+ psum_in[8]=g_row_1__g_col_1__pe_psum_in[8]
+ psum_in[7]=g_row_1__g_col_1__pe_psum_in[7]
+ psum_in[6]=g_row_1__g_col_1__pe_psum_in[6]
+ psum_in[5]=g_row_1__g_col_1__pe_psum_in[5]
+ psum_in[4]=g_row_1__g_col_1__pe_psum_in[4]
+ psum_in[3]=g_row_1__g_col_1__pe_psum_in[3]
+ psum_in[2]=g_row_1__g_col_1__pe_psum_in[2]
+ psum_in[1]=g_row_1__g_col_1__pe_psum_in[1]
+ psum_in[0]=g_row_1__g_col_1__pe_psum_in[0]
+ act_out[7]=g_row_1__g_col_2__pe_act_in[7]
+ act_out[6]=g_row_1__g_col_2__pe_act_in[6]
+ act_out[5]=g_row_1__g_col_2__pe_act_in[5]
+ act_out[4]=g_row_1__g_col_2__pe_act_in[4]
+ act_out[3]=g_row_1__g_col_2__pe_act_in[3]
+ act_out[2]=g_row_1__g_col_2__pe_act_in[2]
+ act_out[1]=g_row_1__g_col_2__pe_act_in[1]
+ act_out[0]=g_row_1__g_col_2__pe_act_in[0]
+ psum_out[31]=g_row_2__g_col_1__pe_psum_in[31]
+ psum_out[30]=g_row_2__g_col_1__pe_psum_in[30]
+ psum_out[29]=g_row_2__g_col_1__pe_psum_in[29]
+ psum_out[28]=g_row_2__g_col_1__pe_psum_in[28]
+ psum_out[27]=g_row_2__g_col_1__pe_psum_in[27]
+ psum_out[26]=g_row_2__g_col_1__pe_psum_in[26]
+ psum_out[25]=g_row_2__g_col_1__pe_psum_in[25]
+ psum_out[24]=g_row_2__g_col_1__pe_psum_in[24]
+ psum_out[23]=g_row_2__g_col_1__pe_psum_in[23]
+ psum_out[22]=g_row_2__g_col_1__pe_psum_in[22]
+ psum_out[21]=g_row_2__g_col_1__pe_psum_in[21]
+ psum_out[20]=g_row_2__g_col_1__pe_psum_in[20]
+ psum_out[19]=g_row_2__g_col_1__pe_psum_in[19]
+ psum_out[18]=g_row_2__g_col_1__pe_psum_in[18]
+ psum_out[17]=g_row_2__g_col_1__pe_psum_in[17]
+ psum_out[16]=g_row_2__g_col_1__pe_psum_in[16]
+ psum_out[15]=g_row_2__g_col_1__pe_psum_in[15]
+ psum_out[14]=g_row_2__g_col_1__pe_psum_in[14]
+ psum_out[13]=g_row_2__g_col_1__pe_psum_in[13]
+ psum_out[12]=g_row_2__g_col_1__pe_psum_in[12]
+ psum_out[11]=g_row_2__g_col_1__pe_psum_in[11]
+ psum_out[10]=g_row_2__g_col_1__pe_psum_in[10]
+ psum_out[9]=g_row_2__g_col_1__pe_psum_in[9]
+ psum_out[8]=g_row_2__g_col_1__pe_psum_in[8]
+ psum_out[7]=g_row_2__g_col_1__pe_psum_in[7]
+ psum_out[6]=g_row_2__g_col_1__pe_psum_in[6]
+ psum_out[5]=g_row_2__g_col_1__pe_psum_in[5]
+ psum_out[4]=g_row_2__g_col_1__pe_psum_in[4]
+ psum_out[3]=g_row_2__g_col_1__pe_psum_in[3]
+ psum_out[2]=g_row_2__g_col_1__pe_psum_in[2]
+ psum_out[1]=g_row_2__g_col_1__pe_psum_in[1]
+ psum_out[0]=g_row_2__g_col_1__pe_psum_in[0] VDD=VDD VSS=VSS
+ ZCTSNET_11=ZCTSNET_111 HFSNET_2=HFSNET_38 HFSNET_3=HFSNET_46 HFSNET_4=HFSNET_47
+ HFSNET_5=HFSNET_48 HFSNET_7=HFSNET_49 HFSNET_8=HFSNET_92 HFSNET_9=HFSNET_93
+ ZCTSNET_0=ZCTSNET_15
Xg_row_1__g_col_2__pe unpu_pe_9 $PINS ZCTSNET_11=ZCTSNET_125 rst_n=HFSNET_85
+ array_en=HFSNET_45 weight_load=weight_load[6] mode_unsigned=HFSNET_28
+ weight_in[7]=weight_in[55] weight_in[6]=weight_in[54]
+ weight_in[5]=weight_in[53] weight_in[4]=weight_in[52]
+ weight_in[3]=weight_in[51] weight_in[2]=weight_in[50]
+ weight_in[1]=weight_in[49] weight_in[0]=weight_in[48]
+ act_in[7]=g_row_1__g_col_2__pe_act_in[7]
+ act_in[6]=g_row_1__g_col_2__pe_act_in[6]
+ act_in[5]=g_row_1__g_col_2__pe_act_in[5]
+ act_in[4]=g_row_1__g_col_2__pe_act_in[4]
+ act_in[3]=g_row_1__g_col_2__pe_act_in[3]
+ act_in[2]=g_row_1__g_col_2__pe_act_in[2]
+ act_in[1]=g_row_1__g_col_2__pe_act_in[1]
+ act_in[0]=g_row_1__g_col_2__pe_act_in[0]
+ psum_in[31]=g_row_1__g_col_2__pe_psum_in[31]
+ psum_in[30]=g_row_1__g_col_2__pe_psum_in[30]
+ psum_in[29]=g_row_1__g_col_2__pe_psum_in[29]
+ psum_in[28]=g_row_1__g_col_2__pe_psum_in[28]
+ psum_in[27]=g_row_1__g_col_2__pe_psum_in[27]
+ psum_in[26]=g_row_1__g_col_2__pe_psum_in[26]
+ psum_in[25]=g_row_1__g_col_2__pe_psum_in[25]
+ psum_in[24]=g_row_1__g_col_2__pe_psum_in[24]
+ psum_in[23]=g_row_1__g_col_2__pe_psum_in[23]
+ psum_in[22]=g_row_1__g_col_2__pe_psum_in[22]
+ psum_in[21]=g_row_1__g_col_2__pe_psum_in[21]
+ psum_in[20]=g_row_1__g_col_2__pe_psum_in[20]
+ psum_in[19]=g_row_1__g_col_2__pe_psum_in[19]
+ psum_in[18]=g_row_1__g_col_2__pe_psum_in[18]
+ psum_in[17]=g_row_1__g_col_2__pe_psum_in[17]
+ psum_in[16]=g_row_1__g_col_2__pe_psum_in[16]
+ psum_in[15]=g_row_1__g_col_2__pe_psum_in[15]
+ psum_in[14]=g_row_1__g_col_2__pe_psum_in[14]
+ psum_in[13]=g_row_1__g_col_2__pe_psum_in[13]
+ psum_in[12]=g_row_1__g_col_2__pe_psum_in[12]
+ psum_in[11]=g_row_1__g_col_2__pe_psum_in[11]
+ psum_in[10]=g_row_1__g_col_2__pe_psum_in[10]
+ psum_in[9]=g_row_1__g_col_2__pe_psum_in[9]
+ psum_in[8]=g_row_1__g_col_2__pe_psum_in[8]
+ psum_in[7]=g_row_1__g_col_2__pe_psum_in[7]
+ psum_in[6]=g_row_1__g_col_2__pe_psum_in[6]
+ psum_in[5]=g_row_1__g_col_2__pe_psum_in[5]
+ psum_in[4]=g_row_1__g_col_2__pe_psum_in[4]
+ psum_in[3]=g_row_1__g_col_2__pe_psum_in[3]
+ psum_in[2]=g_row_1__g_col_2__pe_psum_in[2]
+ psum_in[1]=g_row_1__g_col_2__pe_psum_in[1]
+ psum_in[0]=g_row_1__g_col_2__pe_psum_in[0]
+ act_out[7]=g_row_1__g_col_3__pe_act_in[7]
+ act_out[6]=g_row_1__g_col_3__pe_act_in[6]
+ act_out[5]=g_row_1__g_col_3__pe_act_in[5]
+ act_out[4]=g_row_1__g_col_3__pe_act_in[4]
+ act_out[3]=g_row_1__g_col_3__pe_act_in[3]
+ act_out[2]=g_row_1__g_col_3__pe_act_in[2]
+ act_out[1]=g_row_1__g_col_3__pe_act_in[1]
+ act_out[0]=g_row_1__g_col_3__pe_act_in[0]
+ psum_out[31]=g_row_2__g_col_2__pe_psum_in[31]
+ psum_out[30]=g_row_2__g_col_2__pe_psum_in[30]
+ psum_out[29]=g_row_2__g_col_2__pe_psum_in[29]
+ psum_out[28]=g_row_2__g_col_2__pe_psum_in[28]
+ psum_out[27]=g_row_2__g_col_2__pe_psum_in[27]
+ psum_out[26]=g_row_2__g_col_2__pe_psum_in[26]
+ psum_out[25]=g_row_2__g_col_2__pe_psum_in[25]
+ psum_out[24]=g_row_2__g_col_2__pe_psum_in[24]
+ psum_out[23]=g_row_2__g_col_2__pe_psum_in[23]
+ psum_out[22]=g_row_2__g_col_2__pe_psum_in[22]
+ psum_out[21]=g_row_2__g_col_2__pe_psum_in[21]
+ psum_out[20]=g_row_2__g_col_2__pe_psum_in[20]
+ psum_out[19]=g_row_2__g_col_2__pe_psum_in[19]
+ psum_out[18]=g_row_2__g_col_2__pe_psum_in[18]
+ psum_out[17]=g_row_2__g_col_2__pe_psum_in[17]
+ psum_out[16]=g_row_2__g_col_2__pe_psum_in[16]
+ psum_out[15]=g_row_2__g_col_2__pe_psum_in[15]
+ psum_out[14]=g_row_2__g_col_2__pe_psum_in[14]
+ psum_out[13]=g_row_2__g_col_2__pe_psum_in[13]
+ psum_out[12]=g_row_2__g_col_2__pe_psum_in[12]
+ psum_out[11]=g_row_2__g_col_2__pe_psum_in[11]
+ psum_out[10]=g_row_2__g_col_2__pe_psum_in[10]
+ psum_out[9]=g_row_2__g_col_2__pe_psum_in[9]
+ psum_out[8]=g_row_2__g_col_2__pe_psum_in[8]
+ psum_out[7]=g_row_2__g_col_2__pe_psum_in[7]
+ psum_out[6]=g_row_2__g_col_2__pe_psum_in[6]
+ psum_out[5]=g_row_2__g_col_2__pe_psum_in[5]
+ psum_out[4]=g_row_2__g_col_2__pe_psum_in[4]
+ psum_out[3]=g_row_2__g_col_2__pe_psum_in[3]
+ psum_out[2]=g_row_2__g_col_2__pe_psum_in[2]
+ psum_out[1]=g_row_2__g_col_2__pe_psum_in[1]
+ psum_out[0]=g_row_2__g_col_2__pe_psum_in[0] VDD=VDD VSS=VSS
+ ZCTSNET_2=ZCTSNET_130 HFSNET_3=HFSNET_31 HFSNET_4=HFSNET_41 HFSNET_5=HFSNET_42
+ HFSNET_6=HFSNET_49 HFSNET_8=HFSNET_88 HFSNET_9=HFSNET_101
Xg_row_1__g_col_3__pe unpu_pe_8 $PINS ZCTSNET_11=ZCTSNET_18 rst_n=HFSNET_86
+ array_en=HFSNET_51 weight_load=weight_load[7] mode_unsigned=HFSNET_29
+ weight_in[7]=weight_in[63] weight_in[6]=weight_in[62]
+ weight_in[5]=weight_in[61] weight_in[4]=weight_in[60]
+ weight_in[3]=weight_in[59] weight_in[2]=weight_in[58]
+ weight_in[1]=weight_in[57] weight_in[0]=weight_in[56]
+ act_in[7]=g_row_1__g_col_3__pe_act_in[7]
+ act_in[6]=g_row_1__g_col_3__pe_act_in[6]
+ act_in[5]=g_row_1__g_col_3__pe_act_in[5]
+ act_in[4]=g_row_1__g_col_3__pe_act_in[4]
+ act_in[3]=g_row_1__g_col_3__pe_act_in[3]
+ act_in[2]=g_row_1__g_col_3__pe_act_in[2]
+ act_in[1]=g_row_1__g_col_3__pe_act_in[1]
+ act_in[0]=g_row_1__g_col_3__pe_act_in[0]
+ psum_in[31]=g_row_1__g_col_3__pe_psum_in[31]
+ psum_in[30]=g_row_1__g_col_3__pe_psum_in[30]
+ psum_in[29]=g_row_1__g_col_3__pe_psum_in[29]
+ psum_in[28]=g_row_1__g_col_3__pe_psum_in[28]
+ psum_in[27]=g_row_1__g_col_3__pe_psum_in[27]
+ psum_in[26]=g_row_1__g_col_3__pe_psum_in[26]
+ psum_in[25]=g_row_1__g_col_3__pe_psum_in[25]
+ psum_in[24]=g_row_1__g_col_3__pe_psum_in[24]
+ psum_in[23]=g_row_1__g_col_3__pe_psum_in[23]
+ psum_in[22]=g_row_1__g_col_3__pe_psum_in[22]
+ psum_in[21]=g_row_1__g_col_3__pe_psum_in[21]
+ psum_in[20]=g_row_1__g_col_3__pe_psum_in[20]
+ psum_in[19]=g_row_1__g_col_3__pe_psum_in[19]
+ psum_in[18]=g_row_1__g_col_3__pe_psum_in[18]
+ psum_in[17]=g_row_1__g_col_3__pe_psum_in[17]
+ psum_in[16]=g_row_1__g_col_3__pe_psum_in[16]
+ psum_in[15]=g_row_1__g_col_3__pe_psum_in[15]
+ psum_in[14]=g_row_1__g_col_3__pe_psum_in[14]
+ psum_in[13]=g_row_1__g_col_3__pe_psum_in[13]
+ psum_in[12]=g_row_1__g_col_3__pe_psum_in[12]
+ psum_in[11]=g_row_1__g_col_3__pe_psum_in[11]
+ psum_in[10]=g_row_1__g_col_3__pe_psum_in[10]
+ psum_in[9]=g_row_1__g_col_3__pe_psum_in[9]
+ psum_in[8]=g_row_1__g_col_3__pe_psum_in[8]
+ psum_in[7]=g_row_1__g_col_3__pe_psum_in[7]
+ psum_in[6]=g_row_1__g_col_3__pe_psum_in[6]
+ psum_in[5]=g_row_1__g_col_3__pe_psum_in[5]
+ psum_in[4]=g_row_1__g_col_3__pe_psum_in[4]
+ psum_in[3]=g_row_1__g_col_3__pe_psum_in[3]
+ psum_in[2]=g_row_1__g_col_3__pe_psum_in[2]
+ psum_in[1]=g_row_1__g_col_3__pe_psum_in[1]
+ psum_in[0]=g_row_1__g_col_3__pe_psum_in[0]
+ psum_out[31]=g_row_2__g_col_3__pe_psum_in[31]
+ psum_out[30]=g_row_2__g_col_3__pe_psum_in[30]
+ psum_out[29]=g_row_2__g_col_3__pe_psum_in[29]
+ psum_out[28]=g_row_2__g_col_3__pe_psum_in[28]
+ psum_out[27]=g_row_2__g_col_3__pe_psum_in[27]
+ psum_out[26]=g_row_2__g_col_3__pe_psum_in[26]
+ psum_out[25]=g_row_2__g_col_3__pe_psum_in[25]
+ psum_out[24]=g_row_2__g_col_3__pe_psum_in[24]
+ psum_out[23]=g_row_2__g_col_3__pe_psum_in[23]
+ psum_out[22]=g_row_2__g_col_3__pe_psum_in[22]
+ psum_out[21]=g_row_2__g_col_3__pe_psum_in[21]
+ psum_out[20]=g_row_2__g_col_3__pe_psum_in[20]
+ psum_out[19]=g_row_2__g_col_3__pe_psum_in[19]
+ psum_out[18]=g_row_2__g_col_3__pe_psum_in[18]
+ psum_out[17]=g_row_2__g_col_3__pe_psum_in[17]
+ psum_out[16]=g_row_2__g_col_3__pe_psum_in[16]
+ psum_out[15]=g_row_2__g_col_3__pe_psum_in[15]
+ psum_out[14]=g_row_2__g_col_3__pe_psum_in[14]
+ psum_out[13]=g_row_2__g_col_3__pe_psum_in[13]
+ psum_out[12]=g_row_2__g_col_3__pe_psum_in[12]
+ psum_out[11]=g_row_2__g_col_3__pe_psum_in[11]
+ psum_out[10]=g_row_2__g_col_3__pe_psum_in[10]
+ psum_out[9]=g_row_2__g_col_3__pe_psum_in[9]
+ psum_out[8]=g_row_2__g_col_3__pe_psum_in[8]
+ psum_out[7]=g_row_2__g_col_3__pe_psum_in[7]
+ psum_out[6]=g_row_2__g_col_3__pe_psum_in[6]
+ psum_out[5]=g_row_2__g_col_3__pe_psum_in[5]
+ psum_out[4]=g_row_2__g_col_3__pe_psum_in[4]
+ psum_out[3]=g_row_2__g_col_3__pe_psum_in[3]
+ psum_out[2]=g_row_2__g_col_3__pe_psum_in[2]
+ psum_out[1]=g_row_2__g_col_3__pe_psum_in[1]
+ psum_out[0]=g_row_2__g_col_3__pe_psum_in[0] VDD=VDD VSS=VSS
+ ZCTSNET_12=ZCTSNET_120 ZCTSNET_1=ZCTSNET_20 HFSNET_2=HFSNET_32
+ HFSNET_4=HFSNET_53 HFSNET_5=HFSNET_55 HFSNET_6=HFSNET_57 HFSNET_7=HFSNET_58
+ HFSNET_8=HFSNET_87 HFSNET_9=HFSNET_102 HFSNET_10=HFSNET_104
+ ZCTSNET_13=ZCTSNET_19 ZCTSNET_0=ZCTSNET_21 ZCTSNET_2=ZCTSNET_27
Xg_row_2__g_col_0__pe unpu_pe_7 $PINS clk=ZCTSNET_109 rst_n=HFSNET_75
+ array_en=HFSNET_59 weight_load=weight_load[8] mode_unsigned=HFSNET_34
+ weight_in[7]=weight_in[71] weight_in[6]=weight_in[70]
+ weight_in[5]=weight_in[69] weight_in[4]=weight_in[68]
+ weight_in[3]=weight_in[67] weight_in[2]=weight_in[66]
+ weight_in[1]=weight_in[65] weight_in[0]=weight_in[64] act_in[7]=act_in[23]
+ act_in[6]=act_in[22] act_in[5]=act_in[21] act_in[4]=act_in[20]
+ act_in[3]=act_in[19] act_in[2]=act_in[18] act_in[1]=act_in[17]
+ act_in[0]=act_in[16] psum_in[31]=g_row_2__g_col_0__pe_psum_in[31]
+ psum_in[30]=g_row_2__g_col_0__pe_psum_in[30]
+ psum_in[29]=g_row_2__g_col_0__pe_psum_in[29]
+ psum_in[28]=g_row_2__g_col_0__pe_psum_in[28]
+ psum_in[27]=g_row_2__g_col_0__pe_psum_in[27]
+ psum_in[26]=g_row_2__g_col_0__pe_psum_in[26]
+ psum_in[25]=g_row_2__g_col_0__pe_psum_in[25]
+ psum_in[24]=g_row_2__g_col_0__pe_psum_in[24]
+ psum_in[23]=g_row_2__g_col_0__pe_psum_in[23]
+ psum_in[22]=g_row_2__g_col_0__pe_psum_in[22]
+ psum_in[21]=g_row_2__g_col_0__pe_psum_in[21]
+ psum_in[20]=g_row_2__g_col_0__pe_psum_in[20]
+ psum_in[19]=g_row_2__g_col_0__pe_psum_in[19]
+ psum_in[18]=g_row_2__g_col_0__pe_psum_in[18]
+ psum_in[17]=g_row_2__g_col_0__pe_psum_in[17]
+ psum_in[16]=g_row_2__g_col_0__pe_psum_in[16]
+ psum_in[15]=g_row_2__g_col_0__pe_psum_in[15]
+ psum_in[14]=g_row_2__g_col_0__pe_psum_in[14]
+ psum_in[13]=g_row_2__g_col_0__pe_psum_in[13]
+ psum_in[12]=g_row_2__g_col_0__pe_psum_in[12]
+ psum_in[11]=g_row_2__g_col_0__pe_psum_in[11]
+ psum_in[10]=g_row_2__g_col_0__pe_psum_in[10]
+ psum_in[9]=g_row_2__g_col_0__pe_psum_in[9]
+ psum_in[8]=g_row_2__g_col_0__pe_psum_in[8]
+ psum_in[7]=g_row_2__g_col_0__pe_psum_in[7]
+ psum_in[6]=g_row_2__g_col_0__pe_psum_in[6]
+ psum_in[5]=g_row_2__g_col_0__pe_psum_in[5]
+ psum_in[4]=g_row_2__g_col_0__pe_psum_in[4]
+ psum_in[3]=g_row_2__g_col_0__pe_psum_in[3]
+ psum_in[2]=g_row_2__g_col_0__pe_psum_in[2]
+ psum_in[1]=g_row_2__g_col_0__pe_psum_in[1]
+ psum_in[0]=g_row_2__g_col_0__pe_psum_in[0]
+ act_out[7]=g_row_2__g_col_1__pe_act_in[7]
+ act_out[6]=g_row_2__g_col_1__pe_act_in[6]
+ act_out[5]=g_row_2__g_col_1__pe_act_in[5]
+ act_out[4]=g_row_2__g_col_1__pe_act_in[4]
+ act_out[3]=g_row_2__g_col_1__pe_act_in[3]
+ act_out[2]=g_row_2__g_col_1__pe_act_in[2]
+ act_out[1]=g_row_2__g_col_1__pe_act_in[1]
+ act_out[0]=g_row_2__g_col_1__pe_act_in[0]
+ psum_out[31]=g_row_3__g_col_0__pe_psum_in[31]
+ psum_out[30]=g_row_3__g_col_0__pe_psum_in[30]
+ psum_out[29]=g_row_3__g_col_0__pe_psum_in[29]
+ psum_out[28]=g_row_3__g_col_0__pe_psum_in[28]
+ psum_out[27]=g_row_3__g_col_0__pe_psum_in[27]
+ psum_out[26]=g_row_3__g_col_0__pe_psum_in[26]
+ psum_out[25]=g_row_3__g_col_0__pe_psum_in[25]
+ psum_out[24]=g_row_3__g_col_0__pe_psum_in[24]
+ psum_out[23]=g_row_3__g_col_0__pe_psum_in[23]
+ psum_out[22]=g_row_3__g_col_0__pe_psum_in[22]
+ psum_out[21]=g_row_3__g_col_0__pe_psum_in[21]
+ psum_out[20]=g_row_3__g_col_0__pe_psum_in[20]
+ psum_out[19]=g_row_3__g_col_0__pe_psum_in[19]
+ psum_out[18]=g_row_3__g_col_0__pe_psum_in[18]
+ psum_out[17]=g_row_3__g_col_0__pe_psum_in[17]
+ psum_out[16]=g_row_3__g_col_0__pe_psum_in[16]
+ psum_out[15]=g_row_3__g_col_0__pe_psum_in[15]
+ psum_out[14]=g_row_3__g_col_0__pe_psum_in[14]
+ psum_out[13]=g_row_3__g_col_0__pe_psum_in[13]
+ psum_out[12]=g_row_3__g_col_0__pe_psum_in[12]
+ psum_out[11]=g_row_3__g_col_0__pe_psum_in[11]
+ psum_out[10]=g_row_3__g_col_0__pe_psum_in[10]
+ psum_out[9]=g_row_3__g_col_0__pe_psum_in[9]
+ psum_out[8]=g_row_3__g_col_0__pe_psum_in[8]
+ psum_out[7]=g_row_3__g_col_0__pe_psum_in[7]
+ psum_out[6]=g_row_3__g_col_0__pe_psum_in[6]
+ psum_out[5]=g_row_3__g_col_0__pe_psum_in[5]
+ psum_out[4]=g_row_3__g_col_0__pe_psum_in[4]
+ psum_out[3]=g_row_3__g_col_0__pe_psum_in[3]
+ psum_out[2]=g_row_3__g_col_0__pe_psum_in[2]
+ psum_out[1]=g_row_3__g_col_0__pe_psum_in[1]
+ psum_out[0]=g_row_3__g_col_0__pe_psum_in[0] VDD=VDD VSS=VSS
+ ZCTSNET_13=ZCTSNET_116 HFSNET_3=HFSNET_36 HFSNET_4=HFSNET_60 HFSNET_5=HFSNET_62
+ HFSNET_6=HFSNET_65 HFSNET_7=HFSNET_61 HFSNET_8=HFSNET_77 HFSNET_9=HFSNET_79
+ HFSNET_10=HFSNET_81 HFSNET_11=HFSNET_83 ZCTSNET_0=ZCTSNET_113
+ ZCTSNET_2=ctosc_gls_1 ZCTSNET_3=ZCTSNET_30
Xg_row_2__g_col_1__pe unpu_pe_6 $PINS ZCTSNET_8=ZCTSNET_15 rst_n=HFSNET_92
+ array_en=HFSNET_44 weight_load=weight_load[9] mode_unsigned=HFSNET_35
+ weight_in[7]=weight_in[79] weight_in[6]=weight_in[78]
+ weight_in[5]=weight_in[77] weight_in[4]=weight_in[76]
+ weight_in[3]=weight_in[75] weight_in[2]=weight_in[74]
+ weight_in[1]=weight_in[73] weight_in[0]=weight_in[72]
+ act_in[7]=g_row_2__g_col_1__pe_act_in[7]
+ act_in[6]=g_row_2__g_col_1__pe_act_in[6]
+ act_in[5]=g_row_2__g_col_1__pe_act_in[5]
+ act_in[4]=g_row_2__g_col_1__pe_act_in[4]
+ act_in[3]=g_row_2__g_col_1__pe_act_in[3]
+ act_in[2]=g_row_2__g_col_1__pe_act_in[2]
+ act_in[1]=g_row_2__g_col_1__pe_act_in[1]
+ act_in[0]=g_row_2__g_col_1__pe_act_in[0]
+ psum_in[31]=g_row_2__g_col_1__pe_psum_in[31]
+ psum_in[30]=g_row_2__g_col_1__pe_psum_in[30]
+ psum_in[29]=g_row_2__g_col_1__pe_psum_in[29]
+ psum_in[28]=g_row_2__g_col_1__pe_psum_in[28]
+ psum_in[27]=g_row_2__g_col_1__pe_psum_in[27]
+ psum_in[26]=g_row_2__g_col_1__pe_psum_in[26]
+ psum_in[25]=g_row_2__g_col_1__pe_psum_in[25]
+ psum_in[24]=g_row_2__g_col_1__pe_psum_in[24]
+ psum_in[23]=g_row_2__g_col_1__pe_psum_in[23]
+ psum_in[22]=g_row_2__g_col_1__pe_psum_in[22]
+ psum_in[21]=g_row_2__g_col_1__pe_psum_in[21]
+ psum_in[20]=g_row_2__g_col_1__pe_psum_in[20]
+ psum_in[19]=g_row_2__g_col_1__pe_psum_in[19]
+ psum_in[18]=g_row_2__g_col_1__pe_psum_in[18]
+ psum_in[17]=g_row_2__g_col_1__pe_psum_in[17]
+ psum_in[16]=g_row_2__g_col_1__pe_psum_in[16]
+ psum_in[15]=g_row_2__g_col_1__pe_psum_in[15]
+ psum_in[14]=g_row_2__g_col_1__pe_psum_in[14]
+ psum_in[13]=g_row_2__g_col_1__pe_psum_in[13]
+ psum_in[12]=g_row_2__g_col_1__pe_psum_in[12]
+ psum_in[11]=g_row_2__g_col_1__pe_psum_in[11]
+ psum_in[10]=g_row_2__g_col_1__pe_psum_in[10]
+ psum_in[9]=g_row_2__g_col_1__pe_psum_in[9]
+ psum_in[8]=g_row_2__g_col_1__pe_psum_in[8]
+ psum_in[7]=g_row_2__g_col_1__pe_psum_in[7]
+ psum_in[6]=g_row_2__g_col_1__pe_psum_in[6]
+ psum_in[5]=g_row_2__g_col_1__pe_psum_in[5]
+ psum_in[4]=g_row_2__g_col_1__pe_psum_in[4]
+ psum_in[3]=g_row_2__g_col_1__pe_psum_in[3]
+ psum_in[2]=g_row_2__g_col_1__pe_psum_in[2]
+ psum_in[1]=g_row_2__g_col_1__pe_psum_in[1]
+ psum_in[0]=g_row_2__g_col_1__pe_psum_in[0]
+ act_out[7]=g_row_2__g_col_2__pe_act_in[7]
+ act_out[6]=g_row_2__g_col_2__pe_act_in[6]
+ act_out[5]=g_row_2__g_col_2__pe_act_in[5]
+ act_out[4]=g_row_2__g_col_2__pe_act_in[4]
+ act_out[3]=g_row_2__g_col_2__pe_act_in[3]
+ act_out[2]=g_row_2__g_col_2__pe_act_in[2]
+ act_out[1]=g_row_2__g_col_2__pe_act_in[1]
+ act_out[0]=g_row_2__g_col_2__pe_act_in[0]
+ psum_out[31]=g_row_3__g_col_1__pe_psum_in[31]
+ psum_out[30]=g_row_3__g_col_1__pe_psum_in[30]
+ psum_out[29]=g_row_3__g_col_1__pe_psum_in[29]
+ psum_out[28]=g_row_3__g_col_1__pe_psum_in[28]
+ psum_out[27]=g_row_3__g_col_1__pe_psum_in[27]
+ psum_out[26]=g_row_3__g_col_1__pe_psum_in[26]
+ psum_out[25]=g_row_3__g_col_1__pe_psum_in[25]
+ psum_out[24]=g_row_3__g_col_1__pe_psum_in[24]
+ psum_out[23]=g_row_3__g_col_1__pe_psum_in[23]
+ psum_out[22]=g_row_3__g_col_1__pe_psum_in[22]
+ psum_out[21]=g_row_3__g_col_1__pe_psum_in[21]
+ psum_out[20]=g_row_3__g_col_1__pe_psum_in[20]
+ psum_out[19]=g_row_3__g_col_1__pe_psum_in[19]
+ psum_out[18]=g_row_3__g_col_1__pe_psum_in[18]
+ psum_out[17]=g_row_3__g_col_1__pe_psum_in[17]
+ psum_out[16]=g_row_3__g_col_1__pe_psum_in[16]
+ psum_out[15]=g_row_3__g_col_1__pe_psum_in[15]
+ psum_out[14]=g_row_3__g_col_1__pe_psum_in[14]
+ psum_out[13]=g_row_3__g_col_1__pe_psum_in[13]
+ psum_out[12]=g_row_3__g_col_1__pe_psum_in[12]
+ psum_out[11]=g_row_3__g_col_1__pe_psum_in[11]
+ psum_out[10]=g_row_3__g_col_1__pe_psum_in[10]
+ psum_out[9]=g_row_3__g_col_1__pe_psum_in[9]
+ psum_out[8]=g_row_3__g_col_1__pe_psum_in[8]
+ psum_out[7]=g_row_3__g_col_1__pe_psum_in[7]
+ psum_out[6]=g_row_3__g_col_1__pe_psum_in[6]
+ psum_out[5]=g_row_3__g_col_1__pe_psum_in[5]
+ psum_out[4]=g_row_3__g_col_1__pe_psum_in[4]
+ psum_out[3]=g_row_3__g_col_1__pe_psum_in[3]
+ psum_out[2]=g_row_3__g_col_1__pe_psum_in[2]
+ psum_out[1]=g_row_3__g_col_1__pe_psum_in[1]
+ psum_out[0]=g_row_3__g_col_1__pe_psum_in[0] VDD=VDD VSS=VSS ZCTSNET_0=ZCTSNET_1
+ ZCTSNET_9=ZCTSNET_111 HFSNET_2=HFSNET_38 HFSNET_3=HFSNET_46 HFSNET_4=HFSNET_48
+ HFSNET_5=HFSNET_93 HFSNET_6=HFSNET_90 HFSNET_7=HFSNET_97
Xg_row_2__g_col_2__pe unpu_pe_5 $PINS clk=ZCTSNET_120 rst_n=HFSNET_85
+ array_en=HFSNET_45 weight_load=weight_load[10] mode_unsigned=HFSNET_28
+ weight_in[7]=weight_in[87] weight_in[6]=weight_in[86]
+ weight_in[5]=weight_in[85] weight_in[4]=weight_in[84]
+ weight_in[3]=weight_in[83] weight_in[2]=weight_in[82]
+ weight_in[1]=weight_in[81] weight_in[0]=weight_in[80]
+ act_in[7]=g_row_2__g_col_2__pe_act_in[7]
+ act_in[6]=g_row_2__g_col_2__pe_act_in[6]
+ act_in[5]=g_row_2__g_col_2__pe_act_in[5]
+ act_in[4]=g_row_2__g_col_2__pe_act_in[4]
+ act_in[3]=g_row_2__g_col_2__pe_act_in[3]
+ act_in[2]=g_row_2__g_col_2__pe_act_in[2]
+ act_in[1]=g_row_2__g_col_2__pe_act_in[1]
+ act_in[0]=g_row_2__g_col_2__pe_act_in[0]
+ psum_in[31]=g_row_2__g_col_2__pe_psum_in[31]
+ psum_in[30]=g_row_2__g_col_2__pe_psum_in[30]
+ psum_in[29]=g_row_2__g_col_2__pe_psum_in[29]
+ psum_in[28]=g_row_2__g_col_2__pe_psum_in[28]
+ psum_in[27]=g_row_2__g_col_2__pe_psum_in[27]
+ psum_in[26]=g_row_2__g_col_2__pe_psum_in[26]
+ psum_in[25]=g_row_2__g_col_2__pe_psum_in[25]
+ psum_in[24]=g_row_2__g_col_2__pe_psum_in[24]
+ psum_in[23]=g_row_2__g_col_2__pe_psum_in[23]
+ psum_in[22]=g_row_2__g_col_2__pe_psum_in[22]
+ psum_in[21]=g_row_2__g_col_2__pe_psum_in[21]
+ psum_in[20]=g_row_2__g_col_2__pe_psum_in[20]
+ psum_in[19]=g_row_2__g_col_2__pe_psum_in[19]
+ psum_in[18]=g_row_2__g_col_2__pe_psum_in[18]
+ psum_in[17]=g_row_2__g_col_2__pe_psum_in[17]
+ psum_in[16]=g_row_2__g_col_2__pe_psum_in[16]
+ psum_in[15]=g_row_2__g_col_2__pe_psum_in[15]
+ psum_in[14]=g_row_2__g_col_2__pe_psum_in[14]
+ psum_in[13]=g_row_2__g_col_2__pe_psum_in[13]
+ psum_in[12]=g_row_2__g_col_2__pe_psum_in[12]
+ psum_in[11]=g_row_2__g_col_2__pe_psum_in[11]
+ psum_in[10]=g_row_2__g_col_2__pe_psum_in[10]
+ psum_in[9]=g_row_2__g_col_2__pe_psum_in[9]
+ psum_in[8]=g_row_2__g_col_2__pe_psum_in[8]
+ psum_in[7]=g_row_2__g_col_2__pe_psum_in[7]
+ psum_in[6]=g_row_2__g_col_2__pe_psum_in[6]
+ psum_in[5]=g_row_2__g_col_2__pe_psum_in[5]
+ psum_in[4]=g_row_2__g_col_2__pe_psum_in[4]
+ psum_in[3]=g_row_2__g_col_2__pe_psum_in[3]
+ psum_in[2]=g_row_2__g_col_2__pe_psum_in[2]
+ psum_in[1]=g_row_2__g_col_2__pe_psum_in[1]
+ psum_in[0]=g_row_2__g_col_2__pe_psum_in[0]
+ act_out[7]=g_row_2__g_col_3__pe_act_in[7]
+ act_out[6]=g_row_2__g_col_3__pe_act_in[6]
+ act_out[5]=g_row_2__g_col_3__pe_act_in[5]
+ act_out[4]=g_row_2__g_col_3__pe_act_in[4]
+ act_out[3]=g_row_2__g_col_3__pe_act_in[3]
+ act_out[2]=g_row_2__g_col_3__pe_act_in[2]
+ act_out[1]=g_row_2__g_col_3__pe_act_in[1]
+ act_out[0]=g_row_2__g_col_3__pe_act_in[0]
+ psum_out[31]=g_row_3__g_col_2__pe_psum_in[31]
+ psum_out[30]=g_row_3__g_col_2__pe_psum_in[30]
+ psum_out[29]=g_row_3__g_col_2__pe_psum_in[29]
+ psum_out[28]=g_row_3__g_col_2__pe_psum_in[28]
+ psum_out[27]=g_row_3__g_col_2__pe_psum_in[27]
+ psum_out[26]=g_row_3__g_col_2__pe_psum_in[26]
+ psum_out[25]=g_row_3__g_col_2__pe_psum_in[25]
+ psum_out[24]=g_row_3__g_col_2__pe_psum_in[24]
+ psum_out[23]=g_row_3__g_col_2__pe_psum_in[23]
+ psum_out[22]=g_row_3__g_col_2__pe_psum_in[22]
+ psum_out[21]=g_row_3__g_col_2__pe_psum_in[21]
+ psum_out[20]=g_row_3__g_col_2__pe_psum_in[20]
+ psum_out[19]=g_row_3__g_col_2__pe_psum_in[19]
+ psum_out[18]=g_row_3__g_col_2__pe_psum_in[18]
+ psum_out[17]=g_row_3__g_col_2__pe_psum_in[17]
+ psum_out[16]=g_row_3__g_col_2__pe_psum_in[16]
+ psum_out[15]=g_row_3__g_col_2__pe_psum_in[15]
+ psum_out[14]=g_row_3__g_col_2__pe_psum_in[14]
+ psum_out[13]=g_row_3__g_col_2__pe_psum_in[13]
+ psum_out[12]=g_row_3__g_col_2__pe_psum_in[12]
+ psum_out[11]=g_row_3__g_col_2__pe_psum_in[11]
+ psum_out[10]=g_row_3__g_col_2__pe_psum_in[10]
+ psum_out[9]=g_row_3__g_col_2__pe_psum_in[9]
+ psum_out[8]=g_row_3__g_col_2__pe_psum_in[8]
+ psum_out[7]=g_row_3__g_col_2__pe_psum_in[7]
+ psum_out[6]=g_row_3__g_col_2__pe_psum_in[6]
+ psum_out[5]=g_row_3__g_col_2__pe_psum_in[5]
+ psum_out[4]=g_row_3__g_col_2__pe_psum_in[4]
+ psum_out[3]=g_row_3__g_col_2__pe_psum_in[3]
+ psum_out[2]=g_row_3__g_col_2__pe_psum_in[2]
+ psum_out[1]=g_row_3__g_col_2__pe_psum_in[1]
+ psum_out[0]=g_row_3__g_col_2__pe_psum_in[0] VDD=VDD VSS=VSS
+ ZCTSNET_9=ZCTSNET_130 HFSNET_3=HFSNET_31 HFSNET_4=HFSNET_53 HFSNET_5=HFSNET_71
+ HFSNET_6=HFSNET_89 HFSNET_7=HFSNET_104 ZCTSNET_1=ZCTSNET_18
+ ZCTSNET_4=ZCTSNET_27
Xg_row_2__g_col_3__pe unpu_pe_4 $PINS ZCTSNET_11=ZCTSNET_120 rst_n=HFSNET_87
+ array_en=HFSNET_50 weight_load=weight_load[11] mode_unsigned=HFSNET_30
+ weight_in[7]=weight_in[95] weight_in[6]=weight_in[94]
+ weight_in[5]=weight_in[93] weight_in[4]=weight_in[92]
+ weight_in[3]=weight_in[91] weight_in[2]=weight_in[90]
+ weight_in[1]=weight_in[89] weight_in[0]=weight_in[88]
+ act_in[7]=g_row_2__g_col_3__pe_act_in[7]
+ act_in[6]=g_row_2__g_col_3__pe_act_in[6]
+ act_in[5]=g_row_2__g_col_3__pe_act_in[5]
+ act_in[4]=g_row_2__g_col_3__pe_act_in[4]
+ act_in[3]=g_row_2__g_col_3__pe_act_in[3]
+ act_in[2]=g_row_2__g_col_3__pe_act_in[2]
+ act_in[1]=g_row_2__g_col_3__pe_act_in[1]
+ act_in[0]=g_row_2__g_col_3__pe_act_in[0]
+ psum_in[31]=g_row_2__g_col_3__pe_psum_in[31]
+ psum_in[30]=g_row_2__g_col_3__pe_psum_in[30]
+ psum_in[29]=g_row_2__g_col_3__pe_psum_in[29]
+ psum_in[28]=g_row_2__g_col_3__pe_psum_in[28]
+ psum_in[27]=g_row_2__g_col_3__pe_psum_in[27]
+ psum_in[26]=g_row_2__g_col_3__pe_psum_in[26]
+ psum_in[25]=g_row_2__g_col_3__pe_psum_in[25]
+ psum_in[24]=g_row_2__g_col_3__pe_psum_in[24]
+ psum_in[23]=g_row_2__g_col_3__pe_psum_in[23]
+ psum_in[22]=g_row_2__g_col_3__pe_psum_in[22]
+ psum_in[21]=g_row_2__g_col_3__pe_psum_in[21]
+ psum_in[20]=g_row_2__g_col_3__pe_psum_in[20]
+ psum_in[19]=g_row_2__g_col_3__pe_psum_in[19]
+ psum_in[18]=g_row_2__g_col_3__pe_psum_in[18]
+ psum_in[17]=g_row_2__g_col_3__pe_psum_in[17]
+ psum_in[16]=g_row_2__g_col_3__pe_psum_in[16]
+ psum_in[15]=g_row_2__g_col_3__pe_psum_in[15]
+ psum_in[14]=g_row_2__g_col_3__pe_psum_in[14]
+ psum_in[13]=g_row_2__g_col_3__pe_psum_in[13]
+ psum_in[12]=g_row_2__g_col_3__pe_psum_in[12]
+ psum_in[11]=g_row_2__g_col_3__pe_psum_in[11]
+ psum_in[10]=g_row_2__g_col_3__pe_psum_in[10]
+ psum_in[9]=g_row_2__g_col_3__pe_psum_in[9]
+ psum_in[8]=g_row_2__g_col_3__pe_psum_in[8]
+ psum_in[7]=g_row_2__g_col_3__pe_psum_in[7]
+ psum_in[6]=g_row_2__g_col_3__pe_psum_in[6]
+ psum_in[5]=g_row_2__g_col_3__pe_psum_in[5]
+ psum_in[4]=g_row_2__g_col_3__pe_psum_in[4]
+ psum_in[3]=g_row_2__g_col_3__pe_psum_in[3]
+ psum_in[2]=g_row_2__g_col_3__pe_psum_in[2]
+ psum_in[1]=g_row_2__g_col_3__pe_psum_in[1]
+ psum_in[0]=g_row_2__g_col_3__pe_psum_in[0]
+ psum_out[31]=g_row_3__g_col_3__pe_psum_in[31]
+ psum_out[30]=g_row_3__g_col_3__pe_psum_in[30]
+ psum_out[29]=g_row_3__g_col_3__pe_psum_in[29]
+ psum_out[28]=g_row_3__g_col_3__pe_psum_in[28]
+ psum_out[27]=g_row_3__g_col_3__pe_psum_in[27]
+ psum_out[26]=g_row_3__g_col_3__pe_psum_in[26]
+ psum_out[25]=g_row_3__g_col_3__pe_psum_in[25]
+ psum_out[24]=g_row_3__g_col_3__pe_psum_in[24]
+ psum_out[23]=g_row_3__g_col_3__pe_psum_in[23]
+ psum_out[22]=g_row_3__g_col_3__pe_psum_in[22]
+ psum_out[21]=g_row_3__g_col_3__pe_psum_in[21]
+ psum_out[20]=g_row_3__g_col_3__pe_psum_in[20]
+ psum_out[19]=g_row_3__g_col_3__pe_psum_in[19]
+ psum_out[18]=g_row_3__g_col_3__pe_psum_in[18]
+ psum_out[17]=g_row_3__g_col_3__pe_psum_in[17]
+ psum_out[16]=g_row_3__g_col_3__pe_psum_in[16]
+ psum_out[15]=g_row_3__g_col_3__pe_psum_in[15]
+ psum_out[14]=g_row_3__g_col_3__pe_psum_in[14]
+ psum_out[13]=g_row_3__g_col_3__pe_psum_in[13]
+ psum_out[12]=g_row_3__g_col_3__pe_psum_in[12]
+ psum_out[11]=g_row_3__g_col_3__pe_psum_in[11]
+ psum_out[10]=g_row_3__g_col_3__pe_psum_in[10]
+ psum_out[9]=g_row_3__g_col_3__pe_psum_in[9]
+ psum_out[8]=g_row_3__g_col_3__pe_psum_in[8]
+ psum_out[7]=g_row_3__g_col_3__pe_psum_in[7]
+ psum_out[6]=g_row_3__g_col_3__pe_psum_in[6]
+ psum_out[5]=g_row_3__g_col_3__pe_psum_in[5]
+ psum_out[4]=g_row_3__g_col_3__pe_psum_in[4]
+ psum_out[3]=g_row_3__g_col_3__pe_psum_in[3]
+ psum_out[2]=g_row_3__g_col_3__pe_psum_in[2]
+ psum_out[1]=g_row_3__g_col_3__pe_psum_in[1]
+ psum_out[0]=g_row_3__g_col_3__pe_psum_in[0] VDD=VDD VSS=VSS
+ ZCTSNET_12=ZCTSNET_21 HFSNET_2=HFSNET_39 HFSNET_3=HFSNET_51 HFSNET_4=HFSNET_57
+ HFSNET_5=HFSNET_58 HFSNET_7=HFSNET_102 HFSNET_9=HFSNET_103 HFSNET_10=HFSNET_101
+ ZCTSNET_0=ZCTSNET_19 ZCTSNET_2=ZCTSNET_27
Xg_row_3__g_col_0__pe unpu_pe_3 $PINS rst_n=HFSNET_75 array_en=HFSNET_59
+ weight_load=weight_load[12] mode_unsigned=HFSNET_40 weight_in[7]=weight_in[103]
+ weight_in[6]=weight_in[102] weight_in[5]=weight_in[101]
+ weight_in[4]=weight_in[100] weight_in[3]=weight_in[99]
+ weight_in[2]=weight_in[98] weight_in[1]=weight_in[97]
+ weight_in[0]=weight_in[96] act_in[7]=act_in[31] act_in[6]=act_in[30]
+ act_in[5]=act_in[29] act_in[4]=act_in[28] act_in[3]=act_in[27]
+ act_in[2]=act_in[26] act_in[1]=act_in[25] act_in[0]=act_in[24]
+ psum_in[31]=g_row_3__g_col_0__pe_psum_in[31]
+ psum_in[30]=g_row_3__g_col_0__pe_psum_in[30]
+ psum_in[29]=g_row_3__g_col_0__pe_psum_in[29]
+ psum_in[28]=g_row_3__g_col_0__pe_psum_in[28]
+ psum_in[27]=g_row_3__g_col_0__pe_psum_in[27]
+ psum_in[26]=g_row_3__g_col_0__pe_psum_in[26]
+ psum_in[25]=g_row_3__g_col_0__pe_psum_in[25]
+ psum_in[24]=g_row_3__g_col_0__pe_psum_in[24]
+ psum_in[23]=g_row_3__g_col_0__pe_psum_in[23]
+ psum_in[22]=g_row_3__g_col_0__pe_psum_in[22]
+ psum_in[21]=g_row_3__g_col_0__pe_psum_in[21]
+ psum_in[20]=g_row_3__g_col_0__pe_psum_in[20]
+ psum_in[19]=g_row_3__g_col_0__pe_psum_in[19]
+ psum_in[18]=g_row_3__g_col_0__pe_psum_in[18]
+ psum_in[17]=g_row_3__g_col_0__pe_psum_in[17]
+ psum_in[16]=g_row_3__g_col_0__pe_psum_in[16]
+ psum_in[15]=g_row_3__g_col_0__pe_psum_in[15]
+ psum_in[14]=g_row_3__g_col_0__pe_psum_in[14]
+ psum_in[13]=g_row_3__g_col_0__pe_psum_in[13]
+ psum_in[12]=g_row_3__g_col_0__pe_psum_in[12]
+ psum_in[11]=g_row_3__g_col_0__pe_psum_in[11]
+ psum_in[10]=g_row_3__g_col_0__pe_psum_in[10]
+ psum_in[9]=g_row_3__g_col_0__pe_psum_in[9]
+ psum_in[8]=g_row_3__g_col_0__pe_psum_in[8]
+ psum_in[7]=g_row_3__g_col_0__pe_psum_in[7]
+ psum_in[6]=g_row_3__g_col_0__pe_psum_in[6]
+ psum_in[5]=g_row_3__g_col_0__pe_psum_in[5]
+ psum_in[4]=g_row_3__g_col_0__pe_psum_in[4]
+ psum_in[3]=g_row_3__g_col_0__pe_psum_in[3]
+ psum_in[2]=g_row_3__g_col_0__pe_psum_in[2]
+ psum_in[1]=g_row_3__g_col_0__pe_psum_in[1]
+ psum_in[0]=g_row_3__g_col_0__pe_psum_in[0]
+ act_out[7]=g_row_3__g_col_1__pe_act_in[7]
+ act_out[6]=g_row_3__g_col_1__pe_act_in[6]
+ act_out[5]=g_row_3__g_col_1__pe_act_in[5]
+ act_out[4]=g_row_3__g_col_1__pe_act_in[4]
+ act_out[3]=g_row_3__g_col_1__pe_act_in[3]
+ act_out[2]=g_row_3__g_col_1__pe_act_in[2]
+ act_out[1]=g_row_3__g_col_1__pe_act_in[1]
+ act_out[0]=g_row_3__g_col_1__pe_act_in[0] psum_out[31]=psum_out[31]
+ psum_out[30]=psum_out[30] psum_out[29]=psum_out[29] psum_out[28]=psum_out[28]
+ psum_out[27]=psum_out[27] psum_out[26]=psum_out[26] psum_out[25]=psum_out[25]
+ psum_out[24]=psum_out[24] psum_out[23]=psum_out[23] psum_out[22]=psum_out[22]
+ psum_out[21]=psum_out[21] psum_out[20]=psum_out[20] psum_out[19]=psum_out[19]
+ psum_out[18]=psum_out[18] psum_out[17]=psum_out[17] psum_out[16]=psum_out[16]
+ psum_out[15]=psum_out[15] psum_out[14]=psum_out[14] psum_out[13]=psum_out[13]
+ psum_out[12]=psum_out[12] psum_out[11]=psum_out[11] psum_out[10]=psum_out[10]
+ psum_out[9]=psum_out[9] psum_out[8]=psum_out[8] psum_out[7]=psum_out[7]
+ psum_out[6]=psum_out[6] psum_out[5]=psum_out[5] psum_out[4]=psum_out[4]
+ psum_out[3]=psum_out[3] psum_out[2]=psum_out[2] psum_out[1]=psum_out[1]
+ psum_out[0]=psum_out[0] VDD=VDD VSS=VSS ZCTSNET_12=ctosc_gls_1
+ HFSNET_2=mode_unsigned HFSNET_3=HFSNET_65 HFSNET_4=HFSNET_67 HFSNET_5=HFSNET_68
+ HFSNET_6=HFSNET_69 HFSNET_7=HFSNET_70 HFSNET_8=HFSNET_74 HFSNET_9=HFSNET_76
+ HFSNET_10=HFSNET_95 ZCTSNET_0=ZCTSNET_116 ZCTSNET_2=ZCTSNET_11
Xg_row_3__g_col_1__pe unpu_pe_2 $PINS ZCTSNET_10=ZCTSNET_116 rst_n=HFSNET_78
+ array_en=HFSNET_63 weight_load=weight_load[13] mode_unsigned=HFSNET_37
+ weight_in[7]=weight_in[111] weight_in[6]=weight_in[110]
+ weight_in[5]=weight_in[109] weight_in[4]=weight_in[108]
+ weight_in[3]=weight_in[107] weight_in[2]=weight_in[106]
+ weight_in[1]=weight_in[105] weight_in[0]=weight_in[104]
+ act_in[7]=g_row_3__g_col_1__pe_act_in[7]
+ act_in[6]=g_row_3__g_col_1__pe_act_in[6]
+ act_in[5]=g_row_3__g_col_1__pe_act_in[5]
+ act_in[4]=g_row_3__g_col_1__pe_act_in[4]
+ act_in[3]=g_row_3__g_col_1__pe_act_in[3]
+ act_in[2]=g_row_3__g_col_1__pe_act_in[2]
+ act_in[1]=g_row_3__g_col_1__pe_act_in[1]
+ act_in[0]=g_row_3__g_col_1__pe_act_in[0]
+ psum_in[31]=g_row_3__g_col_1__pe_psum_in[31]
+ psum_in[30]=g_row_3__g_col_1__pe_psum_in[30]
+ psum_in[29]=g_row_3__g_col_1__pe_psum_in[29]
+ psum_in[28]=g_row_3__g_col_1__pe_psum_in[28]
+ psum_in[27]=g_row_3__g_col_1__pe_psum_in[27]
+ psum_in[26]=g_row_3__g_col_1__pe_psum_in[26]
+ psum_in[25]=g_row_3__g_col_1__pe_psum_in[25]
+ psum_in[24]=g_row_3__g_col_1__pe_psum_in[24]
+ psum_in[23]=g_row_3__g_col_1__pe_psum_in[23]
+ psum_in[22]=g_row_3__g_col_1__pe_psum_in[22]
+ psum_in[21]=g_row_3__g_col_1__pe_psum_in[21]
+ psum_in[20]=g_row_3__g_col_1__pe_psum_in[20]
+ psum_in[19]=g_row_3__g_col_1__pe_psum_in[19]
+ psum_in[18]=g_row_3__g_col_1__pe_psum_in[18]
+ psum_in[17]=g_row_3__g_col_1__pe_psum_in[17]
+ psum_in[16]=g_row_3__g_col_1__pe_psum_in[16]
+ psum_in[15]=g_row_3__g_col_1__pe_psum_in[15]
+ psum_in[14]=g_row_3__g_col_1__pe_psum_in[14]
+ psum_in[13]=g_row_3__g_col_1__pe_psum_in[13]
+ psum_in[12]=g_row_3__g_col_1__pe_psum_in[12]
+ psum_in[11]=g_row_3__g_col_1__pe_psum_in[11]
+ psum_in[10]=g_row_3__g_col_1__pe_psum_in[10]
+ psum_in[9]=g_row_3__g_col_1__pe_psum_in[9]
+ psum_in[8]=g_row_3__g_col_1__pe_psum_in[8]
+ psum_in[7]=g_row_3__g_col_1__pe_psum_in[7]
+ psum_in[6]=g_row_3__g_col_1__pe_psum_in[6]
+ psum_in[5]=g_row_3__g_col_1__pe_psum_in[5]
+ psum_in[4]=g_row_3__g_col_1__pe_psum_in[4]
+ psum_in[3]=g_row_3__g_col_1__pe_psum_in[3]
+ psum_in[2]=g_row_3__g_col_1__pe_psum_in[2]
+ psum_in[1]=g_row_3__g_col_1__pe_psum_in[1]
+ psum_in[0]=g_row_3__g_col_1__pe_psum_in[0]
+ act_out[7]=g_row_3__g_col_2__pe_act_in[7]
+ act_out[6]=g_row_3__g_col_2__pe_act_in[6]
+ act_out[5]=g_row_3__g_col_2__pe_act_in[5]
+ act_out[4]=g_row_3__g_col_2__pe_act_in[4]
+ act_out[3]=g_row_3__g_col_2__pe_act_in[3]
+ act_out[2]=g_row_3__g_col_2__pe_act_in[2]
+ act_out[1]=g_row_3__g_col_2__pe_act_in[1]
+ act_out[0]=g_row_3__g_col_2__pe_act_in[0] psum_out[31]=psum_out[63]
+ psum_out[30]=psum_out[62] psum_out[29]=psum_out[61] psum_out[28]=psum_out[60]
+ psum_out[27]=psum_out[59] psum_out[26]=psum_out[58] psum_out[25]=psum_out[57]
+ psum_out[24]=psum_out[56] psum_out[23]=psum_out[55] psum_out[22]=psum_out[54]
+ psum_out[21]=psum_out[53] psum_out[20]=psum_out[52] psum_out[19]=psum_out[51]
+ psum_out[18]=psum_out[50] psum_out[17]=psum_out[49] psum_out[16]=psum_out[48]
+ psum_out[15]=psum_out[47] psum_out[14]=psum_out[46] psum_out[13]=psum_out[45]
+ psum_out[12]=psum_out[44] psum_out[11]=psum_out[43] psum_out[10]=psum_out[42]
+ psum_out[9]=psum_out[41] psum_out[8]=psum_out[40] psum_out[7]=psum_out[39]
+ psum_out[6]=psum_out[38] psum_out[5]=psum_out[37] psum_out[4]=psum_out[36]
+ psum_out[3]=psum_out[35] psum_out[2]=psum_out[34] psum_out[1]=psum_out[33]
+ psum_out[0]=psum_out[32] VDD=VDD VSS=VSS ZCTSNET_0=ZCTSNET_107
+ ZCTSNET_11=ZCTSNET_109 HFSNET_4=HFSNET_38 HFSNET_6=HFSNET_61 HFSNET_7=HFSNET_67
+ HFSNET_8=HFSNET_95 HFSNET_9=HFSNET_96 ZCTSNET_1=ZCTSNET_113
Xg_row_3__g_col_2__pe unpu_pe_1 $PINS ZCTSNET_13=ZCTSNET_118 rst_n=rst_n
+ array_en=HFSNET_50 weight_load=weight_load[14] mode_unsigned=HFSNET_40
+ weight_in[7]=weight_in[119] weight_in[6]=weight_in[118]
+ weight_in[5]=weight_in[117] weight_in[4]=weight_in[116]
+ weight_in[3]=weight_in[115] weight_in[2]=weight_in[114]
+ weight_in[1]=weight_in[113] weight_in[0]=weight_in[112]
+ act_in[7]=g_row_3__g_col_2__pe_act_in[7]
+ act_in[6]=g_row_3__g_col_2__pe_act_in[6]
+ act_in[5]=g_row_3__g_col_2__pe_act_in[5]
+ act_in[4]=g_row_3__g_col_2__pe_act_in[4]
+ act_in[3]=g_row_3__g_col_2__pe_act_in[3]
+ act_in[2]=g_row_3__g_col_2__pe_act_in[2]
+ act_in[1]=g_row_3__g_col_2__pe_act_in[1]
+ act_in[0]=g_row_3__g_col_2__pe_act_in[0]
+ psum_in[31]=g_row_3__g_col_2__pe_psum_in[31]
+ psum_in[30]=g_row_3__g_col_2__pe_psum_in[30]
+ psum_in[29]=g_row_3__g_col_2__pe_psum_in[29]
+ psum_in[28]=g_row_3__g_col_2__pe_psum_in[28]
+ psum_in[27]=g_row_3__g_col_2__pe_psum_in[27]
+ psum_in[26]=g_row_3__g_col_2__pe_psum_in[26]
+ psum_in[25]=g_row_3__g_col_2__pe_psum_in[25]
+ psum_in[24]=g_row_3__g_col_2__pe_psum_in[24]
+ psum_in[23]=g_row_3__g_col_2__pe_psum_in[23]
+ psum_in[22]=g_row_3__g_col_2__pe_psum_in[22]
+ psum_in[21]=g_row_3__g_col_2__pe_psum_in[21]
+ psum_in[20]=g_row_3__g_col_2__pe_psum_in[20]
+ psum_in[19]=g_row_3__g_col_2__pe_psum_in[19]
+ psum_in[18]=g_row_3__g_col_2__pe_psum_in[18]
+ psum_in[17]=g_row_3__g_col_2__pe_psum_in[17]
+ psum_in[16]=g_row_3__g_col_2__pe_psum_in[16]
+ psum_in[15]=g_row_3__g_col_2__pe_psum_in[15]
+ psum_in[14]=g_row_3__g_col_2__pe_psum_in[14]
+ psum_in[13]=g_row_3__g_col_2__pe_psum_in[13]
+ psum_in[12]=g_row_3__g_col_2__pe_psum_in[12]
+ psum_in[11]=g_row_3__g_col_2__pe_psum_in[11]
+ psum_in[10]=g_row_3__g_col_2__pe_psum_in[10]
+ psum_in[9]=g_row_3__g_col_2__pe_psum_in[9]
+ psum_in[8]=g_row_3__g_col_2__pe_psum_in[8]
+ psum_in[7]=g_row_3__g_col_2__pe_psum_in[7]
+ psum_in[6]=g_row_3__g_col_2__pe_psum_in[6]
+ psum_in[5]=g_row_3__g_col_2__pe_psum_in[5]
+ psum_in[4]=g_row_3__g_col_2__pe_psum_in[4]
+ psum_in[3]=g_row_3__g_col_2__pe_psum_in[3]
+ psum_in[2]=g_row_3__g_col_2__pe_psum_in[2]
+ psum_in[1]=g_row_3__g_col_2__pe_psum_in[1]
+ psum_in[0]=g_row_3__g_col_2__pe_psum_in[0]
+ act_out[7]=g_row_3__g_col_3__pe_act_in[7]
+ act_out[6]=g_row_3__g_col_3__pe_act_in[6]
+ act_out[5]=g_row_3__g_col_3__pe_act_in[5]
+ act_out[4]=g_row_3__g_col_3__pe_act_in[4]
+ act_out[3]=g_row_3__g_col_3__pe_act_in[3]
+ act_out[2]=g_row_3__g_col_3__pe_act_in[2]
+ act_out[1]=g_row_3__g_col_3__pe_act_in[1]
+ act_out[0]=g_row_3__g_col_3__pe_act_in[0] psum_out[31]=psum_out[95]
+ psum_out[30]=psum_out[94] psum_out[29]=psum_out[93] psum_out[28]=psum_out[92]
+ psum_out[27]=psum_out[91] psum_out[26]=psum_out[90] psum_out[25]=psum_out[89]
+ psum_out[24]=psum_out[88] psum_out[23]=psum_out[87] psum_out[22]=psum_out[86]
+ psum_out[21]=psum_out[85] psum_out[20]=psum_out[84] psum_out[19]=psum_out[83]
+ psum_out[18]=psum_out[82] psum_out[17]=psum_out[81] psum_out[16]=psum_out[80]
+ psum_out[15]=psum_out[79] psum_out[14]=psum_out[78] psum_out[13]=psum_out[77]
+ psum_out[12]=psum_out[76] psum_out[11]=psum_out[75] psum_out[10]=psum_out[74]
+ psum_out[9]=psum_out[73] psum_out[8]=psum_out[72] psum_out[7]=psum_out[71]
+ psum_out[6]=psum_out[70] psum_out[5]=psum_out[69] psum_out[4]=psum_out[68]
+ psum_out[3]=psum_out[67] psum_out[2]=psum_out[66] psum_out[1]=psum_out[65]
+ psum_out[0]=psum_out[64] VDD=VDD VSS=VSS ZCTSNET_15=ctosc_gls_3
+ ZCTSNET_2=ZCTSNET_117 HFSNET_3=mode_unsigned HFSNET_4=array_en
+ HFSNET_7=HFSNET_58 HFSNET_8=HFSNET_66 HFSNET_9=HFSNET_84 HFSNET_10=HFSNET_98
+ HFSNET_11=HFSNET_99 HFSNET_12=HFSNET_103 ZCTSNET_0=ZCTSNET_27
Xg_row_3__g_col_3__pe unpu_pe_0 $PINS clk=ZCTSNET_118 rst_n=HFSNET_72
+ array_en=HFSNET_50 weight_load=weight_load[15] mode_unsigned=HFSNET_30
+ weight_in[7]=weight_in[127] weight_in[6]=weight_in[126]
+ weight_in[5]=weight_in[125] weight_in[4]=weight_in[124]
+ weight_in[3]=weight_in[123] weight_in[2]=weight_in[122]
+ weight_in[1]=weight_in[121] weight_in[0]=weight_in[120]
+ act_in[7]=g_row_3__g_col_3__pe_act_in[7]
+ act_in[6]=g_row_3__g_col_3__pe_act_in[6]
+ act_in[5]=g_row_3__g_col_3__pe_act_in[5]
+ act_in[4]=g_row_3__g_col_3__pe_act_in[4]
+ act_in[3]=g_row_3__g_col_3__pe_act_in[3]
+ act_in[2]=g_row_3__g_col_3__pe_act_in[2]
+ act_in[1]=g_row_3__g_col_3__pe_act_in[1]
+ act_in[0]=g_row_3__g_col_3__pe_act_in[0]
+ psum_in[31]=g_row_3__g_col_3__pe_psum_in[31]
+ psum_in[30]=g_row_3__g_col_3__pe_psum_in[30]
+ psum_in[29]=g_row_3__g_col_3__pe_psum_in[29]
+ psum_in[28]=g_row_3__g_col_3__pe_psum_in[28]
+ psum_in[27]=g_row_3__g_col_3__pe_psum_in[27]
+ psum_in[26]=g_row_3__g_col_3__pe_psum_in[26]
+ psum_in[25]=g_row_3__g_col_3__pe_psum_in[25]
+ psum_in[24]=g_row_3__g_col_3__pe_psum_in[24]
+ psum_in[23]=g_row_3__g_col_3__pe_psum_in[23]
+ psum_in[22]=g_row_3__g_col_3__pe_psum_in[22]
+ psum_in[21]=g_row_3__g_col_3__pe_psum_in[21]
+ psum_in[20]=g_row_3__g_col_3__pe_psum_in[20]
+ psum_in[19]=g_row_3__g_col_3__pe_psum_in[19]
+ psum_in[18]=g_row_3__g_col_3__pe_psum_in[18]
+ psum_in[17]=g_row_3__g_col_3__pe_psum_in[17]
+ psum_in[16]=g_row_3__g_col_3__pe_psum_in[16]
+ psum_in[15]=g_row_3__g_col_3__pe_psum_in[15]
+ psum_in[14]=g_row_3__g_col_3__pe_psum_in[14]
+ psum_in[13]=g_row_3__g_col_3__pe_psum_in[13]
+ psum_in[12]=g_row_3__g_col_3__pe_psum_in[12]
+ psum_in[11]=g_row_3__g_col_3__pe_psum_in[11]
+ psum_in[10]=g_row_3__g_col_3__pe_psum_in[10]
+ psum_in[9]=g_row_3__g_col_3__pe_psum_in[9]
+ psum_in[8]=g_row_3__g_col_3__pe_psum_in[8]
+ psum_in[7]=g_row_3__g_col_3__pe_psum_in[7]
+ psum_in[6]=g_row_3__g_col_3__pe_psum_in[6]
+ psum_in[5]=g_row_3__g_col_3__pe_psum_in[5]
+ psum_in[4]=g_row_3__g_col_3__pe_psum_in[4]
+ psum_in[3]=g_row_3__g_col_3__pe_psum_in[3]
+ psum_in[2]=g_row_3__g_col_3__pe_psum_in[2]
+ psum_in[1]=g_row_3__g_col_3__pe_psum_in[1]
+ psum_in[0]=g_row_3__g_col_3__pe_psum_in[0] psum_out[31]=psum_out[127]
+ psum_out[30]=psum_out[126] psum_out[29]=psum_out[125]
+ psum_out[28]=psum_out[124] psum_out[27]=psum_out[123]
+ psum_out[26]=psum_out[122] psum_out[25]=psum_out[121]
+ psum_out[24]=psum_out[120] psum_out[23]=psum_out[119]
+ psum_out[22]=psum_out[118] psum_out[21]=psum_out[117]
+ psum_out[20]=psum_out[116] psum_out[19]=psum_out[115]
+ psum_out[18]=psum_out[114] psum_out[17]=psum_out[113]
+ psum_out[16]=psum_out[112] psum_out[15]=psum_out[111]
+ psum_out[14]=psum_out[110] psum_out[13]=psum_out[109]
+ psum_out[12]=psum_out[108] psum_out[11]=psum_out[107]
+ psum_out[10]=psum_out[106] psum_out[9]=psum_out[105] psum_out[8]=psum_out[104]
+ psum_out[7]=psum_out[103] psum_out[6]=psum_out[102] psum_out[5]=psum_out[101]
+ psum_out[4]=psum_out[100] psum_out[3]=psum_out[99] psum_out[2]=psum_out[98]
+ psum_out[1]=psum_out[97] psum_out[0]=psum_out[96] VDD=VDD VSS=VSS
+ ZCTSNET_12=ZCTSNET_119 ZCTSNET_0=ZCTSNET_24 HFSNET_2=HFSNET_39
+ HFSNET_3=HFSNET_40 HFSNET_4=mode_unsigned HFSNET_6=HFSNET_58 HFSNET_9=HFSNET_73
+ HFSNET_10=HFSNET_84 HFSNET_11=HFSNET_103 ZCTSNET_2=ZCTSNET_25
+ ZCTSNET_3=ZCTSNET_27 ZCTSNET_4=ZCTSNET_28
XHFSINV_43991_559 inv0d0 $PINS I=HFSNET_49 ZN=HFSNET_44 VDD=VDD VSS=VSS
XHFSINV_41462_560 inv0d0 $PINS I=HFSNET_49 ZN=HFSNET_45 VDD=VDD VSS=VSS
XHFSBUF_45814_562 buffd1 $PINS I=HFSNET_49 Z=HFSNET_46 VDD=VDD VSS=VSS
XHFSBUF_47978_563 buffd1 $PINS I=HFSNET_49 Z=HFSNET_47 VDD=VDD VSS=VSS
XHFSINV_44186_538 inv0d1 $PINS I=HFSNET_39 ZN=HFSNET_28 VDD=VDD VSS=VSS
XHFSINV_49396_539 inv0d1 $PINS I=HFSNET_39 ZN=HFSNET_29 VDD=VDD VSS=VSS
XHFSINV_41405_540 inv0d1 $PINS I=HFSNET_39 ZN=HFSNET_30 VDD=VDD VSS=VSS
XHFSBUF_44321_541 buffd1 $PINS I=HFSNET_39 Z=HFSNET_31 VDD=VDD VSS=VSS
XHFSINV_19266_651 inv0d1 $PINS I=HFSNET_80 ZN=HFSNET_75 VDD=VDD VSS=VSS
XHFSINV_15494_654 inv0d2 $PINS I=HFSNET_80 ZN=HFSNET_78 VDD=VDD VSS=VSS
XZCTSBUF_60383_2520 buffda $PINS I=ZCTSNET_14 Z=ZCTSNET_15 VDD=VDD VSS=VSS
XZCTSBUF_90590_2525 bufbd3 $PINS I=ZCTSNET_27 Z=ZCTSNET_18 VDD=VDD VSS=VSS
XZCTSBUF_87876_2526 buffd3 $PINS I=ZCTSNET_27 Z=ZCTSNET_19 VDD=VDD VSS=VSS
XZCTSBUF_89125_2527 bufbd3 $PINS I=ZCTSNET_27 Z=ZCTSNET_20 VDD=VDD VSS=VSS
XZCTSBUF_89599_2528 buffd3 $PINS I=ZCTSNET_27 Z=ZCTSNET_21 VDD=VDD VSS=VSS
XHFSBUF_49020_542 buffd1 $PINS I=HFSNET_39 Z=HFSNET_32 VDD=VDD VSS=VSS
XHFSINV_15699_545 inv0d1 $PINS I=HFSNET_38 ZN=HFSNET_34 VDD=VDD VSS=VSS
XHFSINV_6966_548 inv0d1 $PINS I=HFSNET_38 ZN=HFSNET_35 VDD=VDD VSS=VSS
XHFSBUF_15918_550 buffd1 $PINS I=HFSNET_37 Z=HFSNET_36 VDD=VDD VSS=VSS
XHFSBUF_23937_551 buffd3 $PINS I=HFSNET_38 Z=HFSNET_37 VDD=VDD VSS=VSS
XHFSBUF_31605_552 bufbd3 $PINS I=HFSNET_39 Z=HFSNET_38 VDD=VDD VSS=VSS
XHFSINV_53187_553 inv0d2 $PINS I=HFSNET_43 ZN=HFSNET_39 VDD=VDD VSS=VSS
XHFSBUF_52002_554 buffd3 $PINS I=HFSNET_41 Z=HFSNET_40 VDD=VDD VSS=VSS
XHFSINV_52739_555 inv0d2 $PINS I=HFSNET_43 ZN=HFSNET_41 VDD=VDD VSS=VSS
XHFSBUF_30746_556 buffd1 $PINS I=mode_unsigned Z=HFSNET_42 VDD=VDD VSS=VSS
XHFSBUF_48871_565 buffd1 $PINS I=HFSNET_49 Z=HFSNET_48 VDD=VDD VSS=VSS
XHFSINV_51650_567 inv0d1 $PINS I=HFSNET_58 ZN=HFSNET_49 VDD=VDD VSS=VSS
XHFSINV_57789_569 inv0d1 $PINS I=HFSNET_58 ZN=HFSNET_50 VDD=VDD VSS=VSS
XHFSINV_52431_573 inv0d1 $PINS I=HFSNET_58 ZN=HFSNET_51 VDD=VDD VSS=VSS
XHFSINV_54065_575 inv0d1 $PINS I=HFSNET_58 ZN=HFSNET_53 VDD=VDD VSS=VSS
XHFSINV_53265_577 inv0d1 $PINS I=HFSNET_58 ZN=HFSNET_55 VDD=VDD VSS=VSS
XHFSINV_55886_579 inv0d1 $PINS I=HFSNET_58 ZN=HFSNET_57 VDD=VDD VSS=VSS
XHFSINV_20553_591 inv0d1 $PINS I=HFSNET_61 ZN=HFSNET_62 VDD=VDD VSS=VSS
XHFSINV_25240_593 inv0d1 $PINS I=HFSNET_61 ZN=HFSNET_63 VDD=VDD VSS=VSS
XHFSINV_24285_596 inv0d1 $PINS I=HFSNET_61 ZN=HFSNET_64 VDD=VDD VSS=VSS
XHFSINV_21612_597 inv0d1 $PINS I=HFSNET_61 ZN=HFSNET_65 VDD=VDD VSS=VSS
XHFSINV_15743_668 inv0d2 $PINS I=HFSNET_80 ZN=HFSNET_81 VDD=VDD VSS=VSS
XHFSINV_15842_670 inv0d1 $PINS I=HFSNET_80 ZN=HFSNET_82 VDD=VDD VSS=VSS
XHFSINV_15616_671 inv0d1 $PINS I=HFSNET_80 ZN=HFSNET_83 VDD=VDD VSS=VSS
XHFSINV_267_674 inv0d2 $PINS I=HFSNET_101 ZN=HFSNET_86 VDD=VDD VSS=VSS
XHFSINV_128_675 inv0d2 $PINS I=HFSNET_101 ZN=HFSNET_87 VDD=VDD VSS=VSS
XHFSINV_1678_682 inv0d2 $PINS I=HFSNET_100 ZN=HFSNET_91 VDD=VDD VSS=VSS
XHFSINV_1523_683 inv0d2 $PINS I=HFSNET_100 ZN=HFSNET_92 VDD=VDD VSS=VSS
XHFSINV_1945_685 inv0d2 $PINS I=HFSNET_100 ZN=HFSNET_93 VDD=VDD VSS=VSS
XHFSINV_5317_700 inv0d2 $PINS I=HFSNET_101 ZN=HFSNET_102 VDD=VDD VSS=VSS
XHFSINV_5035_701 inv0d2 $PINS I=HFSNET_101 ZN=HFSNET_103 VDD=VDD VSS=VSS
XHFSINV_446_702 inv0d2 $PINS I=HFSNET_101 ZN=HFSNET_104 VDD=VDD VSS=VSS
.ENDS

.SUBCKT unpu_skew ZCTSNET_10 rst_n array_en a_raw[31] a_raw[30] a_raw[29]
+ a_raw[28] a_raw[27] a_raw[26] a_raw[25] a_raw[24] a_raw[23] a_raw[22]
+ a_raw[21] a_raw[20] a_raw[19] a_raw[18] a_raw[17] a_raw[16] a_raw[15]
+ a_raw[14] a_raw[13] a_raw[12] a_raw[11] a_raw[10] a_raw[9] a_raw[8] a_raw[7]
+ a_raw[6] a_raw[5] a_raw[4] a_raw[3] a_raw[2] a_raw[1] a_raw[0] act_out[31]
+ act_out[30] act_out[29] act_out[28] act_out[27] act_out[26] act_out[25]
+ act_out[24] act_out[23] act_out[22] act_out[21] act_out[20] act_out[19]
+ act_out[18] act_out[17] act_out[16] act_out[15] act_out[14] act_out[13]
+ act_out[12] act_out[11] act_out[10] act_out[9] act_out[8] act_out[7]
+ act_out[6] act_out[5] act_out[4] act_out[3] act_out[2] act_out[1] act_out[0]
+ VDD VSS ZCTSNET_0 HFSNET_2 HFSNET_3 HFSNET_4 HFSNET_6 HFSNET_7 HFSNET_8
+ HFSNET_9 sbcto_ht1_0
*.CONNECT act_out[7] a_raw[7]
*.CONNECT act_out[6] a_raw[6]
*.CONNECT act_out[5] a_raw[5]
*.CONNECT act_out[4] a_raw[4]
*.CONNECT act_out[3] a_raw[3]
*.CONNECT act_out[2] a_raw[2]
*.CONNECT act_out[1] a_raw[1]
*.CONNECT act_out[0] a_raw[0]
XU2 aor22d1 $PINS A1=array_en A2=copt_net_1319 B1=act_out[24] B2=HFSNET_4 Z=n2
+ VDD=VDD VSS=VSS
XU4 aor22d1 $PINS A1=array_en A2=copt_net_1970 B1=act_out[25] B2=HFSNET_4 Z=n4
+ VDD=VDD VSS=VSS
XU6 aor22d1 $PINS A1=array_en A2=copt_net_1972 B1=act_out[26] B2=HFSNET_4 Z=n6
+ VDD=VDD VSS=VSS
XU7 aor22d1 $PINS A1=array_en A2=copt_net_690 B1=HFSNET_4 B2=copt_net_1972 Z=n7
+ VDD=VDD VSS=VSS
XU8 aor22d1 $PINS A1=array_en A2=copt_net_1604 B1=act_out[27] B2=HFSNET_4 Z=n8
+ VDD=VDD VSS=VSS
XU9 aor22d1 $PINS A1=array_en A2=copt_net_746 B1=HFSNET_4 B2=copt_net_1604 Z=n9
+ VDD=VDD VSS=VSS
XU10 aor22d1 $PINS A1=HFSNET_6 A2=row3_q2[4] B1=act_out[28] B2=HFSNET_2 Z=n10
+ VDD=VDD VSS=VSS
XU11 aor22d1 $PINS A1=HFSNET_6 A2=copt_net_1233 B1=HFSNET_3 B2=copt_net_2454
+ Z=n11 VDD=VDD VSS=VSS
XU12 aor22d1 $PINS A1=array_en A2=copt_net_1653 B1=act_out[29] B2=HFSNET_4
+ Z=n12 VDD=VDD VSS=VSS
XU13 aor22d1 $PINS A1=array_en A2=copt_net_694 B1=HFSNET_4 B2=copt_net_1653
+ Z=n13 VDD=VDD VSS=VSS
XU15 aor22d1 $PINS A1=array_en A2=copt_net_711 B1=HFSNET_4 B2=copt_net_2084
+ Z=n15 VDD=VDD VSS=VSS
XU17 aor22d1 $PINS A1=array_en A2=copt_net_964 B1=HFSNET_4 B2=copt_net_2073
+ Z=n17 VDD=VDD VSS=VSS
XU18 aor22d1 $PINS A1=HFSNET_3 A2=copt_net_970 B1=a_raw[24] B2=HFSNET_6 Z=n18
+ VDD=VDD VSS=VSS
XU19 aor22d1 $PINS A1=HFSNET_4 A2=copt_net_763 B1=a_raw[25] B2=array_en Z=n19
+ VDD=VDD VSS=VSS
XU20 aor22d1 $PINS A1=HFSNET_4 A2=copt_net_690 B1=a_raw[26] B2=array_en Z=n20
+ VDD=VDD VSS=VSS
XU21 aor22d1 $PINS A1=HFSNET_4 A2=copt_net_746 B1=a_raw[27] B2=array_en Z=n21
+ VDD=VDD VSS=VSS
XU22 aor22d1 $PINS A1=HFSNET_4 A2=copt_net_1234 B1=a_raw[28] B2=array_en Z=n22
+ VDD=VDD VSS=VSS
XU23 aor22d1 $PINS A1=HFSNET_4 A2=copt_net_694 B1=a_raw[29] B2=array_en Z=n23
+ VDD=VDD VSS=VSS
XU24 aor22d1 $PINS A1=HFSNET_4 A2=copt_net_711 B1=a_raw[30] B2=array_en Z=n24
+ VDD=VDD VSS=VSS
XU25 aor22d1 $PINS A1=HFSNET_4 A2=copt_net_964 B1=a_raw[31] B2=array_en Z=n25
+ VDD=VDD VSS=VSS
XU27 aor22d1 $PINS A1=HFSNET_4 A2=copt_net_1036 B1=a_raw[16] B2=array_en Z=n27
+ VDD=VDD VSS=VSS
XU29 aor22d1 $PINS A1=HFSNET_4 A2=copt_net_1292 B1=a_raw[17] B2=array_en Z=n29
+ VDD=VDD VSS=VSS
XU30 aor22d1 $PINS A1=array_en A2=copt_net_681 B1=act_out[18] B2=HFSNET_4 Z=n30
+ VDD=VDD VSS=VSS
XU31 aor22d1 $PINS A1=HFSNET_4 A2=copt_net_681 B1=a_raw[18] B2=array_en Z=n31
+ VDD=VDD VSS=VSS
XU32 aor22d1 $PINS A1=HFSNET_6 A2=copt_net_443 B1=act_out[19] B2=HFSNET_3 Z=n32
+ VDD=VDD VSS=VSS
XU33 aor22d1 $PINS A1=HFSNET_3 A2=copt_net_443 B1=a_raw[19] B2=HFSNET_6 Z=n33
+ VDD=VDD VSS=VSS
XU35 aor22d1 $PINS A1=HFSNET_3 A2=copt_net_462 B1=a_raw[20] B2=HFSNET_6 Z=n35
+ VDD=VDD VSS=VSS
XU36 aor22d1 $PINS A1=HFSNET_6 A2=copt_net_620 B1=act_out[21] B2=HFSNET_3 Z=n36
+ VDD=VDD VSS=VSS
XU37 aor22d1 $PINS A1=HFSNET_3 A2=copt_net_620 B1=a_raw[21] B2=HFSNET_6 Z=n37
+ VDD=VDD VSS=VSS
XU38 aor22d1 $PINS A1=HFSNET_6 A2=copt_net_604 B1=act_out[22] B2=HFSNET_3 Z=n38
+ VDD=VDD VSS=VSS
XU39 aor22d1 $PINS A1=HFSNET_3 A2=copt_net_604 B1=a_raw[22] B2=HFSNET_6 Z=n39
+ VDD=VDD VSS=VSS
XU40 aor22d1 $PINS A1=HFSNET_6 A2=copt_net_364 B1=copt_net_275 B2=HFSNET_3
+ Z=n40 VDD=VDD VSS=VSS
XU41 aor22d1 $PINS A1=HFSNET_3 A2=copt_net_364 B1=a_raw[23] B2=HFSNET_6 Z=n41
+ VDD=VDD VSS=VSS
XU42 aor22d1 $PINS A1=act_out[8] A2=HFSNET_3 B1=a_raw[8] B2=HFSNET_6 Z=n42
+ VDD=VDD VSS=VSS
XU43 aor22d1 $PINS A1=act_out[9] A2=HFSNET_3 B1=a_raw[9] B2=HFSNET_6 Z=n43
+ VDD=VDD VSS=VSS
XU44 aor22d1 $PINS A1=act_out[10] A2=HFSNET_3 B1=a_raw[10] B2=HFSNET_6 Z=n44
+ VDD=VDD VSS=VSS
XU45 aor22d1 $PINS A1=act_out[11] A2=HFSNET_3 B1=a_raw[11] B2=HFSNET_6 Z=n45
+ VDD=VDD VSS=VSS
XU46 aor22d1 $PINS A1=copt_net_290 A2=HFSNET_3 B1=a_raw[12] B2=HFSNET_6 Z=n46
+ VDD=VDD VSS=VSS
XU47 aor22d1 $PINS A1=act_out[13] A2=HFSNET_3 B1=a_raw[13] B2=HFSNET_6 Z=n47
+ VDD=VDD VSS=VSS
XU48 aor22d1 $PINS A1=act_out[14] A2=HFSNET_3 B1=a_raw[14] B2=HFSNET_6 Z=n48
+ VDD=VDD VSS=VSS
XU49 aor22d1 $PINS A1=act_out[15] A2=HFSNET_3 B1=a_raw[15] B2=HFSNET_6 Z=n49
+ VDD=VDD VSS=VSS
Xrow2_q1_reg_7_ dfcrq2 $PINS D=n41 CP=ZCTSNET_10 CDN=HFSNET_7 Q=row2_q1[7]
+ VDD=VDD VSS=VSS
Xrow2_q1_reg_6_ dfcrq2 $PINS D=n39 CP=ZCTSNET_10 CDN=rst_n Q=row2_q1[6] VDD=VDD
+ VSS=VSS
Xrow2_q1_reg_5_ dfcrq2 $PINS D=n37 CP=ZCTSNET_10 CDN=HFSNET_7 Q=row2_q1[5]
+ VDD=VDD VSS=VSS
Xrow2_q1_reg_4_ dfcrq2 $PINS D=n35 CP=ZCTSNET_10 CDN=rst_n Q=row2_q1[4] VDD=VDD
+ VSS=VSS
Xrow2_q1_reg_3_ dfcrq2 $PINS D=n33 CP=ZCTSNET_10 CDN=rst_n Q=row2_q1[3] VDD=VDD
+ VSS=VSS
Xrow2_q1_reg_2_ dfcrq2 $PINS D=n31 CP=ZCTSNET_10 CDN=HFSNET_8 Q=row2_q1[2]
+ VDD=VDD VSS=VSS
Xrow2_q1_reg_1_ dfcrq2 $PINS D=n29 CP=ZCTSNET_10 CDN=HFSNET_8 Q=row2_q1[1]
+ VDD=VDD VSS=VSS
Xrow2_q1_reg_0_ dfcrq2 $PINS D=n27 CP=ZCTSNET_10 CDN=HFSNET_8 Q=row2_q1[0]
+ VDD=VDD VSS=VSS
Xrow3_q1_reg_7_ dfcrq2 $PINS D=n25 CP=ZCTSNET_10 CDN=HFSNET_8 Q=row3_q1[7]
+ VDD=VDD VSS=VSS
Xrow3_q1_reg_6_ dfcrq2 $PINS D=n24 CP=ZCTSNET_10 CDN=HFSNET_8 Q=row3_q1[6]
+ VDD=VDD VSS=VSS
Xrow3_q1_reg_5_ dfcrq2 $PINS D=n23 CP=ZCTSNET_10 CDN=HFSNET_8 Q=row3_q1[5]
+ VDD=VDD VSS=VSS
Xrow3_q1_reg_4_ dfcrq2 $PINS D=n22 CP=ZCTSNET_10 CDN=HFSNET_7 Q=row3_q1[4]
+ VDD=VDD VSS=VSS
Xrow3_q1_reg_3_ dfcrq2 $PINS D=n21 CP=ZCTSNET_10 CDN=HFSNET_7 Q=row3_q1[3]
+ VDD=VDD VSS=VSS
Xrow3_q1_reg_2_ dfcrq2 $PINS D=n20 CP=ZCTSNET_10 CDN=HFSNET_7 Q=row3_q1[2]
+ VDD=VDD VSS=VSS
Xrow3_q1_reg_1_ dfcrq2 $PINS D=n19 CP=ZCTSNET_10 CDN=rst_n Q=row3_q1[1] VDD=VDD
+ VSS=VSS
Xrow3_q1_reg_0_ dfcrq2 $PINS D=n18 CP=ZCTSNET_10 CDN=HFSNET_7 Q=row3_q1[0]
+ VDD=VDD VSS=VSS
Xrow3_q2_reg_7_ dfcrq2 $PINS D=n17 CP=ZCTSNET_10 CDN=HFSNET_9 Q=row3_q2[7]
+ VDD=VDD VSS=VSS
Xrow3_q2_reg_6_ dfcrq2 $PINS D=n15 CP=ZCTSNET_10 CDN=HFSNET_8 Q=row3_q2[6]
+ VDD=VDD VSS=VSS
Xrow3_q2_reg_5_ dfcrq2 $PINS D=n13 CP=ZCTSNET_10 CDN=HFSNET_8 Q=row3_q2[5]
+ VDD=VDD VSS=VSS
Xrow3_q2_reg_4_ dfcrq2 $PINS D=n11 CP=ZCTSNET_10 CDN=HFSNET_7 Q=row3_q2[4]
+ VDD=VDD VSS=VSS
Xrow3_q2_reg_3_ dfcrq2 $PINS D=n9 CP=ZCTSNET_10 CDN=HFSNET_7 Q=row3_q2[3]
+ VDD=VDD VSS=VSS
Xrow3_q2_reg_2_ dfcrq2 $PINS D=n7 CP=ZCTSNET_10 CDN=HFSNET_8 Q=row3_q2[2]
+ VDD=VDD VSS=VSS
Xrow3_q2_reg_1_ dfcrq2 $PINS D=n5 CP=ZCTSNET_10 CDN=HFSNET_7 Q=row3_q2[1]
+ VDD=VDD VSS=VSS
Xrow3_q2_reg_0_ dfcrq2 $PINS D=copt_net_2884 CP=ZCTSNET_10 CDN=HFSNET_7
+ Q=row3_q2[0] VDD=VDD VSS=VSS
Xrow2_q2_reg_7_ dfcrq2 $PINS D=n40 CP=ZCTSNET_10 CDN=HFSNET_7 Q=act_out[23]
+ VDD=VDD VSS=VSS
Xrow3_q3_reg_7_ dfcrq2 $PINS D=n16 CP=ZCTSNET_10 CDN=HFSNET_9 Q=aps_rename_28_
+ VDD=VDD VSS=VSS
Xrow1_q_reg_7_ dfcrq2 $PINS D=n49 CP=ZCTSNET_10 CDN=HFSNET_7 Q=aps_rename_35_
+ VDD=VDD VSS=VSS
Xrow2_q2_reg_5_ dfcrq2 $PINS D=copt_net_2906 CP=ZCTSNET_10 CDN=HFSNET_7
+ Q=act_out[21] VDD=VDD VSS=VSS
Xrow3_q3_reg_5_ dfcrq2 $PINS D=n12 CP=sbcto_ht1_0 CDN=rst_n Q=aps_rename_30_
+ VDD=VDD VSS=VSS
Xrow1_q_reg_5_ dfcrq2 $PINS D=n47 CP=ZCTSNET_10 CDN=HFSNET_7 Q=aps_rename_37_
+ VDD=VDD VSS=VSS
Xrow2_q2_reg_6_ dfcrq2 $PINS D=copt_net_2911 CP=ZCTSNET_10 CDN=rst_n
+ Q=act_out[22] VDD=VDD VSS=VSS
Xrow3_q3_reg_6_ dfcrq2 $PINS D=n14 CP=ZCTSNET_10 CDN=HFSNET_8 Q=aps_rename_29_
+ VDD=VDD VSS=VSS
Xrow1_q_reg_6_ dfcrq2 $PINS D=n48 CP=ZCTSNET_10 CDN=HFSNET_7 Q=aps_rename_36_
+ VDD=VDD VSS=VSS
Xrow2_q2_reg_0_ dfcrq2 $PINS D=copt_net_2916 CP=sbcto_ht1_0 CDN=HFSNET_8
+ Q=act_out[16] VDD=VDD VSS=VSS
Xrow3_q3_reg_0_ dfcrq2 $PINS D=n2 CP=sbcto_ht1_0 CDN=HFSNET_7 Q=aps_rename_33_
+ VDD=VDD VSS=VSS
Xrow1_q_reg_0_ dfcrq2 $PINS D=n42 CP=ZCTSNET_10 CDN=HFSNET_7 Q=aps_rename_41_
+ VDD=VDD VSS=VSS
Xrow2_q2_reg_1_ dfcrq2 $PINS D=n28 CP=ZCTSNET_10 CDN=HFSNET_8 Q=act_out[17]
+ VDD=VDD VSS=VSS
Xrow3_q3_reg_1_ dfcrq2 $PINS D=n4 CP=ZCTSNET_10 CDN=HFSNET_7 Q=aps_rename_32_
+ VDD=VDD VSS=VSS
Xrow1_q_reg_1_ dfcrq2 $PINS D=n43 CP=ZCTSNET_10 CDN=HFSNET_7 Q=aps_rename_40_
+ VDD=VDD VSS=VSS
Xrow2_q2_reg_3_ dfcrq2 $PINS D=copt_net_2885 CP=ZCTSNET_10 CDN=HFSNET_7
+ Q=act_out[19] VDD=VDD VSS=VSS
Xrow3_q3_reg_3_ dfcrq2 $PINS D=n8 CP=sbcto_ht1_0 CDN=HFSNET_8 Q=aps_rename_31_
+ VDD=VDD VSS=VSS
Xrow1_q_reg_3_ dfcrq2 $PINS D=n45 CP=ZCTSNET_10 CDN=HFSNET_7 Q=aps_rename_38_
+ VDD=VDD VSS=VSS
Xrow2_q2_reg_2_ dfcrq2 $PINS D=n30 CP=ZCTSNET_10 CDN=HFSNET_7 Q=aps_rename_34_
+ VDD=VDD VSS=VSS
Xrow3_q3_reg_2_ dfcrq2 $PINS D=copt_net_2896 CP=ZCTSNET_10 CDN=HFSNET_9
+ Q=act_out[26] VDD=VDD VSS=VSS
Xrow1_q_reg_2_ dfcrq2 $PINS D=n44 CP=ZCTSNET_10 CDN=HFSNET_7 Q=aps_rename_39_
+ VDD=VDD VSS=VSS
Xrow2_q2_reg_4_ dfcrq2 $PINS D=copt_net_2897 CP=ZCTSNET_10 CDN=rst_n
+ Q=act_out[20] VDD=VDD VSS=VSS
Xrow3_q3_reg_4_ dfcrq2 $PINS D=copt_net_257 CP=ZCTSNET_0 CDN=HFSNET_9
+ Q=act_out[28] VDD=VDD VSS=VSS
Xrow1_q_reg_4_ dfcrq2 $PINS D=n46 CP=ZCTSNET_10 CDN=HFSNET_7 Q=act_out[12]
+ VDD=VDD VSS=VSS
XU3 mx02d1 $PINS I0=copt_net_462 I1=act_out[20] S=HFSNET_3 Z=n34 VDD=VDD
+ VSS=VSS
XU5 mx02d0 $PINS I0=copt_net_1292 I1=copt_net_1122 S=HFSNET_4 Z=n28 VDD=VDD
+ VSS=VSS
XU14 mx02d1 $PINS I0=copt_net_1036 I1=act_out[16] S=HFSNET_4 Z=n26 VDD=VDD
+ VSS=VSS
XU16 mx02d1 $PINS I0=copt_net_2084 I1=act_out[30] S=HFSNET_2 Z=n14 VDD=VDD
+ VSS=VSS
XU26 mx02d0 $PINS I0=copt_net_2072 I1=act_out[31] S=HFSNET_2 Z=n16 VDD=VDD
+ VSS=VSS
XU28 mx02d0 $PINS I0=row3_q1[0] I1=copt_net_1319 S=HFSNET_4 Z=n3 VDD=VDD
+ VSS=VSS
XU34 mx02d0 $PINS I0=copt_net_763 I1=copt_net_1971 S=HFSNET_3 Z=n5 VDD=VDD
+ VSS=VSS
Xcopt_h_inst_3087 dl02d1 $PINS I=n10 Z=copt_net_257 VDD=VDD VSS=VSS
Xcopt_h_inst_3088 dl02d1 $PINS I=aps_rename_28_ Z=act_out[31] VDD=VDD VSS=VSS
Xcopt_h_inst_3091 dl02d2 $PINS I=aps_rename_29_ Z=act_out[30] VDD=VDD VSS=VSS
Xcopt_h_inst_3092 dl01d1 $PINS I=copt_net_263 Z=act_out[10] VDD=VDD VSS=VSS
Xcopt_h_inst_3093 buffd1 $PINS I=aps_rename_39_ Z=copt_net_263 VDD=VDD VSS=VSS
Xcopt_h_inst_3097 dl02d1 $PINS I=aps_rename_35_ Z=act_out[15] VDD=VDD VSS=VSS
Xcopt_h_inst_3099 dl02d2 $PINS I=aps_rename_37_ Z=act_out[13] VDD=VDD VSS=VSS
Xcopt_h_inst_3103 dl02d2 $PINS I=aps_rename_40_ Z=act_out[9] VDD=VDD VSS=VSS
Xcopt_h_inst_3105 dl02d1 $PINS I=act_out[23] Z=copt_net_275 VDD=VDD VSS=VSS
Xcopt_h_inst_3110 dl02d1 $PINS I=aps_rename_32_ Z=act_out[25] VDD=VDD VSS=VSS
Xcopt_h_inst_3111 dl01d1 $PINS I=copt_net_282 Z=act_out[11] VDD=VDD VSS=VSS
Xcopt_h_inst_3112 buffd1 $PINS I=aps_rename_38_ Z=copt_net_282 VDD=VDD VSS=VSS
Xcopt_h_inst_3114 dl02d2 $PINS I=aps_rename_36_ Z=act_out[14] VDD=VDD VSS=VSS
Xcopt_h_inst_3120 dl01d1 $PINS I=act_out[12] Z=copt_net_290 VDD=VDD VSS=VSS
Xcopt_h_inst_3126 dl01d1 $PINS I=aps_rename_30_ Z=act_out[29] VDD=VDD VSS=VSS
Xcopt_h_inst_3131 dl01d1 $PINS I=aps_rename_41_ Z=act_out[8] VDD=VDD VSS=VSS
Xcopt_h_inst_3132 dl01d2 $PINS I=copt_net_303 Z=act_out[24] VDD=VDD VSS=VSS
Xcopt_h_inst_3133 buffd1 $PINS I=aps_rename_33_ Z=copt_net_303 VDD=VDD VSS=VSS
Xcopt_h_inst_5287 dl02d1 $PINS I=row3_q2[4] Z=copt_net_2454 VDD=VDD VSS=VSS
Xcopt_h_inst_5718 dl02d1 $PINS I=n3 Z=copt_net_2884 VDD=VDD VSS=VSS
Xcopt_h_inst_3194 dl02d1 $PINS I=row2_q1[7] Z=copt_net_364 VDD=VDD VSS=VSS
Xcopt_h_inst_3273 dl02d1 $PINS I=row2_q1[3] Z=copt_net_443 VDD=VDD VSS=VSS
Xcopt_h_inst_3292 dl02d1 $PINS I=row2_q1[4] Z=copt_net_462 VDD=VDD VSS=VSS
Xcopt_h_inst_3434 dl02d1 $PINS I=row2_q1[6] Z=copt_net_604 VDD=VDD VSS=VSS
Xcopt_h_inst_3450 dl02d1 $PINS I=row2_q1[5] Z=copt_net_620 VDD=VDD VSS=VSS
Xcopt_h_inst_3500 dl01d1 $PINS I=aps_rename_31_ Z=act_out[27] VDD=VDD VSS=VSS
Xcopt_h_inst_3511 dl02d1 $PINS I=row2_q1[2] Z=copt_net_681 VDD=VDD VSS=VSS
Xcopt_h_inst_3520 dl02d1 $PINS I=row3_q1[2] Z=copt_net_690 VDD=VDD VSS=VSS
Xcopt_h_inst_3524 dl02d1 $PINS I=row3_q1[5] Z=copt_net_694 VDD=VDD VSS=VSS
Xcopt_h_inst_3541 dl02d1 $PINS I=row3_q1[6] Z=copt_net_711 VDD=VDD VSS=VSS
Xcopt_h_inst_3577 dl02d1 $PINS I=row3_q1[3] Z=copt_net_746 VDD=VDD VSS=VSS
Xcopt_h_inst_3594 dl02d1 $PINS I=row3_q1[1] Z=copt_net_763 VDD=VDD VSS=VSS
Xcopt_h_inst_3796 dl02d1 $PINS I=row3_q1[7] Z=copt_net_964 VDD=VDD VSS=VSS
Xcopt_h_inst_3802 dl02d1 $PINS I=row3_q1[0] Z=copt_net_970 VDD=VDD VSS=VSS
Xcopt_h_inst_3868 dl02d1 $PINS I=row2_q1[0] Z=copt_net_1036 VDD=VDD VSS=VSS
Xcopt_h_inst_3947 dl01d1 $PINS I=aps_rename_34_ Z=act_out[18] VDD=VDD VSS=VSS
Xcopt_h_inst_3954 dl01d1 $PINS I=act_out[17] Z=copt_net_1122 VDD=VDD VSS=VSS
Xcopt_h_inst_4065 dl02d1 $PINS I=row3_q1[4] Z=copt_net_1233 VDD=VDD VSS=VSS
Xcopt_h_inst_4066 dl02d1 $PINS I=row3_q1[4] Z=copt_net_1234 VDD=VDD VSS=VSS
Xcopt_h_inst_4124 dl02d1 $PINS I=row2_q1[1] Z=copt_net_1292 VDD=VDD VSS=VSS
Xcopt_h_inst_4151 dl02d1 $PINS I=row3_q2[0] Z=copt_net_1319 VDD=VDD VSS=VSS
Xcopt_h_inst_4436 dl02d1 $PINS I=row3_q2[3] Z=copt_net_1604 VDD=VDD VSS=VSS
Xcopt_h_inst_4485 dl02d1 $PINS I=row3_q2[5] Z=copt_net_1653 VDD=VDD VSS=VSS
Xcopt_h_inst_4803 dl02d1 $PINS I=row3_q2[1] Z=copt_net_1970 VDD=VDD VSS=VSS
Xcopt_h_inst_4804 dl02d1 $PINS I=row3_q2[1] Z=copt_net_1971 VDD=VDD VSS=VSS
Xcopt_h_inst_4805 dl02d1 $PINS I=row3_q2[2] Z=copt_net_1972 VDD=VDD VSS=VSS
Xcopt_h_inst_4905 dl02d1 $PINS I=row3_q2[7] Z=copt_net_2072 VDD=VDD VSS=VSS
Xcopt_h_inst_4906 dl02d1 $PINS I=row3_q2[7] Z=copt_net_2073 VDD=VDD VSS=VSS
Xcopt_h_inst_4917 dl02d1 $PINS I=row3_q2[6] Z=copt_net_2084 VDD=VDD VSS=VSS
Xcopt_h_inst_5719 dl02d1 $PINS I=n32 Z=copt_net_2885 VDD=VDD VSS=VSS
Xcopt_h_inst_5730 dl02d1 $PINS I=n6 Z=copt_net_2896 VDD=VDD VSS=VSS
Xcopt_h_inst_5731 dl01d1 $PINS I=n34 Z=copt_net_2897 VDD=VDD VSS=VSS
Xcopt_h_inst_5740 dl01d1 $PINS I=n36 Z=copt_net_2906 VDD=VDD VSS=VSS
Xcopt_h_inst_5745 dl01d1 $PINS I=n38 Z=copt_net_2911 VDD=VDD VSS=VSS
Xcopt_h_inst_5750 dl01d1 $PINS I=n26 Z=copt_net_2916 VDD=VDD VSS=VSS
.ENDS

.SUBCKT unpu_actbuf ZCTSNET_48 rst_n array_en load_start load_m[2] load_m[1]
+ load_m[0] load_k[2] load_k[1] load_k[0] load_row[31] load_row[30]
+ load_row[29] load_row[28] load_row[27] load_row[26] load_row[25] load_row[24]
+ load_row[23] load_row[22] load_row[21] load_row[20] load_row[19] load_row[18]
+ load_row[17] load_row[16] load_row[15] load_row[14] load_row[13] load_row[12]
+ load_row[11] load_row[10] load_row[9] load_row[8] load_row[7] load_row[6]
+ load_row[5] load_row[4] load_row[3] load_row[2] load_row[1] load_row[0]
+ load_busy load_done swap rd_row[1] rd_row[0] rd_data[31] rd_data[30]
+ rd_data[29] rd_data[28] rd_data[27] rd_data[26] rd_data[25] rd_data[24]
+ rd_data[23] rd_data[22] rd_data[21] rd_data[20] rd_data[19] rd_data[18]
+ rd_data[17] rd_data[16] rd_data[15] rd_data[14] rd_data[13] rd_data[12]
+ rd_data[11] rd_data[10] rd_data[9] rd_data[8] rd_data[7] rd_data[6]
+ rd_data[5] rd_data[4] rd_data[3] rd_data[2] rd_data[1] rd_data[0] VDD VSS
+ ZCTSNET_53 ZCTSNET_54 ZCTSNET_55 HFSNET_36 HFSNET_37 HFSNET_38 HFSNET_39
+ HFSNET_42 HFSNET_43 ZCTSNET_0 sbcto_ht1_0
Xbank_b_reg_3__0__0_ dfcrn1 $PINS D=n407 CP=ZCTSNET_6 CDN=HFSNET_41 QN=n279
+ VDD=VDD VSS=VSS
Xbank_b_reg_3__3__7_ dfcrn2 $PINS D=n406 CP=ZCTSNET_54 CDN=HFSNET_44 QN=n248
+ VDD=VDD VSS=VSS
Xbank_b_reg_3__3__6_ dfcrn2 $PINS D=n405 CP=ZCTSNET_54 CDN=HFSNET_41 QN=n249
+ VDD=VDD VSS=VSS
Xbank_b_reg_3__3__5_ dfcrn2 $PINS D=n404 CP=ZCTSNET_54 CDN=HFSNET_41 QN=n250
+ VDD=VDD VSS=VSS
Xbank_b_reg_3__3__4_ dfcrn2 $PINS D=n403 CP=ZCTSNET_6 CDN=HFSNET_41 QN=n251
+ VDD=VDD VSS=VSS
Xbank_b_reg_3__3__3_ dfcrn2 $PINS D=n402 CP=ZCTSNET_6 CDN=HFSNET_41 QN=n252
+ VDD=VDD VSS=VSS
Xbank_b_reg_3__3__2_ dfcrn2 $PINS D=n401 CP=ZCTSNET_6 CDN=HFSNET_41 QN=n253
+ VDD=VDD VSS=VSS
Xbank_b_reg_3__3__1_ dfcrn2 $PINS D=n400 CP=ZCTSNET_54 CDN=HFSNET_44 QN=n254
+ VDD=VDD VSS=VSS
Xbank_b_reg_3__3__0_ dfcrn2 $PINS D=n399 CP=ZCTSNET_55 CDN=HFSNET_44 QN=n255
+ VDD=VDD VSS=VSS
Xbank_b_reg_3__2__7_ dfcrn2 $PINS D=n398 CP=ZCTSNET_53 CDN=HFSNET_44 QN=n256
+ VDD=VDD VSS=VSS
Xbank_b_reg_3__2__6_ dfcrn2 $PINS D=n397 CP=ZCTSNET_0 CDN=HFSNET_44 QN=n257
+ VDD=VDD VSS=VSS
Xbank_b_reg_3__2__5_ dfcrn2 $PINS D=n396 CP=ZCTSNET_55 CDN=HFSNET_44 QN=n258
+ VDD=VDD VSS=VSS
Xbank_b_reg_3__2__4_ dfcrn2 $PINS D=n395 CP=ZCTSNET_53 CDN=HFSNET_44 QN=n259
+ VDD=VDD VSS=VSS
Xbank_b_reg_3__2__3_ dfcrn2 $PINS D=n394 CP=ZCTSNET_53 CDN=HFSNET_44 QN=n260
+ VDD=VDD VSS=VSS
Xbank_b_reg_3__2__2_ dfcrn2 $PINS D=n393 CP=ZCTSNET_53 CDN=HFSNET_44 QN=n261
+ VDD=VDD VSS=VSS
Xbank_b_reg_3__2__1_ dfcrn2 $PINS D=n392 CP=ZCTSNET_0 CDN=HFSNET_44 QN=n262
+ VDD=VDD VSS=VSS
Xbank_b_reg_3__2__0_ dfcrn2 $PINS D=n391 CP=ZCTSNET_0 CDN=HFSNET_44 QN=n263
+ VDD=VDD VSS=VSS
Xbank_b_reg_3__1__7_ dfcrn2 $PINS D=n390 CP=ZCTSNET_0 CDN=HFSNET_44 QN=n264
+ VDD=VDD VSS=VSS
Xbank_b_reg_3__1__6_ dfcrn2 $PINS D=n389 CP=ZCTSNET_0 CDN=HFSNET_38 QN=n265
+ VDD=VDD VSS=VSS
Xbank_b_reg_3__1__5_ dfcrn2 $PINS D=n388 CP=ZCTSNET_0 CDN=HFSNET_38 QN=n266
+ VDD=VDD VSS=VSS
Xbank_b_reg_3__1__4_ dfcrn2 $PINS D=n387 CP=ZCTSNET_0 CDN=HFSNET_38 QN=n267
+ VDD=VDD VSS=VSS
Xbank_b_reg_3__1__3_ dfcrn2 $PINS D=n386 CP=ZCTSNET_0 CDN=HFSNET_38 QN=n268
+ VDD=VDD VSS=VSS
Xbank_b_reg_3__1__2_ dfcrn2 $PINS D=n385 CP=ZCTSNET_53 CDN=HFSNET_44 QN=n269
+ VDD=VDD VSS=VSS
Xbank_b_reg_3__1__1_ dfcrn2 $PINS D=n384 CP=ZCTSNET_0 CDN=HFSNET_38 QN=n270
+ VDD=VDD VSS=VSS
Xbank_b_reg_3__1__0_ dfcrn2 $PINS D=n383 CP=ZCTSNET_0 CDN=HFSNET_38 QN=n271
+ VDD=VDD VSS=VSS
Xbank_b_reg_3__0__7_ dfcrn2 $PINS D=n382 CP=ZCTSNET_0 CDN=HFSNET_38 QN=n272
+ VDD=VDD VSS=VSS
Xbank_b_reg_3__0__6_ dfcrn2 $PINS D=n381 CP=ZCTSNET_0 CDN=HFSNET_38 QN=n273
+ VDD=VDD VSS=VSS
Xbank_b_reg_3__0__5_ dfcrn2 $PINS D=n380 CP=ZCTSNET_6 CDN=HFSNET_41 QN=n274
+ VDD=VDD VSS=VSS
Xbank_b_reg_3__0__4_ dfcrn2 $PINS D=n379 CP=ZCTSNET_6 CDN=HFSNET_41 QN=n275
+ VDD=VDD VSS=VSS
Xbank_b_reg_3__0__3_ dfcrn2 $PINS D=n378 CP=ZCTSNET_6 CDN=HFSNET_41 QN=n276
+ VDD=VDD VSS=VSS
Xbank_b_reg_3__0__2_ dfcrn2 $PINS D=n377 CP=ZCTSNET_6 CDN=HFSNET_41 QN=n277
+ VDD=VDD VSS=VSS
Xbank_b_reg_3__0__1_ dfcrn2 $PINS D=n376 CP=ZCTSNET_6 CDN=HFSNET_41 QN=n278
+ VDD=VDD VSS=VSS
Xbank_b_reg_2__0__0_ dfcrn2 $PINS D=n439 CP=ZCTSNET_5 CDN=HFSNET_41 QN=n311
+ VDD=VDD VSS=VSS
Xbank_b_reg_2__3__7_ dfcrn2 $PINS D=n438 CP=ZCTSNET_53 CDN=HFSNET_41 QN=n280
+ VDD=VDD VSS=VSS
Xbank_b_reg_2__3__6_ dfcrn2 $PINS D=n437 CP=ZCTSNET_5 CDN=HFSNET_41 QN=n281
+ VDD=VDD VSS=VSS
Xbank_b_reg_2__3__5_ dfcrn2 $PINS D=n436 CP=ZCTSNET_5 CDN=HFSNET_41 QN=n282
+ VDD=VDD VSS=VSS
Xbank_b_reg_2__3__4_ dfcrn2 $PINS D=n435 CP=ZCTSNET_5 CDN=HFSNET_41 QN=n283
+ VDD=VDD VSS=VSS
Xbank_b_reg_2__3__3_ dfcrn2 $PINS D=n434 CP=ZCTSNET_5 CDN=HFSNET_41 QN=n284
+ VDD=VDD VSS=VSS
Xbank_b_reg_2__3__2_ dfcrn2 $PINS D=n433 CP=ZCTSNET_5 CDN=HFSNET_41 QN=n285
+ VDD=VDD VSS=VSS
Xbank_b_reg_2__3__1_ dfcrn2 $PINS D=n432 CP=ZCTSNET_4 CDN=HFSNET_41 QN=n286
+ VDD=VDD VSS=VSS
Xbank_b_reg_2__3__0_ dfcrn2 $PINS D=n431 CP=ZCTSNET_4 CDN=HFSNET_41 QN=n287
+ VDD=VDD VSS=VSS
Xbank_b_reg_2__2__7_ dfcrn2 $PINS D=n430 CP=ZCTSNET_5 CDN=HFSNET_47 QN=n288
+ VDD=VDD VSS=VSS
Xbank_b_reg_2__2__6_ dfcrn2 $PINS D=n429 CP=ZCTSNET_4 CDN=HFSNET_41 QN=n289
+ VDD=VDD VSS=VSS
Xbank_b_reg_2__2__5_ dfcrn2 $PINS D=n428 CP=ZCTSNET_4 CDN=HFSNET_41 QN=n290
+ VDD=VDD VSS=VSS
Xbank_b_reg_2__2__4_ dfcrn2 $PINS D=n427 CP=ZCTSNET_4 CDN=HFSNET_41 QN=n291
+ VDD=VDD VSS=VSS
Xbank_b_reg_2__2__3_ dfcrn2 $PINS D=n426 CP=ZCTSNET_4 CDN=HFSNET_47 QN=n292
+ VDD=VDD VSS=VSS
Xbank_b_reg_2__2__2_ dfcrn2 $PINS D=n425 CP=ZCTSNET_53 CDN=HFSNET_47 QN=n293
+ VDD=VDD VSS=VSS
Xbank_b_reg_2__2__1_ dfcrn2 $PINS D=n424 CP=ZCTSNET_0 CDN=HFSNET_47 QN=n294
+ VDD=VDD VSS=VSS
Xbank_b_reg_2__2__0_ dfcrn2 $PINS D=n423 CP=ZCTSNET_0 CDN=HFSNET_47 QN=n295
+ VDD=VDD VSS=VSS
Xbank_b_reg_2__1__7_ dfcrn2 $PINS D=n422 CP=ZCTSNET_0 CDN=HFSNET_38 QN=n296
+ VDD=VDD VSS=VSS
Xbank_b_reg_2__1__6_ dfcrn2 $PINS D=n421 CP=ZCTSNET_0 CDN=HFSNET_38 QN=n297
+ VDD=VDD VSS=VSS
Xbank_b_reg_2__1__5_ dfcrn2 $PINS D=n420 CP=ZCTSNET_0 CDN=rst_n QN=n298 VDD=VDD
+ VSS=VSS
Xbank_b_reg_2__1__4_ dfcrn2 $PINS D=n419 CP=ZCTSNET_0 CDN=HFSNET_38 QN=n299
+ VDD=VDD VSS=VSS
Xbank_b_reg_2__1__3_ dfcrn2 $PINS D=n418 CP=ZCTSNET_0 CDN=rst_n QN=n300 VDD=VDD
+ VSS=VSS
Xbank_b_reg_2__1__2_ dfcrn2 $PINS D=n417 CP=ZCTSNET_0 CDN=HFSNET_47 QN=n301
+ VDD=VDD VSS=VSS
Xbank_b_reg_2__1__1_ dfcrn2 $PINS D=n416 CP=ZCTSNET_0 CDN=rst_n QN=n302 VDD=VDD
+ VSS=VSS
Xbank_b_reg_2__1__0_ dfcrn2 $PINS D=n415 CP=ZCTSNET_0 CDN=rst_n QN=n303 VDD=VDD
+ VSS=VSS
Xbank_b_reg_2__0__7_ dfcrn2 $PINS D=n414 CP=ZCTSNET_4 CDN=HFSNET_40 QN=n304
+ VDD=VDD VSS=VSS
Xbank_b_reg_2__0__6_ dfcrn2 $PINS D=n413 CP=ZCTSNET_4 CDN=HFSNET_40 QN=n305
+ VDD=VDD VSS=VSS
Xbank_b_reg_2__0__5_ dfcrn2 $PINS D=n412 CP=ZCTSNET_4 CDN=HFSNET_40 QN=n306
+ VDD=VDD VSS=VSS
Xbank_b_reg_2__0__4_ dfcrn2 $PINS D=n411 CP=ZCTSNET_4 CDN=HFSNET_40 QN=n307
+ VDD=VDD VSS=VSS
Xbank_b_reg_2__0__3_ dfcrn2 $PINS D=n410 CP=ZCTSNET_4 CDN=HFSNET_40 QN=n308
+ VDD=VDD VSS=VSS
Xbank_b_reg_2__0__2_ dfcrn2 $PINS D=n409 CP=ZCTSNET_4 CDN=HFSNET_40 QN=n309
+ VDD=VDD VSS=VSS
Xbank_b_reg_2__0__1_ dfcrn2 $PINS D=n408 CP=ZCTSNET_4 CDN=HFSNET_40 QN=n310
+ VDD=VDD VSS=VSS
Xbank_b_reg_1__0__0_ dfcrn2 $PINS D=n471 CP=ZCTSNET_4 CDN=HFSNET_40 QN=n343
+ VDD=VDD VSS=VSS
Xbank_b_reg_1__3__7_ dfcrn2 $PINS D=n470 CP=ZCTSNET_4 CDN=HFSNET_40 QN=n312
+ VDD=VDD VSS=VSS
Xbank_b_reg_1__3__6_ dfcrn2 $PINS D=n469 CP=ZCTSNET_4 CDN=HFSNET_40 QN=n313
+ VDD=VDD VSS=VSS
Xbank_b_reg_1__3__5_ dfcrn2 $PINS D=n468 CP=ZCTSNET_4 CDN=HFSNET_40 QN=n314
+ VDD=VDD VSS=VSS
Xbank_b_reg_1__3__4_ dfcrn2 $PINS D=n467 CP=ZCTSNET_4 CDN=HFSNET_40 QN=n315
+ VDD=VDD VSS=VSS
Xbank_b_reg_1__3__3_ dfcrn2 $PINS D=n466 CP=ZCTSNET_4 CDN=HFSNET_40 QN=n316
+ VDD=VDD VSS=VSS
Xbank_b_reg_1__3__2_ dfcrn2 $PINS D=n465 CP=ZCTSNET_2 CDN=HFSNET_40 QN=n317
+ VDD=VDD VSS=VSS
Xbank_b_reg_1__3__1_ dfcrn2 $PINS D=n464 CP=ZCTSNET_4 CDN=HFSNET_40 QN=n318
+ VDD=VDD VSS=VSS
Xbank_b_reg_1__3__0_ dfcrn2 $PINS D=n463 CP=ZCTSNET_4 CDN=HFSNET_40 QN=n319
+ VDD=VDD VSS=VSS
Xbank_b_reg_1__2__7_ dfcrn2 $PINS D=n462 CP=ZCTSNET_4 CDN=HFSNET_40 QN=n320
+ VDD=VDD VSS=VSS
Xbank_b_reg_1__2__6_ dfcrn2 $PINS D=n461 CP=ZCTSNET_4 CDN=HFSNET_40 QN=n321
+ VDD=VDD VSS=VSS
Xbank_b_reg_1__2__5_ dfcrn2 $PINS D=n460 CP=ZCTSNET_4 CDN=HFSNET_40 QN=n322
+ VDD=VDD VSS=VSS
Xbank_b_reg_1__2__4_ dfcrn2 $PINS D=n459 CP=ZCTSNET_4 CDN=HFSNET_40 QN=n323
+ VDD=VDD VSS=VSS
Xbank_b_reg_1__2__3_ dfcrn2 $PINS D=n458 CP=ZCTSNET_2 CDN=HFSNET_45 QN=n324
+ VDD=VDD VSS=VSS
Xbank_b_reg_1__2__2_ dfcrn2 $PINS D=n457 CP=ZCTSNET_2 CDN=HFSNET_46 QN=n325
+ VDD=VDD VSS=VSS
Xbank_b_reg_1__2__1_ dfcrn2 $PINS D=n456 CP=ZCTSNET_2 CDN=HFSNET_45 QN=n326
+ VDD=VDD VSS=VSS
Xbank_b_reg_1__2__0_ dfcrn2 $PINS D=n455 CP=ZCTSNET_2 CDN=HFSNET_45 QN=n327
+ VDD=VDD VSS=VSS
Xbank_b_reg_1__1__7_ dfcrn2 $PINS D=n454 CP=ZCTSNET_2 CDN=HFSNET_46 QN=n328
+ VDD=VDD VSS=VSS
Xbank_b_reg_1__1__6_ dfcrn2 $PINS D=n453 CP=ZCTSNET_2 CDN=HFSNET_46 QN=n329
+ VDD=VDD VSS=VSS
Xbank_b_reg_1__1__5_ dfcrn2 $PINS D=n452 CP=ZCTSNET_2 CDN=HFSNET_46 QN=n330
+ VDD=VDD VSS=VSS
Xbank_b_reg_1__1__4_ dfcrn2 $PINS D=n451 CP=ZCTSNET_2 CDN=HFSNET_46 QN=n331
+ VDD=VDD VSS=VSS
Xbank_b_reg_1__1__3_ dfcrn2 $PINS D=n450 CP=ZCTSNET_2 CDN=HFSNET_46 QN=n332
+ VDD=VDD VSS=VSS
Xbank_b_reg_1__1__2_ dfcrn2 $PINS D=n449 CP=ZCTSNET_2 CDN=HFSNET_46 QN=n333
+ VDD=VDD VSS=VSS
Xbank_b_reg_1__1__1_ dfcrn2 $PINS D=n448 CP=ZCTSNET_0 CDN=HFSNET_46 QN=n334
+ VDD=VDD VSS=VSS
Xbank_b_reg_1__1__0_ dfcrn2 $PINS D=n447 CP=ZCTSNET_0 CDN=rst_n QN=n335 VDD=VDD
+ VSS=VSS
Xbank_b_reg_1__0__7_ dfcrn2 $PINS D=n446 CP=ZCTSNET_0 CDN=rst_n QN=n336 VDD=VDD
+ VSS=VSS
Xbank_b_reg_1__0__6_ dfcrn2 $PINS D=n445 CP=ZCTSNET_0 CDN=rst_n QN=n337 VDD=VDD
+ VSS=VSS
Xbank_b_reg_1__0__5_ dfcrn2 $PINS D=n444 CP=ZCTSNET_0 CDN=rst_n QN=n338 VDD=VDD
+ VSS=VSS
Xbank_b_reg_1__0__4_ dfcrn2 $PINS D=n443 CP=ZCTSNET_0 CDN=rst_n QN=n339 VDD=VDD
+ VSS=VSS
Xbank_b_reg_1__0__3_ dfcrn2 $PINS D=n442 CP=ZCTSNET_0 CDN=HFSNET_46 QN=n340
+ VDD=VDD VSS=VSS
Xbank_b_reg_1__0__2_ dfcrn2 $PINS D=n441 CP=ZCTSNET_0 CDN=rst_n QN=n341 VDD=VDD
+ VSS=VSS
Xbank_b_reg_1__0__1_ dfcrn2 $PINS D=n440 CP=ZCTSNET_2 CDN=HFSNET_46 QN=n342
+ VDD=VDD VSS=VSS
Xbank_b_reg_0__0__0_ dfcrn2 $PINS D=n503 CP=ZCTSNET_2 CDN=HFSNET_46 QN=n375
+ VDD=VDD VSS=VSS
Xbank_b_reg_0__3__7_ dfcrn2 $PINS D=n502 CP=ZCTSNET_2 CDN=HFSNET_45 QN=n344
+ VDD=VDD VSS=VSS
Xbank_b_reg_0__3__6_ dfcrn2 $PINS D=n501 CP=ZCTSNET_4 CDN=HFSNET_40 QN=n345
+ VDD=VDD VSS=VSS
Xbank_b_reg_0__3__5_ dfcrn2 $PINS D=n500 CP=ZCTSNET_4 CDN=HFSNET_40 QN=n346
+ VDD=VDD VSS=VSS
Xbank_b_reg_0__3__4_ dfcrn2 $PINS D=n499 CP=ZCTSNET_2 CDN=HFSNET_45 QN=n347
+ VDD=VDD VSS=VSS
Xbank_b_reg_0__3__3_ dfcrn2 $PINS D=n498 CP=ZCTSNET_4 CDN=HFSNET_45 QN=n348
+ VDD=VDD VSS=VSS
Xbank_b_reg_0__3__2_ dfcrn2 $PINS D=n497 CP=ZCTSNET_4 CDN=HFSNET_40 QN=n349
+ VDD=VDD VSS=VSS
Xbank_b_reg_0__3__1_ dfcrn2 $PINS D=n496 CP=ZCTSNET_2 CDN=HFSNET_45 QN=n350
+ VDD=VDD VSS=VSS
Xbank_b_reg_0__3__0_ dfcrn2 $PINS D=n495 CP=ZCTSNET_2 CDN=HFSNET_45 QN=n351
+ VDD=VDD VSS=VSS
Xbank_b_reg_0__2__7_ dfcrn2 $PINS D=n494 CP=ZCTSNET_4 CDN=HFSNET_45 QN=n352
+ VDD=VDD VSS=VSS
Xbank_b_reg_0__2__6_ dfcrn2 $PINS D=n493 CP=ZCTSNET_4 CDN=HFSNET_45 QN=n353
+ VDD=VDD VSS=VSS
Xbank_b_reg_0__2__5_ dfcrn2 $PINS D=n492 CP=ZCTSNET_2 CDN=HFSNET_45 QN=n354
+ VDD=VDD VSS=VSS
Xbank_b_reg_0__2__4_ dfcrn2 $PINS D=n491 CP=ZCTSNET_2 CDN=HFSNET_45 QN=n355
+ VDD=VDD VSS=VSS
Xbank_b_reg_0__2__3_ dfcrn2 $PINS D=n490 CP=ZCTSNET_2 CDN=HFSNET_45 QN=n356
+ VDD=VDD VSS=VSS
Xbank_b_reg_0__2__2_ dfcrn2 $PINS D=n489 CP=ZCTSNET_2 CDN=HFSNET_45 QN=n357
+ VDD=VDD VSS=VSS
Xbank_b_reg_0__2__1_ dfcrn2 $PINS D=n488 CP=ZCTSNET_2 CDN=HFSNET_45 QN=n358
+ VDD=VDD VSS=VSS
Xbank_b_reg_0__2__0_ dfcrn2 $PINS D=n487 CP=ZCTSNET_2 CDN=HFSNET_45 QN=n359
+ VDD=VDD VSS=VSS
Xbank_b_reg_0__1__7_ dfcrn2 $PINS D=n486 CP=ZCTSNET_2 CDN=HFSNET_46 QN=n360
+ VDD=VDD VSS=VSS
Xbank_b_reg_0__1__6_ dfcrn2 $PINS D=n485 CP=ZCTSNET_2 CDN=HFSNET_45 QN=n361
+ VDD=VDD VSS=VSS
Xbank_b_reg_0__1__5_ dfcrn2 $PINS D=n484 CP=ZCTSNET_2 CDN=HFSNET_45 QN=n362
+ VDD=VDD VSS=VSS
Xbank_b_reg_0__1__4_ dfcrn2 $PINS D=n483 CP=ZCTSNET_2 CDN=HFSNET_45 QN=n363
+ VDD=VDD VSS=VSS
Xbank_b_reg_0__1__3_ dfcrn2 $PINS D=n482 CP=ZCTSNET_0 CDN=rst_n QN=n364 VDD=VDD
+ VSS=VSS
Xbank_b_reg_0__1__2_ dfcrn2 $PINS D=n481 CP=ZCTSNET_0 CDN=rst_n QN=n365 VDD=VDD
+ VSS=VSS
Xbank_b_reg_0__1__1_ dfcrn2 $PINS D=n480 CP=ZCTSNET_0 CDN=rst_n QN=n366 VDD=VDD
+ VSS=VSS
Xbank_b_reg_0__1__0_ dfcrn2 $PINS D=n479 CP=ZCTSNET_0 CDN=rst_n QN=n367 VDD=VDD
+ VSS=VSS
Xbank_b_reg_0__0__7_ dfcrn2 $PINS D=n478 CP=ZCTSNET_0 CDN=HFSNET_38 QN=n368
+ VDD=VDD VSS=VSS
Xbank_b_reg_0__0__6_ dfcrn2 $PINS D=n477 CP=ZCTSNET_0 CDN=rst_n QN=n369 VDD=VDD
+ VSS=VSS
Xbank_b_reg_0__0__5_ dfcrn2 $PINS D=n476 CP=ZCTSNET_0 CDN=rst_n QN=n370 VDD=VDD
+ VSS=VSS
Xbank_b_reg_0__0__4_ dfcrn2 $PINS D=n475 CP=ZCTSNET_0 CDN=rst_n QN=n371 VDD=VDD
+ VSS=VSS
Xbank_b_reg_0__0__3_ dfcrn2 $PINS D=n474 CP=ZCTSNET_0 CDN=rst_n QN=n372 VDD=VDD
+ VSS=VSS
Xbank_b_reg_0__0__2_ dfcrn2 $PINS D=n473 CP=ZCTSNET_0 CDN=rst_n QN=n373 VDD=VDD
+ VSS=VSS
Xbank_b_reg_0__0__1_ dfcrn2 $PINS D=n472 CP=ZCTSNET_53 CDN=HFSNET_44 QN=n374
+ VDD=VDD VSS=VSS
Xbank_a_reg_3__0__0_ dfcrn2 $PINS D=n535 CP=ZCTSNET_54 CDN=HFSNET_42 QN=n151
+ VDD=VDD VSS=VSS
Xbank_a_reg_3__3__7_ dfcrn2 $PINS D=n534 CP=ZCTSNET_54 CDN=HFSNET_42 QN=n120
+ VDD=VDD VSS=VSS
Xbank_a_reg_3__3__6_ dfcrn2 $PINS D=n533 CP=ZCTSNET_54 CDN=HFSNET_42 QN=n121
+ VDD=VDD VSS=VSS
Xbank_a_reg_3__3__5_ dfcrn2 $PINS D=n532 CP=ZCTSNET_54 CDN=HFSNET_42 QN=n122
+ VDD=VDD VSS=VSS
Xbank_a_reg_3__3__4_ dfcrn2 $PINS D=n531 CP=ZCTSNET_54 CDN=HFSNET_42 QN=n123
+ VDD=VDD VSS=VSS
Xbank_a_reg_3__3__3_ dfcrn2 $PINS D=n530 CP=ZCTSNET_54 CDN=HFSNET_42 QN=n124
+ VDD=VDD VSS=VSS
Xbank_a_reg_3__3__2_ dfcrn2 $PINS D=n529 CP=ZCTSNET_54 CDN=HFSNET_42 QN=n125
+ VDD=VDD VSS=VSS
Xbank_a_reg_3__3__1_ dfcrn2 $PINS D=n528 CP=ZCTSNET_54 CDN=HFSNET_42 QN=n126
+ VDD=VDD VSS=VSS
Xbank_a_reg_3__3__0_ dfcrn2 $PINS D=n527 CP=ZCTSNET_54 CDN=HFSNET_42 QN=n127
+ VDD=VDD VSS=VSS
Xbank_a_reg_3__2__7_ dfcrn2 $PINS D=n526 CP=ZCTSNET_55 CDN=HFSNET_42 QN=n128
+ VDD=VDD VSS=VSS
Xbank_a_reg_3__2__6_ dfcrn2 $PINS D=n525 CP=ZCTSNET_55 CDN=HFSNET_44 QN=n129
+ VDD=VDD VSS=VSS
Xbank_a_reg_3__2__5_ dfcrn2 $PINS D=n524 CP=ZCTSNET_55 CDN=HFSNET_39 QN=n130
+ VDD=VDD VSS=VSS
Xbank_a_reg_3__2__4_ dfcrn2 $PINS D=n523 CP=ZCTSNET_55 CDN=HFSNET_42 QN=n131
+ VDD=VDD VSS=VSS
Xbank_a_reg_3__2__3_ dfcrn2 $PINS D=n522 CP=ZCTSNET_55 CDN=HFSNET_44 QN=n132
+ VDD=VDD VSS=VSS
Xbank_a_reg_3__2__2_ dfcrn2 $PINS D=n521 CP=ZCTSNET_55 CDN=HFSNET_39 QN=n133
+ VDD=VDD VSS=VSS
Xbank_a_reg_3__2__1_ dfcrn2 $PINS D=n520 CP=ZCTSNET_0 CDN=HFSNET_39 QN=n134
+ VDD=VDD VSS=VSS
Xbank_a_reg_3__2__0_ dfcrn2 $PINS D=n519 CP=ZCTSNET_55 CDN=HFSNET_44 QN=n135
+ VDD=VDD VSS=VSS
Xbank_a_reg_3__1__7_ dfcrn2 $PINS D=n518 CP=ZCTSNET_0 CDN=HFSNET_39 QN=n136
+ VDD=VDD VSS=VSS
Xbank_a_reg_3__1__6_ dfcrn2 $PINS D=n517 CP=ZCTSNET_0 CDN=HFSNET_39 QN=n137
+ VDD=VDD VSS=VSS
Xbank_a_reg_3__1__5_ dfcrn2 $PINS D=n516 CP=ZCTSNET_0 CDN=HFSNET_39 QN=n138
+ VDD=VDD VSS=VSS
Xbank_a_reg_3__1__4_ dfcrn2 $PINS D=n515 CP=ZCTSNET_0 CDN=HFSNET_44 QN=n139
+ VDD=VDD VSS=VSS
Xbank_a_reg_3__1__3_ dfcrn2 $PINS D=n514 CP=ZCTSNET_0 CDN=HFSNET_44 QN=n140
+ VDD=VDD VSS=VSS
Xbank_a_reg_3__1__2_ dfcrn2 $PINS D=n513 CP=ZCTSNET_0 CDN=HFSNET_47 QN=n141
+ VDD=VDD VSS=VSS
Xbank_a_reg_3__1__1_ dfcrn2 $PINS D=n512 CP=ZCTSNET_0 CDN=HFSNET_38 QN=n142
+ VDD=VDD VSS=VSS
Xbank_a_reg_3__1__0_ dfcrn2 $PINS D=n511 CP=ZCTSNET_0 CDN=HFSNET_44 QN=n143
+ VDD=VDD VSS=VSS
Xbank_a_reg_3__0__7_ dfcrn2 $PINS D=n510 CP=ZCTSNET_0 CDN=HFSNET_38 QN=n144
+ VDD=VDD VSS=VSS
Xbank_a_reg_3__0__6_ dfcrn2 $PINS D=n509 CP=ZCTSNET_0 CDN=HFSNET_44 QN=n145
+ VDD=VDD VSS=VSS
Xbank_a_reg_3__0__5_ dfcrn2 $PINS D=n508 CP=ZCTSNET_5 CDN=HFSNET_41 QN=n146
+ VDD=VDD VSS=VSS
Xbank_a_reg_3__0__4_ dfcrn2 $PINS D=n507 CP=ZCTSNET_5 CDN=HFSNET_41 QN=n147
+ VDD=VDD VSS=VSS
Xbank_a_reg_3__0__3_ dfcrn2 $PINS D=n506 CP=ZCTSNET_53 CDN=HFSNET_41 QN=n148
+ VDD=VDD VSS=VSS
Xbank_a_reg_3__0__2_ dfcrn2 $PINS D=n505 CP=ZCTSNET_5 CDN=HFSNET_44 QN=n149
+ VDD=VDD VSS=VSS
Xbank_a_reg_3__0__1_ dfcrn2 $PINS D=n504 CP=ZCTSNET_6 CDN=HFSNET_42 QN=n150
+ VDD=VDD VSS=VSS
Xbank_a_reg_2__0__0_ dfcrn2 $PINS D=n567 CP=ZCTSNET_4 CDN=HFSNET_41 QN=n183
+ VDD=VDD VSS=VSS
Xbank_a_reg_2__3__7_ dfcrn2 $PINS D=n566 CP=ZCTSNET_55 CDN=HFSNET_39 QN=n152
+ VDD=VDD VSS=VSS
Xbank_a_reg_2__3__6_ dfcrn2 $PINS D=n565 CP=ZCTSNET_5 CDN=HFSNET_41 QN=n153
+ VDD=VDD VSS=VSS
Xbank_a_reg_2__3__5_ dfcrn2 $PINS D=n564 CP=ZCTSNET_5 CDN=HFSNET_41 QN=n154
+ VDD=VDD VSS=VSS
Xbank_a_reg_2__3__4_ dfcrn2 $PINS D=n563 CP=ZCTSNET_5 CDN=HFSNET_41 QN=n155
+ VDD=VDD VSS=VSS
Xbank_a_reg_2__3__3_ dfcrn2 $PINS D=n562 CP=ZCTSNET_4 CDN=HFSNET_41 QN=n156
+ VDD=VDD VSS=VSS
Xbank_a_reg_2__3__2_ dfcrn2 $PINS D=n561 CP=ZCTSNET_53 CDN=HFSNET_44 QN=n157
+ VDD=VDD VSS=VSS
Xbank_a_reg_2__3__1_ dfcrn2 $PINS D=n560 CP=ZCTSNET_5 CDN=HFSNET_41 QN=n158
+ VDD=VDD VSS=VSS
Xbank_a_reg_2__3__0_ dfcrn2 $PINS D=n559 CP=ZCTSNET_2 CDN=HFSNET_45 QN=n159
+ VDD=VDD VSS=VSS
Xbank_a_reg_2__2__7_ dfcrn2 $PINS D=n558 CP=ZCTSNET_5 CDN=HFSNET_41 QN=n160
+ VDD=VDD VSS=VSS
Xbank_a_reg_2__2__6_ dfcrn2 $PINS D=n557 CP=ZCTSNET_53 CDN=HFSNET_44 QN=n161
+ VDD=VDD VSS=VSS
Xbank_a_reg_2__2__5_ dfcrn2 $PINS D=n556 CP=ZCTSNET_53 CDN=HFSNET_44 QN=n162
+ VDD=VDD VSS=VSS
Xbank_a_reg_2__2__4_ dfcrn2 $PINS D=n555 CP=ZCTSNET_5 CDN=HFSNET_41 QN=n163
+ VDD=VDD VSS=VSS
Xbank_a_reg_2__2__3_ dfcrn2 $PINS D=n554 CP=ZCTSNET_53 CDN=HFSNET_47 QN=n164
+ VDD=VDD VSS=VSS
Xbank_a_reg_2__2__2_ dfcrn2 $PINS D=n553 CP=ZCTSNET_53 CDN=HFSNET_44 QN=n165
+ VDD=VDD VSS=VSS
Xbank_a_reg_2__2__1_ dfcrn2 $PINS D=n552 CP=ZCTSNET_0 CDN=HFSNET_38 QN=n166
+ VDD=VDD VSS=VSS
Xbank_a_reg_2__2__0_ dfcrn2 $PINS D=n551 CP=ZCTSNET_53 CDN=HFSNET_44 QN=n167
+ VDD=VDD VSS=VSS
Xbank_a_reg_2__1__7_ dfcrn2 $PINS D=n550 CP=ZCTSNET_0 CDN=HFSNET_38 QN=n168
+ VDD=VDD VSS=VSS
Xbank_a_reg_2__1__6_ dfcrn2 $PINS D=n549 CP=ZCTSNET_0 CDN=HFSNET_39 QN=n169
+ VDD=VDD VSS=VSS
Xbank_a_reg_2__1__5_ dfcrn1 $PINS D=n548 CP=ZCTSNET_54 CDN=HFSNET_42 QN=n170
+ VDD=VDD VSS=VSS
Xbank_a_reg_2__1__4_ dfcrn2 $PINS D=n547 CP=ZCTSNET_0 CDN=HFSNET_38 QN=n171
+ VDD=VDD VSS=VSS
Xbank_a_reg_2__1__3_ dfcrn2 $PINS D=n546 CP=ZCTSNET_0 CDN=HFSNET_39 QN=n172
+ VDD=VDD VSS=VSS
Xbank_a_reg_2__1__2_ dfcrn2 $PINS D=n545 CP=ZCTSNET_53 CDN=HFSNET_42 QN=n173
+ VDD=VDD VSS=VSS
Xbank_a_reg_2__1__1_ dfcrn2 $PINS D=n544 CP=ZCTSNET_0 CDN=HFSNET_38 QN=n174
+ VDD=VDD VSS=VSS
Xbank_a_reg_2__1__0_ dfcrn2 $PINS D=n543 CP=ZCTSNET_0 CDN=HFSNET_38 QN=n175
+ VDD=VDD VSS=VSS
Xbank_a_reg_2__0__7_ dfcrn2 $PINS D=n542 CP=ZCTSNET_0 CDN=HFSNET_39 QN=n176
+ VDD=VDD VSS=VSS
Xbank_a_reg_2__0__6_ dfcrn2 $PINS D=n541 CP=ZCTSNET_53 CDN=HFSNET_42 QN=n177
+ VDD=VDD VSS=VSS
Xbank_a_reg_2__0__5_ dfcrn2 $PINS D=n540 CP=ZCTSNET_4 CDN=HFSNET_40 QN=n178
+ VDD=VDD VSS=VSS
Xbank_a_reg_2__0__4_ dfcrn2 $PINS D=n539 CP=ZCTSNET_4 CDN=HFSNET_40 QN=n179
+ VDD=VDD VSS=VSS
Xbank_a_reg_2__0__3_ dfcrn2 $PINS D=n538 CP=ZCTSNET_0 CDN=HFSNET_47 QN=n180
+ VDD=VDD VSS=VSS
Xbank_a_reg_2__0__2_ dfcrn2 $PINS D=n537 CP=ZCTSNET_4 CDN=HFSNET_41 QN=n181
+ VDD=VDD VSS=VSS
Xbank_a_reg_2__0__1_ dfcrn2 $PINS D=n536 CP=ZCTSNET_4 CDN=HFSNET_41 QN=n182
+ VDD=VDD VSS=VSS
Xbank_a_reg_1__0__0_ dfcrn2 $PINS D=n599 CP=ZCTSNET_2 CDN=HFSNET_46 QN=n215
+ VDD=VDD VSS=VSS
Xbank_a_reg_1__3__7_ dfcrn2 $PINS D=n598 CP=ZCTSNET_2 CDN=HFSNET_45 QN=n184
+ VDD=VDD VSS=VSS
Xbank_a_reg_1__3__6_ dfcrn2 $PINS D=n597 CP=ZCTSNET_4 CDN=HFSNET_40 QN=n185
+ VDD=VDD VSS=VSS
Xbank_a_reg_1__3__5_ dfcrn2 $PINS D=n596 CP=ZCTSNET_4 CDN=HFSNET_40 QN=n186
+ VDD=VDD VSS=VSS
Xbank_a_reg_1__3__4_ dfcrn2 $PINS D=n595 CP=ZCTSNET_0 CDN=HFSNET_47 QN=n187
+ VDD=VDD VSS=VSS
Xbank_a_reg_1__3__3_ dfcrn2 $PINS D=n594 CP=ZCTSNET_4 CDN=HFSNET_41 QN=n188
+ VDD=VDD VSS=VSS
Xbank_a_reg_1__3__2_ dfcrn2 $PINS D=n593 CP=ZCTSNET_2 CDN=HFSNET_45 QN=n189
+ VDD=VDD VSS=VSS
Xbank_a_reg_1__3__1_ dfcrn2 $PINS D=n592 CP=ZCTSNET_2 CDN=HFSNET_45 QN=n190
+ VDD=VDD VSS=VSS
Xbank_a_reg_1__3__0_ dfcrn2 $PINS D=n591 CP=ZCTSNET_4 CDN=HFSNET_40 QN=n191
+ VDD=VDD VSS=VSS
Xbank_a_reg_1__2__7_ dfcrn2 $PINS D=n590 CP=ZCTSNET_2 CDN=HFSNET_45 QN=n192
+ VDD=VDD VSS=VSS
Xbank_a_reg_1__2__6_ dfcrn2 $PINS D=n589 CP=ZCTSNET_4 CDN=HFSNET_45 QN=n193
+ VDD=VDD VSS=VSS
Xbank_a_reg_1__2__5_ dfcrn2 $PINS D=n588 CP=ZCTSNET_2 CDN=HFSNET_46 QN=n194
+ VDD=VDD VSS=VSS
Xbank_a_reg_1__2__4_ dfcrn2 $PINS D=n587 CP=ZCTSNET_2 CDN=HFSNET_45 QN=n195
+ VDD=VDD VSS=VSS
Xbank_a_reg_1__2__3_ dfcrn2 $PINS D=n586 CP=ZCTSNET_2 CDN=HFSNET_45 QN=n196
+ VDD=VDD VSS=VSS
Xbank_a_reg_1__2__2_ dfcrn2 $PINS D=n585 CP=ZCTSNET_2 CDN=HFSNET_46 QN=n197
+ VDD=VDD VSS=VSS
Xbank_a_reg_1__2__1_ dfcrn2 $PINS D=n584 CP=ZCTSNET_2 CDN=HFSNET_46 QN=n198
+ VDD=VDD VSS=VSS
Xbank_a_reg_1__2__0_ dfcrn2 $PINS D=n583 CP=ZCTSNET_2 CDN=HFSNET_46 QN=n199
+ VDD=VDD VSS=VSS
Xbank_a_reg_1__1__7_ dfcrn2 $PINS D=n582 CP=ZCTSNET_2 CDN=HFSNET_46 QN=n200
+ VDD=VDD VSS=VSS
Xbank_a_reg_1__1__6_ dfcrn2 $PINS D=n581 CP=ZCTSNET_2 CDN=HFSNET_46 QN=n201
+ VDD=VDD VSS=VSS
Xbank_a_reg_1__1__5_ dfcrn2 $PINS D=n580 CP=ZCTSNET_2 CDN=HFSNET_46 QN=n202
+ VDD=VDD VSS=VSS
Xbank_a_reg_1__1__4_ dfcrn2 $PINS D=n579 CP=ZCTSNET_2 CDN=HFSNET_46 QN=n203
+ VDD=VDD VSS=VSS
Xbank_a_reg_1__1__3_ dfcrn2 $PINS D=n578 CP=ZCTSNET_0 CDN=HFSNET_46 QN=n204
+ VDD=VDD VSS=VSS
Xbank_a_reg_1__1__2_ dfcrn2 $PINS D=n577 CP=ZCTSNET_2 CDN=HFSNET_46 QN=n205
+ VDD=VDD VSS=VSS
Xbank_a_reg_1__1__1_ dfcrn2 $PINS D=n576 CP=ZCTSNET_0 CDN=HFSNET_46 QN=n206
+ VDD=VDD VSS=VSS
Xbank_a_reg_1__1__0_ dfcrn2 $PINS D=n575 CP=ZCTSNET_0 CDN=HFSNET_46 QN=n207
+ VDD=VDD VSS=VSS
Xbank_a_reg_1__0__7_ dfcrn2 $PINS D=n574 CP=ZCTSNET_0 CDN=HFSNET_47 QN=n208
+ VDD=VDD VSS=VSS
Xbank_a_reg_1__0__6_ dfcrn2 $PINS D=n573 CP=ZCTSNET_0 CDN=HFSNET_44 QN=n209
+ VDD=VDD VSS=VSS
Xbank_a_reg_1__0__5_ dfcrn2 $PINS D=n572 CP=ZCTSNET_0 CDN=HFSNET_47 QN=n210
+ VDD=VDD VSS=VSS
Xbank_a_reg_1__0__4_ dfcrn2 $PINS D=n571 CP=ZCTSNET_0 CDN=HFSNET_38 QN=n211
+ VDD=VDD VSS=VSS
Xbank_a_reg_1__0__3_ dfcrn2 $PINS D=n570 CP=ZCTSNET_0 CDN=HFSNET_47 QN=n212
+ VDD=VDD VSS=VSS
Xbank_a_reg_1__0__2_ dfcrn2 $PINS D=n569 CP=ZCTSNET_0 CDN=HFSNET_44 QN=n213
+ VDD=VDD VSS=VSS
Xbank_a_reg_1__0__1_ dfcrn2 $PINS D=n568 CP=ZCTSNET_0 CDN=HFSNET_47 QN=n214
+ VDD=VDD VSS=VSS
Xbank_a_reg_0__0__0_ dfcrn2 $PINS D=n631 CP=ZCTSNET_0 CDN=HFSNET_38 QN=n247
+ VDD=VDD VSS=VSS
Xbank_a_reg_0__3__7_ dfcrn2 $PINS D=n630 CP=ZCTSNET_4 CDN=HFSNET_47 QN=n216
+ VDD=VDD VSS=VSS
Xbank_a_reg_0__3__6_ dfcrn2 $PINS D=n629 CP=ZCTSNET_4 CDN=HFSNET_40 QN=n217
+ VDD=VDD VSS=VSS
Xbank_a_reg_0__3__5_ dfcrn2 $PINS D=n628 CP=ZCTSNET_53 CDN=HFSNET_44 QN=n218
+ VDD=VDD VSS=VSS
Xbank_a_reg_0__3__4_ dfcrn2 $PINS D=n627 CP=ZCTSNET_0 CDN=HFSNET_47 QN=n219
+ VDD=VDD VSS=VSS
Xbank_a_reg_0__3__3_ dfcrn2 $PINS D=n626 CP=ZCTSNET_4 CDN=HFSNET_41 QN=n220
+ VDD=VDD VSS=VSS
Xbank_a_reg_0__3__2_ dfcrn2 $PINS D=n625 CP=ZCTSNET_4 CDN=HFSNET_40 QN=n221
+ VDD=VDD VSS=VSS
Xbank_a_reg_0__3__1_ dfcrn2 $PINS D=n624 CP=ZCTSNET_53 CDN=HFSNET_44 QN=n222
+ VDD=VDD VSS=VSS
Xbank_a_reg_0__3__0_ dfcrn2 $PINS D=n623 CP=ZCTSNET_2 CDN=HFSNET_47 QN=n223
+ VDD=VDD VSS=VSS
Xbank_a_reg_0__2__7_ dfcrn2 $PINS D=n622 CP=ZCTSNET_4 CDN=HFSNET_40 QN=n224
+ VDD=VDD VSS=VSS
Xbank_a_reg_0__2__6_ dfcrn2 $PINS D=n621 CP=ZCTSNET_4 CDN=HFSNET_41 QN=n225
+ VDD=VDD VSS=VSS
Xbank_a_reg_0__2__5_ dfcrn2 $PINS D=n620 CP=ZCTSNET_4 CDN=HFSNET_47 QN=n226
+ VDD=VDD VSS=VSS
Xbank_a_reg_0__2__4_ dfcrn2 $PINS D=n619 CP=ZCTSNET_4 CDN=HFSNET_47 QN=n227
+ VDD=VDD VSS=VSS
Xbank_a_reg_0__2__3_ dfcrn2 $PINS D=n618 CP=ZCTSNET_2 CDN=HFSNET_40 QN=n228
+ VDD=VDD VSS=VSS
Xbank_a_reg_0__2__2_ dfcrn2 $PINS D=n617 CP=ZCTSNET_2 CDN=HFSNET_45 QN=n229
+ VDD=VDD VSS=VSS
Xbank_a_reg_0__2__1_ dfcrn2 $PINS D=n616 CP=ZCTSNET_0 CDN=HFSNET_47 QN=n230
+ VDD=VDD VSS=VSS
Xbank_a_reg_0__2__0_ dfcrn2 $PINS D=n615 CP=ZCTSNET_2 CDN=HFSNET_47 QN=n231
+ VDD=VDD VSS=VSS
Xbank_a_reg_0__1__7_ dfcrn2 $PINS D=n614 CP=ZCTSNET_0 CDN=HFSNET_47 QN=n232
+ VDD=VDD VSS=VSS
Xbank_a_reg_0__1__6_ dfcrn2 $PINS D=n613 CP=ZCTSNET_2 CDN=HFSNET_40 QN=n233
+ VDD=VDD VSS=VSS
Xbank_a_reg_0__1__5_ dfcrn2 $PINS D=n612 CP=ZCTSNET_0 CDN=HFSNET_38 QN=n234
+ VDD=VDD VSS=VSS
Xbank_a_reg_0__1__4_ dfcrn2 $PINS D=n611 CP=ZCTSNET_4 CDN=HFSNET_40 QN=n235
+ VDD=VDD VSS=VSS
Xbank_a_reg_0__1__3_ dfcrn2 $PINS D=n610 CP=ZCTSNET_0 CDN=HFSNET_47 QN=n236
+ VDD=VDD VSS=VSS
Xbank_a_reg_0__1__2_ dfcrn2 $PINS D=n609 CP=ZCTSNET_0 CDN=HFSNET_47 QN=n237
+ VDD=VDD VSS=VSS
Xbank_a_reg_0__1__1_ dfcrn2 $PINS D=n608 CP=ZCTSNET_0 CDN=HFSNET_47 QN=n238
+ VDD=VDD VSS=VSS
Xbank_a_reg_0__1__0_ dfcrn2 $PINS D=n607 CP=ZCTSNET_2 CDN=HFSNET_40 QN=n239
+ VDD=VDD VSS=VSS
Xbank_a_reg_0__0__7_ dfcrn2 $PINS D=n606 CP=ZCTSNET_0 CDN=HFSNET_47 QN=n240
+ VDD=VDD VSS=VSS
Xbank_a_reg_0__0__6_ dfcrn2 $PINS D=n605 CP=ZCTSNET_0 CDN=HFSNET_47 QN=n241
+ VDD=VDD VSS=VSS
Xbank_a_reg_0__0__5_ dfcrn2 $PINS D=n604 CP=ZCTSNET_0 CDN=HFSNET_47 QN=n242
+ VDD=VDD VSS=VSS
Xbank_a_reg_0__0__4_ dfcrn2 $PINS D=n603 CP=ZCTSNET_0 CDN=HFSNET_47 QN=n243
+ VDD=VDD VSS=VSS
Xbank_a_reg_0__0__3_ dfcrn2 $PINS D=n602 CP=ZCTSNET_0 CDN=HFSNET_47 QN=n244
+ VDD=VDD VSS=VSS
Xbank_a_reg_0__0__2_ dfcrn2 $PINS D=n601 CP=ZCTSNET_0 CDN=HFSNET_47 QN=n245
+ VDD=VDD VSS=VSS
Xbank_a_reg_0__0__1_ dfcrn2 $PINS D=n600 CP=ZCTSNET_4 CDN=HFSNET_47 QN=n246
+ VDD=VDD VSS=VSS
XZCTSBUF_106140_2566 buffda $PINS I=ZCTSNET_0 Z=ZCTSNET_2 VDD=VDD VSS=VSS
XU5 oai22d2 $PINS A1=n750 A2=n752 B1=n31 B2=copt_net_1117 ZN=n113 VDD=VDD
+ VSS=VSS
XU6 aor22d1 $PINS A1=n31 A2=load_m[1] B1=n750 B2=copt_net_1442 Z=n114 VDD=VDD
+ VSS=VSS
XU7 aor22d1 $PINS A1=n31 A2=load_m[2] B1=n750 B2=copt_net_1964 Z=n115 VDD=VDD
+ VSS=VSS
XU8 aor22d1 $PINS A1=n31 A2=load_k[0] B1=n750 B2=copt_net_1550 Z=n116 VDD=VDD
+ VSS=VSS
XU9 aor22d1 $PINS A1=n31 A2=load_k[1] B1=n750 B2=copt_net_1722 Z=n117 VDD=VDD
+ VSS=VSS
XU10 aor22d1 $PINS A1=n31 A2=load_k[2] B1=n750 B2=copt_net_1048 Z=n118 VDD=VDD
+ VSS=VSS
XU11 oaim21d1 $PINS B1=load_done_gOb7 B2=HFSNET_36 A=n34 ZN=n119 VDD=VDD
+ VSS=VSS
XU12 oai22d1 $PINS A1=copt_net_366 A2=n2 B1=HFSNET_16 B2=n37 ZN=n376 VDD=VDD
+ VSS=VSS
XU13 oai22d1 $PINS A1=copt_net_376 A2=n2 B1=HFSNET_16 B2=n38 ZN=n377 VDD=VDD
+ VSS=VSS
XU14 oai22d1 $PINS A1=copt_net_411 A2=n2 B1=HFSNET_16 B2=n39 ZN=n378 VDD=VDD
+ VSS=VSS
XU15 oai22d1 $PINS A1=copt_net_373 A2=n2 B1=HFSNET_16 B2=n40 ZN=n379 VDD=VDD
+ VSS=VSS
XU16 oai22d1 $PINS A1=copt_net_374 A2=n2 B1=HFSNET_16 B2=n41 ZN=n380 VDD=VDD
+ VSS=VSS
XU17 oai22d1 $PINS A1=copt_net_463 A2=n2 B1=HFSNET_16 B2=n42 ZN=n381 VDD=VDD
+ VSS=VSS
XU18 oai22d1 $PINS A1=copt_net_392 A2=n2 B1=HFSNET_16 B2=n43 ZN=n382 VDD=VDD
+ VSS=VSS
XU19 oai22d1 $PINS A1=copt_net_441 A2=n2 B1=HFSNET_16 B2=n44 ZN=n383 VDD=VDD
+ VSS=VSS
XU20 oai22d1 $PINS A1=copt_net_380 A2=n2 B1=HFSNET_16 B2=n45 ZN=n384 VDD=VDD
+ VSS=VSS
XU21 oai22d1 $PINS A1=copt_net_495 A2=n2 B1=HFSNET_16 B2=n46 ZN=n385 VDD=VDD
+ VSS=VSS
XU22 oai22d1 $PINS A1=copt_net_400 A2=n2 B1=HFSNET_16 B2=n47 ZN=n386 VDD=VDD
+ VSS=VSS
XU23 oai22d1 $PINS A1=copt_net_384 A2=n2 B1=HFSNET_16 B2=n48 ZN=n387 VDD=VDD
+ VSS=VSS
XU24 oai22d1 $PINS A1=copt_net_494 A2=n2 B1=HFSNET_16 B2=n49 ZN=n388 VDD=VDD
+ VSS=VSS
XU25 oai22d1 $PINS A1=copt_net_511 A2=n2 B1=HFSNET_16 B2=n50 ZN=n389 VDD=VDD
+ VSS=VSS
XU26 oai22d1 $PINS A1=copt_net_445 A2=n2 B1=HFSNET_16 B2=n51 ZN=n390 VDD=VDD
+ VSS=VSS
XU27 oai22d1 $PINS A1=copt_net_459 A2=n2 B1=HFSNET_16 B2=n52 ZN=n391 VDD=VDD
+ VSS=VSS
XU28 oai22d1 $PINS A1=copt_net_455 A2=n2 B1=HFSNET_16 B2=n53 ZN=n392 VDD=VDD
+ VSS=VSS
XU29 oai22d1 $PINS A1=copt_net_454 A2=n2 B1=HFSNET_16 B2=n54 ZN=n393 VDD=VDD
+ VSS=VSS
XU30 oai22d1 $PINS A1=copt_net_464 A2=n2 B1=HFSNET_16 B2=n55 ZN=n394 VDD=VDD
+ VSS=VSS
XU31 oai22d1 $PINS A1=copt_net_410 A2=n2 B1=HFSNET_16 B2=n56 ZN=n395 VDD=VDD
+ VSS=VSS
XU32 oai22d1 $PINS A1=copt_net_361 A2=n2 B1=HFSNET_16 B2=n57 ZN=n396 VDD=VDD
+ VSS=VSS
XU33 oai22d1 $PINS A1=copt_net_551 A2=n2 B1=HFSNET_16 B2=n58 ZN=n397 VDD=VDD
+ VSS=VSS
XU34 oai22d1 $PINS A1=copt_net_423 A2=n2 B1=HFSNET_16 B2=n59 ZN=n398 VDD=VDD
+ VSS=VSS
XU35 oai22d1 $PINS A1=copt_net_370 A2=n2 B1=HFSNET_16 B2=n60 ZN=n399 VDD=VDD
+ VSS=VSS
XU36 oai22d1 $PINS A1=copt_net_635 A2=n2 B1=HFSNET_16 B2=n61 ZN=n400 VDD=VDD
+ VSS=VSS
XU37 oai22d1 $PINS A1=copt_net_367 A2=n2 B1=HFSNET_16 B2=n62 ZN=n401 VDD=VDD
+ VSS=VSS
XU38 oai22d1 $PINS A1=copt_net_369 A2=n2 B1=HFSNET_16 B2=n63 ZN=n402 VDD=VDD
+ VSS=VSS
XU39 oai22d1 $PINS A1=copt_net_425 A2=n2 B1=HFSNET_16 B2=n64 ZN=n403 VDD=VDD
+ VSS=VSS
XU40 oai22d1 $PINS A1=copt_net_568 A2=n2 B1=HFSNET_16 B2=n65 ZN=n404 VDD=VDD
+ VSS=VSS
XU41 oai22d1 $PINS A1=copt_net_887 A2=n2 B1=HFSNET_16 B2=n66 ZN=n405 VDD=VDD
+ VSS=VSS
XU42 oai22d1 $PINS A1=copt_net_418 A2=n2 B1=HFSNET_16 B2=n67 ZN=n406 VDD=VDD
+ VSS=VSS
XU43 oai22d1 $PINS A1=copt_net_437 A2=n2 B1=HFSNET_16 B2=n68 ZN=n407 VDD=VDD
+ VSS=VSS
XU46 oai22d1 $PINS A1=copt_net_503 A2=HFSNET_26 B1=n37 B2=n73 ZN=n408 VDD=VDD
+ VSS=VSS
XU47 oai22d1 $PINS A1=copt_net_483 A2=HFSNET_26 B1=n38 B2=n73 ZN=n409 VDD=VDD
+ VSS=VSS
XU48 oai22d1 $PINS A1=copt_net_489 A2=HFSNET_26 B1=n39 B2=n73 ZN=n410 VDD=VDD
+ VSS=VSS
XU49 oai22d1 $PINS A1=copt_net_436 A2=HFSNET_26 B1=n40 B2=n73 ZN=n411 VDD=VDD
+ VSS=VSS
XU50 oai22d1 $PINS A1=copt_net_523 A2=HFSNET_26 B1=n41 B2=n73 ZN=n412 VDD=VDD
+ VSS=VSS
XU51 oai22d1 $PINS A1=copt_net_404 A2=HFSNET_26 B1=n42 B2=n73 ZN=n413 VDD=VDD
+ VSS=VSS
XU52 oai22d1 $PINS A1=copt_net_597 A2=HFSNET_26 B1=n43 B2=n73 ZN=n414 VDD=VDD
+ VSS=VSS
XU53 oai22d1 $PINS A1=copt_net_554 A2=HFSNET_26 B1=n44 B2=n73 ZN=n415 VDD=VDD
+ VSS=VSS
XU54 oai22d1 $PINS A1=copt_net_566 A2=HFSNET_26 B1=n45 B2=n73 ZN=n416 VDD=VDD
+ VSS=VSS
XU55 oai22d1 $PINS A1=copt_net_415 A2=HFSNET_26 B1=n46 B2=n73 ZN=n417 VDD=VDD
+ VSS=VSS
XU56 oai22d1 $PINS A1=copt_net_576 A2=HFSNET_26 B1=n47 B2=n73 ZN=n418 VDD=VDD
+ VSS=VSS
XU57 oai22d1 $PINS A1=copt_net_559 A2=HFSNET_26 B1=n48 B2=n73 ZN=n419 VDD=VDD
+ VSS=VSS
XU58 oai22d1 $PINS A1=copt_net_567 A2=HFSNET_26 B1=n49 B2=n73 ZN=n420 VDD=VDD
+ VSS=VSS
XU59 oai22d1 $PINS A1=copt_net_492 A2=HFSNET_26 B1=n50 B2=n73 ZN=n421 VDD=VDD
+ VSS=VSS
XU60 oai22d1 $PINS A1=copt_net_573 A2=HFSNET_26 B1=n51 B2=n73 ZN=n422 VDD=VDD
+ VSS=VSS
XU61 oai22d1 $PINS A1=copt_net_493 A2=HFSNET_26 B1=n52 B2=n73 ZN=n423 VDD=VDD
+ VSS=VSS
XU62 oai22d1 $PINS A1=copt_net_585 A2=HFSNET_26 B1=n53 B2=n73 ZN=n424 VDD=VDD
+ VSS=VSS
XU63 oai22d1 $PINS A1=copt_net_528 A2=HFSNET_26 B1=n54 B2=n73 ZN=n425 VDD=VDD
+ VSS=VSS
XU64 oai22d1 $PINS A1=copt_net_466 A2=HFSNET_26 B1=n55 B2=n73 ZN=n426 VDD=VDD
+ VSS=VSS
XU65 oai22d1 $PINS A1=copt_net_396 A2=HFSNET_26 B1=n56 B2=n73 ZN=n427 VDD=VDD
+ VSS=VSS
XU66 oai22d1 $PINS A1=copt_net_480 A2=HFSNET_26 B1=n57 B2=n73 ZN=n428 VDD=VDD
+ VSS=VSS
XU67 oai22d1 $PINS A1=copt_net_433 A2=HFSNET_26 B1=n58 B2=n73 ZN=n429 VDD=VDD
+ VSS=VSS
XU68 oai22d1 $PINS A1=copt_net_397 A2=HFSNET_26 B1=n59 B2=n73 ZN=n430 VDD=VDD
+ VSS=VSS
XU69 oai22d1 $PINS A1=copt_net_426 A2=HFSNET_26 B1=n60 B2=n73 ZN=n431 VDD=VDD
+ VSS=VSS
XU70 oai22d1 $PINS A1=copt_net_684 A2=HFSNET_26 B1=n61 B2=n73 ZN=n432 VDD=VDD
+ VSS=VSS
XU71 oai22d1 $PINS A1=copt_net_467 A2=HFSNET_26 B1=n62 B2=n73 ZN=n433 VDD=VDD
+ VSS=VSS
XU72 oai22d1 $PINS A1=copt_net_606 A2=HFSNET_26 B1=n63 B2=n73 ZN=n434 VDD=VDD
+ VSS=VSS
XU73 oai22d1 $PINS A1=copt_net_444 A2=HFSNET_26 B1=n64 B2=n73 ZN=n435 VDD=VDD
+ VSS=VSS
XU74 oai22d1 $PINS A1=copt_net_533 A2=HFSNET_26 B1=n65 B2=n73 ZN=n436 VDD=VDD
+ VSS=VSS
XU75 oai22d1 $PINS A1=copt_net_876 A2=HFSNET_26 B1=n66 B2=n73 ZN=n437 VDD=VDD
+ VSS=VSS
XU76 oai22d1 $PINS A1=copt_net_442 A2=HFSNET_26 B1=n67 B2=n73 ZN=n438 VDD=VDD
+ VSS=VSS
XU77 oai22d1 $PINS A1=copt_net_440 A2=HFSNET_26 B1=n68 B2=n73 ZN=n439 VDD=VDD
+ VSS=VSS
XU80 oai22d1 $PINS A1=copt_net_520 A2=HFSNET_24 B1=n37 B2=n76 ZN=n440 VDD=VDD
+ VSS=VSS
XU81 oai22d1 $PINS A1=copt_net_447 A2=HFSNET_24 B1=n38 B2=n76 ZN=n441 VDD=VDD
+ VSS=VSS
XU82 oai22d1 $PINS A1=copt_net_516 A2=HFSNET_24 B1=n39 B2=n76 ZN=n442 VDD=VDD
+ VSS=VSS
XU83 oai22d1 $PINS A1=copt_net_541 A2=HFSNET_24 B1=n40 B2=n76 ZN=n443 VDD=VDD
+ VSS=VSS
XU84 oai22d1 $PINS A1=copt_net_451 A2=HFSNET_24 B1=n41 B2=n76 ZN=n444 VDD=VDD
+ VSS=VSS
XU85 oai22d1 $PINS A1=copt_net_504 A2=HFSNET_24 B1=n42 B2=n76 ZN=n445 VDD=VDD
+ VSS=VSS
XU86 oai22d1 $PINS A1=copt_net_473 A2=HFSNET_24 B1=n43 B2=n76 ZN=n446 VDD=VDD
+ VSS=VSS
XU87 oai22d1 $PINS A1=copt_net_421 A2=HFSNET_24 B1=n44 B2=n76 ZN=n447 VDD=VDD
+ VSS=VSS
XU88 oai22d1 $PINS A1=copt_net_372 A2=HFSNET_24 B1=n45 B2=n76 ZN=n448 VDD=VDD
+ VSS=VSS
XU89 oai22d1 $PINS A1=copt_net_385 A2=HFSNET_24 B1=n46 B2=n76 ZN=n449 VDD=VDD
+ VSS=VSS
XU90 oai22d1 $PINS A1=copt_net_485 A2=HFSNET_24 B1=n47 B2=n76 ZN=n450 VDD=VDD
+ VSS=VSS
XU91 oai22d1 $PINS A1=copt_net_471 A2=HFSNET_24 B1=n48 B2=n76 ZN=n451 VDD=VDD
+ VSS=VSS
XU92 oai22d1 $PINS A1=copt_net_487 A2=HFSNET_24 B1=n49 B2=n76 ZN=n452 VDD=VDD
+ VSS=VSS
XU93 oai22d1 $PINS A1=copt_net_401 A2=HFSNET_24 B1=n50 B2=n76 ZN=n453 VDD=VDD
+ VSS=VSS
XU94 oai22d1 $PINS A1=copt_net_590 A2=HFSNET_24 B1=n51 B2=n76 ZN=n454 VDD=VDD
+ VSS=VSS
XU95 oai22d1 $PINS A1=copt_net_521 A2=HFSNET_24 B1=n52 B2=n76 ZN=n455 VDD=VDD
+ VSS=VSS
XU96 oai22d1 $PINS A1=copt_net_419 A2=HFSNET_24 B1=n53 B2=n76 ZN=n456 VDD=VDD
+ VSS=VSS
XU97 oai22d1 $PINS A1=copt_net_527 A2=HFSNET_24 B1=n54 B2=n76 ZN=n457 VDD=VDD
+ VSS=VSS
XU98 oai22d1 $PINS A1=copt_net_518 A2=HFSNET_24 B1=n55 B2=n76 ZN=n458 VDD=VDD
+ VSS=VSS
XU99 oai22d1 $PINS A1=copt_net_375 A2=HFSNET_24 B1=n56 B2=n76 ZN=n459 VDD=VDD
+ VSS=VSS
XU100 oai22d1 $PINS A1=copt_net_538 A2=HFSNET_24 B1=n57 B2=n76 ZN=n460 VDD=VDD
+ VSS=VSS
XU101 oai22d1 $PINS A1=copt_net_368 A2=HFSNET_24 B1=n58 B2=n76 ZN=n461 VDD=VDD
+ VSS=VSS
XU102 oai22d1 $PINS A1=copt_net_387 A2=HFSNET_24 B1=n59 B2=n76 ZN=n462 VDD=VDD
+ VSS=VSS
XU103 oai22d1 $PINS A1=copt_net_379 A2=HFSNET_24 B1=n60 B2=n76 ZN=n463 VDD=VDD
+ VSS=VSS
XU104 oai22d1 $PINS A1=copt_net_646 A2=HFSNET_24 B1=n61 B2=n76 ZN=n464 VDD=VDD
+ VSS=VSS
XU105 oai22d1 $PINS A1=copt_net_365 A2=HFSNET_24 B1=n62 B2=n76 ZN=n465 VDD=VDD
+ VSS=VSS
XU106 oai22d1 $PINS A1=copt_net_645 A2=HFSNET_24 B1=n63 B2=n76 ZN=n466 VDD=VDD
+ VSS=VSS
XU107 oai22d1 $PINS A1=copt_net_591 A2=HFSNET_24 B1=n64 B2=n76 ZN=n467 VDD=VDD
+ VSS=VSS
XU108 oai22d1 $PINS A1=copt_net_561 A2=HFSNET_24 B1=n65 B2=n76 ZN=n468 VDD=VDD
+ VSS=VSS
XU109 oai22d1 $PINS A1=copt_net_880 A2=HFSNET_24 B1=n66 B2=n76 ZN=n469 VDD=VDD
+ VSS=VSS
XU110 oai22d1 $PINS A1=copt_net_525 A2=HFSNET_24 B1=n67 B2=n76 ZN=n470 VDD=VDD
+ VSS=VSS
XU111 oai22d1 $PINS A1=copt_net_592 A2=HFSNET_24 B1=n68 B2=n76 ZN=n471 VDD=VDD
+ VSS=VSS
XU114 oai22d1 $PINS A1=copt_net_721 A2=HFSNET_14 B1=n37 B2=n79 ZN=n472 VDD=VDD
+ VSS=VSS
XU115 oai22d1 $PINS A1=copt_net_578 A2=HFSNET_14 B1=n38 B2=n79 ZN=n473 VDD=VDD
+ VSS=VSS
XU116 oai22d1 $PINS A1=copt_net_558 A2=HFSNET_14 B1=n39 B2=n79 ZN=n474 VDD=VDD
+ VSS=VSS
XU117 oai22d1 $PINS A1=copt_net_589 A2=HFSNET_14 B1=n40 B2=n79 ZN=n475 VDD=VDD
+ VSS=VSS
XU118 oai22d1 $PINS A1=copt_net_560 A2=HFSNET_14 B1=n41 B2=n79 ZN=n476 VDD=VDD
+ VSS=VSS
XU119 oai22d1 $PINS A1=copt_net_472 A2=HFSNET_14 B1=n42 B2=n79 ZN=n477 VDD=VDD
+ VSS=VSS
XU120 oai22d1 $PINS A1=copt_net_596 A2=HFSNET_14 B1=n43 B2=n79 ZN=n478 VDD=VDD
+ VSS=VSS
XU121 oai22d1 $PINS A1=copt_net_626 A2=HFSNET_14 B1=n44 B2=n79 ZN=n479 VDD=VDD
+ VSS=VSS
XU122 oai22d1 $PINS A1=copt_net_562 A2=HFSNET_14 B1=n45 B2=n79 ZN=n480 VDD=VDD
+ VSS=VSS
XU123 oai22d1 $PINS A1=copt_net_569 A2=HFSNET_14 B1=n46 B2=n79 ZN=n481 VDD=VDD
+ VSS=VSS
XU124 oai22d1 $PINS A1=copt_net_545 A2=HFSNET_14 B1=n47 B2=n79 ZN=n482 VDD=VDD
+ VSS=VSS
XU125 oai22d1 $PINS A1=copt_net_389 A2=HFSNET_14 B1=n48 B2=n79 ZN=n483 VDD=VDD
+ VSS=VSS
XU126 oai22d1 $PINS A1=copt_net_543 A2=HFSNET_14 B1=n49 B2=n79 ZN=n484 VDD=VDD
+ VSS=VSS
XU127 oai22d1 $PINS A1=copt_net_398 A2=HFSNET_14 B1=n50 B2=n79 ZN=n485 VDD=VDD
+ VSS=VSS
XU128 oai22d1 $PINS A1=copt_net_600 A2=HFSNET_14 B1=n51 B2=n79 ZN=n486 VDD=VDD
+ VSS=VSS
XU129 oai22d1 $PINS A1=copt_net_481 A2=HFSNET_14 B1=n52 B2=n79 ZN=n487 VDD=VDD
+ VSS=VSS
XU130 oai22d1 $PINS A1=copt_net_537 A2=HFSNET_14 B1=n53 B2=n79 ZN=n488 VDD=VDD
+ VSS=VSS
XU131 oai22d1 $PINS A1=copt_net_529 A2=HFSNET_14 B1=n54 B2=n79 ZN=n489 VDD=VDD
+ VSS=VSS
XU132 oai22d1 $PINS A1=copt_net_517 A2=HFSNET_14 B1=n55 B2=n79 ZN=n490 VDD=VDD
+ VSS=VSS
XU133 oai22d1 $PINS A1=copt_net_512 A2=HFSNET_14 B1=n56 B2=n79 ZN=n491 VDD=VDD
+ VSS=VSS
XU134 oai22d1 $PINS A1=copt_net_363 A2=HFSNET_14 B1=n57 B2=n79 ZN=n492 VDD=VDD
+ VSS=VSS
XU135 oai22d1 $PINS A1=copt_net_501 A2=HFSNET_14 B1=n58 B2=n79 ZN=n493 VDD=VDD
+ VSS=VSS
XU136 oai22d1 $PINS A1=copt_net_413 A2=HFSNET_14 B1=n59 B2=n79 ZN=n494 VDD=VDD
+ VSS=VSS
XU137 oai22d1 $PINS A1=copt_net_431 A2=HFSNET_14 B1=n60 B2=n79 ZN=n495 VDD=VDD
+ VSS=VSS
XU138 oai22d1 $PINS A1=copt_net_714 A2=HFSNET_14 B1=n61 B2=n79 ZN=n496 VDD=VDD
+ VSS=VSS
XU139 oai22d1 $PINS A1=copt_net_402 A2=HFSNET_14 B1=n62 B2=n79 ZN=n497 VDD=VDD
+ VSS=VSS
XU140 oai22d1 $PINS A1=copt_net_686 A2=HFSNET_14 B1=n63 B2=n79 ZN=n498 VDD=VDD
+ VSS=VSS
XU141 oai22d1 $PINS A1=copt_net_408 A2=HFSNET_14 B1=n64 B2=n79 ZN=n499 VDD=VDD
+ VSS=VSS
XU142 oai22d1 $PINS A1=copt_net_579 A2=HFSNET_14 B1=n65 B2=n79 ZN=n500 VDD=VDD
+ VSS=VSS
XU143 oai22d1 $PINS A1=copt_net_930 A2=HFSNET_14 B1=n66 B2=n79 ZN=n501 VDD=VDD
+ VSS=VSS
XU144 oai22d1 $PINS A1=copt_net_427 A2=HFSNET_14 B1=n67 B2=n79 ZN=n502 VDD=VDD
+ VSS=VSS
XU145 oai22d1 $PINS A1=copt_net_570 A2=HFSNET_14 B1=n68 B2=n79 ZN=n503 VDD=VDD
+ VSS=VSS
XU149 oai22d1 $PINS A1=copt_net_508 A2=HFSNET_18 B1=n37 B2=n81 ZN=n504 VDD=VDD
+ VSS=VSS
XU150 oai22d1 $PINS A1=copt_net_409 A2=HFSNET_18 B1=n38 B2=n81 ZN=n505 VDD=VDD
+ VSS=VSS
XU151 oai22d1 $PINS A1=copt_net_417 A2=HFSNET_18 B1=n39 B2=n81 ZN=n506 VDD=VDD
+ VSS=VSS
XU152 oai22d1 $PINS A1=copt_net_403 A2=HFSNET_18 B1=n40 B2=n81 ZN=n507 VDD=VDD
+ VSS=VSS
XU153 oai22d1 $PINS A1=copt_net_572 A2=HFSNET_18 B1=n41 B2=n81 ZN=n508 VDD=VDD
+ VSS=VSS
XU154 oai22d1 $PINS A1=copt_net_439 A2=HFSNET_18 B1=n42 B2=n81 ZN=n509 VDD=VDD
+ VSS=VSS
XU155 oai22d1 $PINS A1=copt_net_491 A2=HFSNET_18 B1=n43 B2=n81 ZN=n510 VDD=VDD
+ VSS=VSS
XU156 oai22d1 $PINS A1=copt_net_500 A2=HFSNET_18 B1=n44 B2=n81 ZN=n511 VDD=VDD
+ VSS=VSS
XU157 oai22d1 $PINS A1=copt_net_502 A2=HFSNET_18 B1=n45 B2=n81 ZN=n512 VDD=VDD
+ VSS=VSS
XU158 oai22d1 $PINS A1=copt_net_588 A2=HFSNET_18 B1=n46 B2=n81 ZN=n513 VDD=VDD
+ VSS=VSS
XU159 oai22d1 $PINS A1=copt_net_582 A2=HFSNET_18 B1=n47 B2=n81 ZN=n514 VDD=VDD
+ VSS=VSS
XU160 oai22d1 $PINS A1=copt_net_434 A2=HFSNET_18 B1=n48 B2=n81 ZN=n515 VDD=VDD
+ VSS=VSS
XU161 oai22d1 $PINS A1=copt_net_574 A2=HFSNET_18 B1=n49 B2=n81 ZN=n516 VDD=VDD
+ VSS=VSS
XU162 oai22d1 $PINS A1=copt_net_542 A2=HFSNET_18 B1=n50 B2=n81 ZN=n517 VDD=VDD
+ VSS=VSS
XU163 oai22d1 $PINS A1=copt_net_406 A2=HFSNET_18 B1=n51 B2=n81 ZN=n518 VDD=VDD
+ VSS=VSS
XU164 oai22d1 $PINS A1=copt_net_478 A2=HFSNET_18 B1=n52 B2=n81 ZN=n519 VDD=VDD
+ VSS=VSS
XU165 oai22d1 $PINS A1=copt_net_535 A2=HFSNET_18 B1=n53 B2=n81 ZN=n520 VDD=VDD
+ VSS=VSS
XU166 oai22d1 $PINS A1=copt_net_599 A2=HFSNET_18 B1=n54 B2=n81 ZN=n521 VDD=VDD
+ VSS=VSS
XU167 oai22d1 $PINS A1=copt_net_469 A2=HFSNET_18 B1=n55 B2=n81 ZN=n522 VDD=VDD
+ VSS=VSS
XU168 oai22d1 $PINS A1=copt_net_475 A2=HFSNET_18 B1=n56 B2=n81 ZN=n523 VDD=VDD
+ VSS=VSS
XU169 oai22d1 $PINS A1=copt_net_531 A2=HFSNET_18 B1=n57 B2=n81 ZN=n524 VDD=VDD
+ VSS=VSS
XU170 oai22d1 $PINS A1=copt_net_386 A2=HFSNET_18 B1=n58 B2=n81 ZN=n525 VDD=VDD
+ VSS=VSS
XU171 oai22d1 $PINS A1=copt_net_510 A2=HFSNET_18 B1=n59 B2=n81 ZN=n526 VDD=VDD
+ VSS=VSS
XU172 oai22d1 $PINS A1=copt_net_428 A2=HFSNET_18 B1=n60 B2=n81 ZN=n527 VDD=VDD
+ VSS=VSS
XU173 oai22d1 $PINS A1=copt_net_702 A2=HFSNET_18 B1=n61 B2=n81 ZN=n528 VDD=VDD
+ VSS=VSS
XU174 oai22d1 $PINS A1=copt_net_430 A2=HFSNET_18 B1=n62 B2=n81 ZN=n529 VDD=VDD
+ VSS=VSS
XU175 oai22d1 $PINS A1=copt_net_689 A2=HFSNET_18 B1=n63 B2=n81 ZN=n530 VDD=VDD
+ VSS=VSS
XU176 oai22d1 $PINS A1=copt_net_484 A2=HFSNET_18 B1=n64 B2=n81 ZN=n531 VDD=VDD
+ VSS=VSS
XU177 oai22d1 $PINS A1=copt_net_617 A2=HFSNET_18 B1=n65 B2=n81 ZN=n532 VDD=VDD
+ VSS=VSS
XU178 oai22d1 $PINS A1=copt_net_979 A2=HFSNET_18 B1=n66 B2=n81 ZN=n533 VDD=VDD
+ VSS=VSS
XU179 oai22d1 $PINS A1=copt_net_557 A2=HFSNET_18 B1=n67 B2=n81 ZN=n534 VDD=VDD
+ VSS=VSS
XU180 oai22d1 $PINS A1=copt_net_422 A2=HFSNET_18 B1=n68 B2=n81 ZN=n535 VDD=VDD
+ VSS=VSS
XU183 oai22d1 $PINS A1=copt_net_383 A2=HFSNET_22 B1=n37 B2=n84 ZN=n536 VDD=VDD
+ VSS=VSS
XU184 oai22d1 $PINS A1=copt_net_457 A2=HFSNET_22 B1=n38 B2=n84 ZN=n537 VDD=VDD
+ VSS=VSS
XU185 oai22d1 $PINS A1=copt_net_555 A2=HFSNET_22 B1=n39 B2=n84 ZN=n538 VDD=VDD
+ VSS=VSS
XU186 oai22d1 $PINS A1=copt_net_482 A2=HFSNET_22 B1=n40 B2=n84 ZN=n539 VDD=VDD
+ VSS=VSS
XU187 oai22d1 $PINS A1=copt_net_479 A2=HFSNET_22 B1=n41 B2=n84 ZN=n540 VDD=VDD
+ VSS=VSS
XU188 oai22d1 $PINS A1=copt_net_636 A2=HFSNET_22 B1=n42 B2=n84 ZN=n541 VDD=VDD
+ VSS=VSS
XU189 oai22d1 $PINS A1=copt_net_526 A2=HFSNET_22 B1=n43 B2=n84 ZN=n542 VDD=VDD
+ VSS=VSS
XU190 oai22d1 $PINS A1=copt_net_499 A2=HFSNET_22 B1=n44 B2=n84 ZN=n543 VDD=VDD
+ VSS=VSS
XU191 oai22d1 $PINS A1=copt_net_449 A2=HFSNET_22 B1=n45 B2=n84 ZN=n544 VDD=VDD
+ VSS=VSS
XU192 oai22d1 $PINS A1=copt_net_656 A2=HFSNET_22 B1=n46 B2=n84 ZN=n545 VDD=VDD
+ VSS=VSS
XU193 oai22d1 $PINS A1=copt_net_522 A2=HFSNET_22 B1=n47 B2=n84 ZN=n546 VDD=VDD
+ VSS=VSS
XU194 oai22d1 $PINS A1=copt_net_519 A2=HFSNET_22 B1=n48 B2=n84 ZN=n547 VDD=VDD
+ VSS=VSS
XU195 oai22d1 $PINS A1=copt_net_732 A2=HFSNET_22 B1=n49 B2=n84 ZN=n548 VDD=VDD
+ VSS=VSS
XU196 oai22d1 $PINS A1=copt_net_532 A2=HFSNET_22 B1=n50 B2=n84 ZN=n549 VDD=VDD
+ VSS=VSS
XU197 oai22d1 $PINS A1=copt_net_450 A2=HFSNET_22 B1=n51 B2=n84 ZN=n550 VDD=VDD
+ VSS=VSS
XU198 oai22d1 $PINS A1=copt_net_405 A2=HFSNET_22 B1=n52 B2=n84 ZN=n551 VDD=VDD
+ VSS=VSS
XU199 oai22d1 $PINS A1=copt_net_488 A2=HFSNET_22 B1=n53 B2=n84 ZN=n552 VDD=VDD
+ VSS=VSS
XU200 oai22d1 $PINS A1=copt_net_552 A2=HFSNET_22 B1=n54 B2=n84 ZN=n553 VDD=VDD
+ VSS=VSS
XU201 oai22d1 $PINS A1=copt_net_497 A2=HFSNET_22 B1=n55 B2=n84 ZN=n554 VDD=VDD
+ VSS=VSS
XU202 oai22d1 $PINS A1=copt_net_496 A2=HFSNET_22 B1=n56 B2=n84 ZN=n555 VDD=VDD
+ VSS=VSS
XU203 oai22d1 $PINS A1=copt_net_540 A2=HFSNET_22 B1=n57 B2=n84 ZN=n556 VDD=VDD
+ VSS=VSS
XU204 oai22d1 $PINS A1=copt_net_460 A2=HFSNET_22 B1=n58 B2=n84 ZN=n557 VDD=VDD
+ VSS=VSS
XU205 oai22d1 $PINS A1=copt_net_584 A2=HFSNET_22 B1=n59 B2=n84 ZN=n558 VDD=VDD
+ VSS=VSS
XU206 oai22d1 $PINS A1=copt_net_393 A2=HFSNET_22 B1=n60 B2=n84 ZN=n559 VDD=VDD
+ VSS=VSS
XU207 oai22d1 $PINS A1=copt_net_655 A2=HFSNET_22 B1=n61 B2=n84 ZN=n560 VDD=VDD
+ VSS=VSS
XU208 oai22d1 $PINS A1=copt_net_490 A2=HFSNET_22 B1=n62 B2=n84 ZN=n561 VDD=VDD
+ VSS=VSS
XU209 oai22d1 $PINS A1=copt_net_685 A2=HFSNET_22 B1=n63 B2=n84 ZN=n562 VDD=VDD
+ VSS=VSS
XU210 oai22d1 $PINS A1=copt_net_477 A2=HFSNET_22 B1=n64 B2=n84 ZN=n563 VDD=VDD
+ VSS=VSS
XU211 oai22d1 $PINS A1=copt_net_580 A2=HFSNET_22 B1=n65 B2=n84 ZN=n564 VDD=VDD
+ VSS=VSS
XU212 oai22d1 $PINS A1=copt_net_945 A2=HFSNET_22 B1=n66 B2=n84 ZN=n565 VDD=VDD
+ VSS=VSS
XU213 oai22d1 $PINS A1=copt_net_593 A2=HFSNET_22 B1=n67 B2=n84 ZN=n566 VDD=VDD
+ VSS=VSS
XU214 oai22d1 $PINS A1=copt_net_498 A2=HFSNET_22 B1=n68 B2=n84 ZN=n567 VDD=VDD
+ VSS=VSS
XU217 oai22d1 $PINS A1=copt_net_536 A2=HFSNET_20 B1=n37 B2=n86 ZN=n568 VDD=VDD
+ VSS=VSS
XU218 oai22d1 $PINS A1=copt_net_776 A2=HFSNET_20 B1=n38 B2=n86 ZN=n569 VDD=VDD
+ VSS=VSS
XU219 oai22d1 $PINS A1=copt_net_412 A2=HFSNET_20 B1=n39 B2=n86 ZN=n570 VDD=VDD
+ VSS=VSS
XU220 oai22d1 $PINS A1=copt_net_813 A2=HFSNET_20 B1=n40 B2=n86 ZN=n571 VDD=VDD
+ VSS=VSS
XU221 oai22d1 $PINS A1=copt_net_539 A2=HFSNET_20 B1=n41 B2=n86 ZN=n572 VDD=VDD
+ VSS=VSS
XU222 oai22d1 $PINS A1=copt_net_736 A2=HFSNET_20 B1=n42 B2=n86 ZN=n573 VDD=VDD
+ VSS=VSS
XU223 oai22d1 $PINS A1=copt_net_505 A2=HFSNET_20 B1=n43 B2=n86 ZN=n574 VDD=VDD
+ VSS=VSS
XU224 oai22d1 $PINS A1=copt_net_465 A2=HFSNET_20 B1=n44 B2=n86 ZN=n575 VDD=VDD
+ VSS=VSS
XU225 oai22d1 $PINS A1=copt_net_468 A2=HFSNET_20 B1=n45 B2=n86 ZN=n576 VDD=VDD
+ VSS=VSS
XU226 oai22d1 $PINS A1=copt_net_382 A2=HFSNET_20 B1=n46 B2=n86 ZN=n577 VDD=VDD
+ VSS=VSS
XU227 oai22d1 $PINS A1=copt_net_474 A2=HFSNET_20 B1=n47 B2=n86 ZN=n578 VDD=VDD
+ VSS=VSS
XU228 oai22d1 $PINS A1=copt_net_509 A2=HFSNET_20 B1=n48 B2=n86 ZN=n579 VDD=VDD
+ VSS=VSS
XU229 oai22d1 $PINS A1=copt_net_453 A2=HFSNET_20 B1=n49 B2=n86 ZN=n580 VDD=VDD
+ VSS=VSS
XU230 oai22d1 $PINS A1=copt_net_456 A2=HFSNET_20 B1=n50 B2=n86 ZN=n581 VDD=VDD
+ VSS=VSS
XU231 oai22d1 $PINS A1=copt_net_571 A2=HFSNET_20 B1=n51 B2=n86 ZN=n582 VDD=VDD
+ VSS=VSS
XU232 oai22d1 $PINS A1=copt_net_395 A2=HFSNET_20 B1=n52 B2=n86 ZN=n583 VDD=VDD
+ VSS=VSS
XU233 oai22d1 $PINS A1=copt_net_362 A2=HFSNET_20 B1=n53 B2=n86 ZN=n584 VDD=VDD
+ VSS=VSS
XU234 oai22d1 $PINS A1=copt_net_549 A2=HFSNET_20 B1=n54 B2=n86 ZN=n585 VDD=VDD
+ VSS=VSS
XU235 oai22d1 $PINS A1=copt_net_461 A2=HFSNET_20 B1=n55 B2=n86 ZN=n586 VDD=VDD
+ VSS=VSS
XU236 oai22d1 $PINS A1=copt_net_371 A2=HFSNET_20 B1=n56 B2=n86 ZN=n587 VDD=VDD
+ VSS=VSS
XU237 oai22d1 $PINS A1=copt_net_438 A2=HFSNET_20 B1=n57 B2=n86 ZN=n588 VDD=VDD
+ VSS=VSS
XU238 oai22d1 $PINS A1=copt_net_424 A2=HFSNET_20 B1=n58 B2=n86 ZN=n589 VDD=VDD
+ VSS=VSS
XU239 oai22d1 $PINS A1=copt_net_506 A2=HFSNET_20 B1=n59 B2=n86 ZN=n590 VDD=VDD
+ VSS=VSS
XU240 oai22d1 $PINS A1=copt_net_448 A2=HFSNET_20 B1=n60 B2=n86 ZN=n591 VDD=VDD
+ VSS=VSS
XU241 oai22d1 $PINS A1=copt_net_652 A2=HFSNET_20 B1=n61 B2=n86 ZN=n592 VDD=VDD
+ VSS=VSS
XU242 oai22d1 $PINS A1=copt_net_394 A2=HFSNET_20 B1=n62 B2=n86 ZN=n593 VDD=VDD
+ VSS=VSS
XU243 oai22d1 $PINS A1=copt_net_629 A2=HFSNET_20 B1=n63 B2=n86 ZN=n594 VDD=VDD
+ VSS=VSS
XU244 oai22d1 $PINS A1=copt_net_553 A2=HFSNET_20 B1=n64 B2=n86 ZN=n595 VDD=VDD
+ VSS=VSS
XU245 oai22d1 $PINS A1=copt_net_564 A2=HFSNET_20 B1=n65 B2=n86 ZN=n596 VDD=VDD
+ VSS=VSS
XU246 oai22d1 $PINS A1=copt_net_911 A2=HFSNET_20 B1=n66 B2=n86 ZN=n597 VDD=VDD
+ VSS=VSS
XU247 oai22d1 $PINS A1=copt_net_407 A2=HFSNET_20 B1=n67 B2=n86 ZN=n598 VDD=VDD
+ VSS=VSS
XU248 oai22d1 $PINS A1=copt_net_381 A2=HFSNET_20 B1=n68 B2=n86 ZN=n599 VDD=VDD
+ VSS=VSS
XU251 oai22d1 $PINS A1=copt_net_435 A2=HFSNET_12 B1=n37 B2=n88 ZN=n600 VDD=VDD
+ VSS=VSS
XU253 oai22d1 $PINS A1=copt_net_602 A2=HFSNET_12 B1=n38 B2=n88 ZN=n601 VDD=VDD
+ VSS=VSS
XU255 oai22d1 $PINS A1=copt_net_470 A2=HFSNET_12 B1=n39 B2=n88 ZN=n602 VDD=VDD
+ VSS=VSS
XU257 oai22d1 $PINS A1=copt_net_546 A2=HFSNET_12 B1=n40 B2=n88 ZN=n603 VDD=VDD
+ VSS=VSS
XU259 oai22d1 $PINS A1=copt_net_598 A2=HFSNET_12 B1=n41 B2=n88 ZN=n604 VDD=VDD
+ VSS=VSS
XU261 oai22d1 $PINS A1=copt_net_594 A2=HFSNET_12 B1=n42 B2=n88 ZN=n605 VDD=VDD
+ VSS=VSS
XU263 oai22d1 $PINS A1=copt_net_544 A2=HFSNET_12 B1=n43 B2=n88 ZN=n606 VDD=VDD
+ VSS=VSS
XU265 oai22d1 $PINS A1=copt_net_665 A2=HFSNET_12 B1=n44 B2=n88 ZN=n607 VDD=VDD
+ VSS=VSS
XU267 oai22d1 $PINS A1=copt_net_581 A2=HFSNET_12 B1=n45 B2=n88 ZN=n608 VDD=VDD
+ VSS=VSS
XU269 oai22d1 $PINS A1=copt_net_548 A2=HFSNET_12 B1=n46 B2=n88 ZN=n609 VDD=VDD
+ VSS=VSS
XU271 oai22d1 $PINS A1=copt_net_416 A2=HFSNET_12 B1=n47 B2=n88 ZN=n610 VDD=VDD
+ VSS=VSS
XU273 oai22d1 $PINS A1=copt_net_583 A2=HFSNET_12 B1=n48 B2=n88 ZN=n611 VDD=VDD
+ VSS=VSS
XU275 oai22d1 $PINS A1=copt_net_644 A2=HFSNET_12 B1=n49 B2=n88 ZN=n612 VDD=VDD
+ VSS=VSS
XU277 oai22d1 $PINS A1=copt_net_420 A2=HFSNET_12 B1=n50 B2=n88 ZN=n613 VDD=VDD
+ VSS=VSS
XU279 oai22d1 $PINS A1=copt_net_556 A2=HFSNET_12 B1=n51 B2=n88 ZN=n614 VDD=VDD
+ VSS=VSS
XU282 oai22d1 $PINS A1=copt_net_563 A2=HFSNET_12 B1=n52 B2=n88 ZN=n615 VDD=VDD
+ VSS=VSS
XU284 oai22d1 $PINS A1=copt_net_550 A2=HFSNET_12 B1=n53 B2=n88 ZN=n616 VDD=VDD
+ VSS=VSS
XU286 oai22d1 $PINS A1=copt_net_547 A2=HFSNET_12 B1=n54 B2=n88 ZN=n617 VDD=VDD
+ VSS=VSS
XU288 oai22d1 $PINS A1=copt_net_378 A2=HFSNET_12 B1=n55 B2=n88 ZN=n618 VDD=VDD
+ VSS=VSS
XU290 oai22d1 $PINS A1=copt_net_514 A2=HFSNET_12 B1=n56 B2=n88 ZN=n619 VDD=VDD
+ VSS=VSS
XU292 oai22d1 $PINS A1=copt_net_446 A2=HFSNET_12 B1=n57 B2=n88 ZN=n620 VDD=VDD
+ VSS=VSS
XU294 oai22d1 $PINS A1=copt_net_452 A2=HFSNET_12 B1=n58 B2=n88 ZN=n621 VDD=VDD
+ VSS=VSS
XU296 oai22d1 $PINS A1=copt_net_414 A2=HFSNET_12 B1=n59 B2=n88 ZN=n622 VDD=VDD
+ VSS=VSS
XU299 oai22d1 $PINS A1=copt_net_507 A2=HFSNET_12 B1=n60 B2=n88 ZN=n623 VDD=VDD
+ VSS=VSS
XU301 oai22d1 $PINS A1=copt_net_715 A2=HFSNET_12 B1=n61 B2=n88 ZN=n624 VDD=VDD
+ VSS=VSS
XU303 oai22d1 $PINS A1=copt_net_429 A2=HFSNET_12 B1=n62 B2=n88 ZN=n625 VDD=VDD
+ VSS=VSS
XU305 oai22d1 $PINS A1=copt_net_630 A2=HFSNET_12 B1=n63 B2=n88 ZN=n626 VDD=VDD
+ VSS=VSS
XU307 oai22d1 $PINS A1=copt_net_534 A2=HFSNET_12 B1=n64 B2=n88 ZN=n627 VDD=VDD
+ VSS=VSS
XU309 oai22d1 $PINS A1=copt_net_691 A2=HFSNET_12 B1=n65 B2=n88 ZN=n628 VDD=VDD
+ VSS=VSS
XU311 oai22d1 $PINS A1=copt_net_932 A2=HFSNET_12 B1=n66 B2=n88 ZN=n629 VDD=VDD
+ VSS=VSS
XU313 oai22d1 $PINS A1=copt_net_530 A2=HFSNET_12 B1=n67 B2=n88 ZN=n630 VDD=VDD
+ VSS=VSS
XU315 oai22d1 $PINS A1=copt_net_723 A2=HFSNET_12 B1=n68 B2=n88 ZN=n631 VDD=VDD
+ VSS=VSS
XU318 aoim21d1 $PINS B1=n97 B2=n96 A=n95 ZN=n91 VDD=VDD VSS=VSS
XU320 oai22d1 $PINS A1=load_k[2] A2=n751 B1=n667 B2=k_lat[2] ZN=n93 VDD=VDD
+ VSS=VSS
XU321 aoi22d1 $PINS A1=n751 A2=k_lat[1] B1=n667 B2=load_k[1] ZN=n97 VDD=VDD
+ VSS=VSS
XU322 aor31d1 $PINS B1=n99 B2=n100 B3=n70 A=n101 Z=n96 VDD=VDD VSS=VSS
XU323 aoi221d1 $PINS B1=n748 B2=n745 C1=n103 C2=n743 A=n747 ZN=n101 VDD=VDD
+ VSS=VSS
XU325 oai22d1 $PINS A1=n667 A2=n749 B1=n751 B2=n752 ZN=n103 VDD=VDD VSS=VSS
XU329 oai22d1 $PINS A1=m_lat[2] A2=n667 B1=load_m[2] B2=n751 ZN=n100 VDD=VDD
+ VSS=VSS
XU330 oai22d1 $PINS A1=m_lat[1] A2=n667 B1=load_m[1] B2=n751 ZN=n99 VDD=VDD
+ VSS=VSS
XU331 aoi22d1 $PINS A1=n667 A2=load_k[0] B1=n751 B2=k_lat[0] ZN=n94 VDD=VDD
+ VSS=VSS
XU335 oai22d1 $PINS A1=copt_net_2165 A2=n740 B1=n107 B2=n69 ZN=n632 VDD=VDD
+ VSS=VSS
XU336 oai221d1 $PINS B1=n107 B2=n743 C1=n746 C2=n740 A=n745 ZN=n633 VDD=VDD
+ VSS=VSS
XU342 oan211d1 $PINS C1=n746 C2=copt_net_2165 B=n109 A=n31 ZN=n107 VDD=VDD
+ VSS=VSS
XU355 oai22d1 $PINS A1=n248 A2=HFSNET_28 B1=n120 B2=HFSNET_35
+ ZN=active_bank[127] VDD=VDD VSS=VSS
XU356 oai22d1 $PINS A1=n249 A2=HFSNET_28 B1=n121 B2=HFSNET_35
+ ZN=active_bank[126] VDD=VDD VSS=VSS
XU357 oai22d1 $PINS A1=n250 A2=HFSNET_28 B1=n122 B2=HFSNET_35
+ ZN=active_bank[125] VDD=VDD VSS=VSS
XU358 oai22d1 $PINS A1=n251 A2=HFSNET_28 B1=n123 B2=HFSNET_35
+ ZN=active_bank[124] VDD=VDD VSS=VSS
XU359 oai22d1 $PINS A1=n252 A2=HFSNET_28 B1=n124 B2=HFSNET_35
+ ZN=active_bank[123] VDD=VDD VSS=VSS
XU360 oai22d1 $PINS A1=n253 A2=HFSNET_28 B1=n125 B2=HFSNET_35
+ ZN=active_bank[122] VDD=VDD VSS=VSS
XU361 oai22d1 $PINS A1=n254 A2=HFSNET_28 B1=n126 B2=HFSNET_35
+ ZN=active_bank[121] VDD=VDD VSS=VSS
XU362 oai22d1 $PINS A1=n255 A2=HFSNET_28 B1=n127 B2=HFSNET_35
+ ZN=active_bank[120] VDD=VDD VSS=VSS
XU363 oai22d1 $PINS A1=n256 A2=HFSNET_28 B1=n128 B2=HFSNET_35
+ ZN=active_bank[119] VDD=VDD VSS=VSS
XU364 oai22d1 $PINS A1=copt_net_551 A2=HFSNET_28 B1=n129 B2=HFSNET_35
+ ZN=active_bank[118] VDD=VDD VSS=VSS
XU365 oai22d1 $PINS A1=n258 A2=HFSNET_28 B1=n130 B2=HFSNET_35
+ ZN=active_bank[117] VDD=VDD VSS=VSS
XU366 oai22d1 $PINS A1=n259 A2=HFSNET_28 B1=n131 B2=HFSNET_35
+ ZN=active_bank[116] VDD=VDD VSS=VSS
XU367 oai22d1 $PINS A1=n260 A2=HFSNET_28 B1=n132 B2=HFSNET_35
+ ZN=active_bank[115] VDD=VDD VSS=VSS
XU368 oai22d1 $PINS A1=copt_net_454 A2=HFSNET_30 B1=n133 B2=active_sel
+ ZN=active_bank[114] VDD=VDD VSS=VSS
XU369 oai22d1 $PINS A1=copt_net_455 A2=HFSNET_30 B1=copt_net_535 B2=active_sel
+ ZN=active_bank[113] VDD=VDD VSS=VSS
XU370 oai22d1 $PINS A1=copt_net_459 A2=HFSNET_30 B1=copt_net_478 B2=active_sel
+ ZN=active_bank[112] VDD=VDD VSS=VSS
XU371 oai22d1 $PINS A1=copt_net_445 A2=HFSNET_30 B1=copt_net_406 B2=active_sel
+ ZN=active_bank[111] VDD=VDD VSS=VSS
XU372 oai22d1 $PINS A1=copt_net_511 A2=HFSNET_30 B1=copt_net_542 B2=active_sel
+ ZN=active_bank[110] VDD=VDD VSS=VSS
XU373 oai22d1 $PINS A1=copt_net_494 A2=HFSNET_30 B1=copt_net_575 B2=active_sel
+ ZN=active_bank[109] VDD=VDD VSS=VSS
XU374 oai22d1 $PINS A1=copt_net_384 A2=HFSNET_30 B1=copt_net_434 B2=active_sel
+ ZN=active_bank[108] VDD=VDD VSS=VSS
XU375 oai22d1 $PINS A1=copt_net_400 A2=HFSNET_30 B1=copt_net_582 B2=active_sel
+ ZN=active_bank[107] VDD=VDD VSS=VSS
XU376 oai22d1 $PINS A1=n269 A2=HFSNET_30 B1=copt_net_588 B2=active_sel
+ ZN=active_bank[106] VDD=VDD VSS=VSS
XU377 oai22d2 $PINS A1=copt_net_380 A2=HFSNET_30 B1=n142 B2=active_sel
+ ZN=active_bank[105] VDD=VDD VSS=VSS
XU378 oai22d1 $PINS A1=copt_net_441 A2=HFSNET_30 B1=copt_net_500 B2=active_sel
+ ZN=active_bank[104] VDD=VDD VSS=VSS
XU379 oai22d1 $PINS A1=copt_net_392 A2=HFSNET_30 B1=copt_net_491 B2=active_sel
+ ZN=active_bank[103] VDD=VDD VSS=VSS
XU380 oai22d1 $PINS A1=copt_net_463 A2=HFSNET_30 B1=copt_net_439 B2=active_sel
+ ZN=active_bank[102] VDD=VDD VSS=VSS
XU381 oai22d1 $PINS A1=n274 A2=HFSNET_28 B1=n146 B2=HFSNET_35
+ ZN=active_bank[101] VDD=VDD VSS=VSS
XU382 oai22d1 $PINS A1=n275 A2=HFSNET_28 B1=n147 B2=HFSNET_35
+ ZN=active_bank[100] VDD=VDD VSS=VSS
XU383 oai22d1 $PINS A1=n276 A2=HFSNET_28 B1=n148 B2=HFSNET_35
+ ZN=active_bank[99] VDD=VDD VSS=VSS
XU384 oai22d1 $PINS A1=n277 A2=HFSNET_28 B1=n149 B2=HFSNET_35
+ ZN=active_bank[98] VDD=VDD VSS=VSS
XU385 oai22d1 $PINS A1=n278 A2=HFSNET_28 B1=n150 B2=HFSNET_35
+ ZN=active_bank[97] VDD=VDD VSS=VSS
XU386 oai22d1 $PINS A1=n279 A2=HFSNET_28 B1=n151 B2=HFSNET_35
+ ZN=active_bank[96] VDD=VDD VSS=VSS
XU387 oai22d1 $PINS A1=copt_net_442 A2=HFSNET_28 B1=copt_net_593 B2=HFSNET_35
+ ZN=active_bank[95] VDD=VDD VSS=VSS
XU388 oai22d1 $PINS A1=n281 A2=HFSNET_28 B1=n153 B2=HFSNET_35
+ ZN=active_bank[94] VDD=VDD VSS=VSS
XU389 oai22d1 $PINS A1=n282 A2=HFSNET_28 B1=n154 B2=HFSNET_35
+ ZN=active_bank[93] VDD=VDD VSS=VSS
XU390 oai22d1 $PINS A1=n283 A2=HFSNET_28 B1=n155 B2=HFSNET_35
+ ZN=active_bank[92] VDD=VDD VSS=VSS
XU391 oai22d1 $PINS A1=n284 A2=HFSNET_28 B1=n156 B2=HFSNET_35
+ ZN=active_bank[91] VDD=VDD VSS=VSS
XU392 oai22d1 $PINS A1=n285 A2=HFSNET_28 B1=n157 B2=HFSNET_35
+ ZN=active_bank[90] VDD=VDD VSS=VSS
XU393 oai22d1 $PINS A1=n286 A2=HFSNET_28 B1=n158 B2=HFSNET_35
+ ZN=active_bank[89] VDD=VDD VSS=VSS
XU394 oai22d1 $PINS A1=copt_net_426 A2=HFSNET_29 B1=copt_net_393 B2=HFSNET_34
+ ZN=active_bank[88] VDD=VDD VSS=VSS
XU395 oai22d1 $PINS A1=n288 A2=HFSNET_28 B1=n160 B2=HFSNET_35
+ ZN=active_bank[87] VDD=VDD VSS=VSS
XU396 oai22d1 $PINS A1=n289 A2=HFSNET_28 B1=n161 B2=HFSNET_35
+ ZN=active_bank[86] VDD=VDD VSS=VSS
XU397 oai22d1 $PINS A1=copt_net_480 A2=HFSNET_30 B1=n162 B2=active_sel
+ ZN=active_bank[85] VDD=VDD VSS=VSS
XU398 oai22d1 $PINS A1=n291 A2=HFSNET_28 B1=n163 B2=HFSNET_35
+ ZN=active_bank[84] VDD=VDD VSS=VSS
XU399 oai22d1 $PINS A1=n292 A2=HFSNET_30 B1=n164 B2=active_sel
+ ZN=active_bank[83] VDD=VDD VSS=VSS
XU400 oai22d1 $PINS A1=copt_net_528 A2=HFSNET_30 B1=copt_net_552 B2=active_sel
+ ZN=active_bank[82] VDD=VDD VSS=VSS
XU401 oai22d1 $PINS A1=copt_net_586 A2=HFSNET_30 B1=copt_net_488 B2=active_sel
+ ZN=active_bank[81] VDD=VDD VSS=VSS
XU402 oai22d1 $PINS A1=copt_net_493 A2=HFSNET_30 B1=copt_net_405 B2=active_sel
+ ZN=active_bank[80] VDD=VDD VSS=VSS
XU403 oai22d1 $PINS A1=copt_net_573 A2=HFSNET_30 B1=copt_net_450 B2=active_sel
+ ZN=active_bank[79] VDD=VDD VSS=VSS
XU404 oai22d1 $PINS A1=copt_net_492 A2=HFSNET_30 B1=copt_net_532 B2=active_sel
+ ZN=active_bank[78] VDD=VDD VSS=VSS
XU405 oai22d1 $PINS A1=copt_net_567 A2=HFSNET_30 B1=n170 B2=active_sel
+ ZN=active_bank[77] VDD=VDD VSS=VSS
XU406 oai22d1 $PINS A1=copt_net_559 A2=HFSNET_30 B1=copt_net_519 B2=active_sel
+ ZN=active_bank[76] VDD=VDD VSS=VSS
XU407 oai22d1 $PINS A1=copt_net_576 A2=HFSNET_30 B1=copt_net_522 B2=active_sel
+ ZN=active_bank[75] VDD=VDD VSS=VSS
XU408 oai22d1 $PINS A1=copt_net_415 A2=HFSNET_30 B1=n173 B2=active_sel
+ ZN=active_bank[74] VDD=VDD VSS=VSS
XU409 oai22d1 $PINS A1=copt_net_566 A2=HFSNET_30 B1=copt_net_449 B2=active_sel
+ ZN=active_bank[73] VDD=VDD VSS=VSS
XU410 oai22d1 $PINS A1=copt_net_554 A2=HFSNET_30 B1=copt_net_499 B2=active_sel
+ ZN=active_bank[72] VDD=VDD VSS=VSS
XU411 oai22d1 $PINS A1=n304 A2=HFSNET_30 B1=copt_net_526 B2=active_sel
+ ZN=active_bank[71] VDD=VDD VSS=VSS
XU412 oai22d1 $PINS A1=n305 A2=HFSNET_29 B1=n177 B2=HFSNET_34
+ ZN=active_bank[70] VDD=VDD VSS=VSS
XU413 oai22d1 $PINS A1=n306 A2=HFSNET_29 B1=n178 B2=HFSNET_34
+ ZN=active_bank[69] VDD=VDD VSS=VSS
XU414 oai22d1 $PINS A1=n307 A2=HFSNET_29 B1=n179 B2=HFSNET_34
+ ZN=active_bank[68] VDD=VDD VSS=VSS
XU415 oai22d1 $PINS A1=n308 A2=HFSNET_29 B1=copt_net_555 B2=HFSNET_34
+ ZN=active_bank[67] VDD=VDD VSS=VSS
XU416 oai22d1 $PINS A1=n309 A2=HFSNET_29 B1=n181 B2=HFSNET_34
+ ZN=active_bank[66] VDD=VDD VSS=VSS
XU417 oai22d1 $PINS A1=n310 A2=HFSNET_29 B1=n182 B2=HFSNET_34
+ ZN=active_bank[65] VDD=VDD VSS=VSS
XU418 oai22d1 $PINS A1=n311 A2=HFSNET_29 B1=n183 B2=HFSNET_34
+ ZN=active_bank[64] VDD=VDD VSS=VSS
XU419 oai22d1 $PINS A1=n312 A2=HFSNET_29 B1=n184 B2=HFSNET_34
+ ZN=active_bank[63] VDD=VDD VSS=VSS
XU420 oai22d1 $PINS A1=n313 A2=HFSNET_29 B1=n185 B2=HFSNET_34
+ ZN=active_bank[62] VDD=VDD VSS=VSS
XU421 oai22d1 $PINS A1=n314 A2=HFSNET_29 B1=n186 B2=HFSNET_34
+ ZN=active_bank[61] VDD=VDD VSS=VSS
XU422 oai22d1 $PINS A1=n315 A2=HFSNET_29 B1=copt_net_553 B2=HFSNET_34
+ ZN=active_bank[60] VDD=VDD VSS=VSS
XU423 oai22d1 $PINS A1=n316 A2=HFSNET_29 B1=n188 B2=HFSNET_34
+ ZN=active_bank[59] VDD=VDD VSS=VSS
XU424 oai22d1 $PINS A1=n317 A2=HFSNET_29 B1=n189 B2=HFSNET_34
+ ZN=active_bank[58] VDD=VDD VSS=VSS
XU425 oai22d1 $PINS A1=n318 A2=HFSNET_29 B1=n190 B2=HFSNET_34
+ ZN=active_bank[57] VDD=VDD VSS=VSS
XU426 oai22d1 $PINS A1=n319 A2=HFSNET_29 B1=n191 B2=HFSNET_34
+ ZN=active_bank[56] VDD=VDD VSS=VSS
XU427 oai22d1 $PINS A1=n320 A2=HFSNET_29 B1=n192 B2=HFSNET_34
+ ZN=active_bank[55] VDD=VDD VSS=VSS
XU428 oai22d1 $PINS A1=n321 A2=HFSNET_29 B1=n193 B2=HFSNET_34
+ ZN=active_bank[54] VDD=VDD VSS=VSS
XU429 oai22d1 $PINS A1=copt_net_538 A2=HFSNET_29 B1=copt_net_438 B2=HFSNET_34
+ ZN=active_bank[53] VDD=VDD VSS=VSS
XU430 oai22d1 $PINS A1=n323 A2=HFSNET_29 B1=n195 B2=HFSNET_34
+ ZN=active_bank[52] VDD=VDD VSS=VSS
XU431 oai22d1 $PINS A1=n324 A2=HFSNET_29 B1=n196 B2=HFSNET_34
+ ZN=active_bank[51] VDD=VDD VSS=VSS
XU432 oai22d1 $PINS A1=n325 A2=HFSNET_31 B1=n197 B2=HFSNET_33
+ ZN=active_bank[50] VDD=VDD VSS=VSS
XU433 oai22d1 $PINS A1=n326 A2=HFSNET_31 B1=n198 B2=HFSNET_33
+ ZN=active_bank[49] VDD=VDD VSS=VSS
XU434 oai22d1 $PINS A1=n327 A2=HFSNET_31 B1=n199 B2=HFSNET_33
+ ZN=active_bank[48] VDD=VDD VSS=VSS
XU435 oai22d1 $PINS A1=n328 A2=HFSNET_31 B1=n200 B2=HFSNET_33
+ ZN=active_bank[47] VDD=VDD VSS=VSS
XU436 oai22d1 $PINS A1=n329 A2=HFSNET_31 B1=n201 B2=HFSNET_33
+ ZN=active_bank[46] VDD=VDD VSS=VSS
XU437 oai22d1 $PINS A1=n330 A2=HFSNET_31 B1=n202 B2=HFSNET_33
+ ZN=active_bank[45] VDD=VDD VSS=VSS
XU438 oai22d1 $PINS A1=n331 A2=HFSNET_31 B1=n203 B2=HFSNET_33
+ ZN=active_bank[44] VDD=VDD VSS=VSS
XU439 oai22d1 $PINS A1=n332 A2=HFSNET_31 B1=copt_net_474 B2=HFSNET_33
+ ZN=active_bank[43] VDD=VDD VSS=VSS
XU440 oai22d1 $PINS A1=n333 A2=HFSNET_31 B1=n205 B2=HFSNET_33
+ ZN=active_bank[42] VDD=VDD VSS=VSS
XU441 oai22d1 $PINS A1=copt_net_372 A2=HFSNET_31 B1=copt_net_468 B2=HFSNET_33
+ ZN=active_bank[41] VDD=VDD VSS=VSS
XU442 oai22d1 $PINS A1=copt_net_421 A2=HFSNET_31 B1=copt_net_465 B2=HFSNET_33
+ ZN=active_bank[40] VDD=VDD VSS=VSS
XU443 oai22d1 $PINS A1=copt_net_473 A2=HFSNET_31 B1=copt_net_505 B2=HFSNET_33
+ ZN=active_bank[39] VDD=VDD VSS=VSS
XU444 oai22d1 $PINS A1=copt_net_504 A2=HFSNET_31 B1=copt_net_736 B2=HFSNET_33
+ ZN=active_bank[38] VDD=VDD VSS=VSS
XU445 oai22d1 $PINS A1=copt_net_451 A2=HFSNET_31 B1=copt_net_539 B2=HFSNET_33
+ ZN=active_bank[37] VDD=VDD VSS=VSS
XU446 oai22d1 $PINS A1=copt_net_541 A2=HFSNET_31 B1=copt_net_813 B2=HFSNET_33
+ ZN=active_bank[36] VDD=VDD VSS=VSS
XU447 oai22d1 $PINS A1=copt_net_516 A2=HFSNET_31 B1=copt_net_412 B2=HFSNET_33
+ ZN=active_bank[35] VDD=VDD VSS=VSS
XU448 oai22d1 $PINS A1=copt_net_447 A2=HFSNET_31 B1=copt_net_776 B2=HFSNET_33
+ ZN=active_bank[34] VDD=VDD VSS=VSS
XU449 oai22d1 $PINS A1=n342 A2=HFSNET_31 B1=copt_net_536 B2=HFSNET_33
+ ZN=active_bank[33] VDD=VDD VSS=VSS
XU450 oai22d1 $PINS A1=n343 A2=HFSNET_31 B1=n215 B2=HFSNET_33
+ ZN=active_bank[32] VDD=VDD VSS=VSS
XU451 oai22d1 $PINS A1=n344 A2=HFSNET_29 B1=n216 B2=HFSNET_34
+ ZN=active_bank[31] VDD=VDD VSS=VSS
XU452 oai22d1 $PINS A1=n345 A2=HFSNET_29 B1=n217 B2=HFSNET_34
+ ZN=active_bank[30] VDD=VDD VSS=VSS
XU453 oai22d1 $PINS A1=n346 A2=HFSNET_29 B1=n218 B2=HFSNET_34
+ ZN=active_bank[29] VDD=VDD VSS=VSS
XU454 oai22d1 $PINS A1=copt_net_408 A2=HFSNET_29 B1=copt_net_534 B2=HFSNET_34
+ ZN=active_bank[28] VDD=VDD VSS=VSS
XU455 oai22d1 $PINS A1=n348 A2=HFSNET_29 B1=n220 B2=HFSNET_34
+ ZN=active_bank[27] VDD=VDD VSS=VSS
XU456 oai22d1 $PINS A1=n349 A2=HFSNET_29 B1=n221 B2=HFSNET_34
+ ZN=active_bank[26] VDD=VDD VSS=VSS
XU457 oai22d1 $PINS A1=n350 A2=HFSNET_29 B1=n222 B2=HFSNET_34
+ ZN=active_bank[25] VDD=VDD VSS=VSS
XU458 oai22d1 $PINS A1=n351 A2=HFSNET_29 B1=n223 B2=HFSNET_34
+ ZN=active_bank[24] VDD=VDD VSS=VSS
XU459 oai22d1 $PINS A1=n352 A2=HFSNET_29 B1=n224 B2=HFSNET_34
+ ZN=active_bank[23] VDD=VDD VSS=VSS
XU460 oai22d1 $PINS A1=n353 A2=HFSNET_29 B1=n225 B2=HFSNET_34
+ ZN=active_bank[22] VDD=VDD VSS=VSS
XU461 oai22d1 $PINS A1=copt_net_363 A2=HFSNET_29 B1=n226 B2=HFSNET_34
+ ZN=active_bank[21] VDD=VDD VSS=VSS
XU462 oai22d1 $PINS A1=n355 A2=HFSNET_29 B1=n227 B2=HFSNET_34
+ ZN=active_bank[20] VDD=VDD VSS=VSS
XU463 oai22d1 $PINS A1=n356 A2=HFSNET_29 B1=n228 B2=HFSNET_34
+ ZN=active_bank[19] VDD=VDD VSS=VSS
XU464 oai22d1 $PINS A1=copt_net_529 A2=HFSNET_29 B1=n229 B2=HFSNET_34
+ ZN=active_bank[18] VDD=VDD VSS=VSS
XU465 oai22d1 $PINS A1=copt_net_537 A2=HFSNET_31 B1=copt_net_550 B2=HFSNET_33
+ ZN=active_bank[17] VDD=VDD VSS=VSS
XU466 oai22d1 $PINS A1=n359 A2=HFSNET_31 B1=n231 B2=HFSNET_33
+ ZN=active_bank[16] VDD=VDD VSS=VSS
XU467 oai22d1 $PINS A1=n360 A2=HFSNET_31 B1=copt_net_556 B2=HFSNET_33
+ ZN=active_bank[15] VDD=VDD VSS=VSS
XU468 oai22d1 $PINS A1=copt_net_398 A2=HFSNET_29 B1=copt_net_420 B2=HFSNET_34
+ ZN=active_bank[14] VDD=VDD VSS=VSS
XU469 oai22d1 $PINS A1=copt_net_543 A2=HFSNET_31 B1=copt_net_644 B2=HFSNET_33
+ ZN=active_bank[13] VDD=VDD VSS=VSS
XU470 oai22d1 $PINS A1=copt_net_389 A2=HFSNET_31 B1=n235 B2=HFSNET_33
+ ZN=active_bank[12] VDD=VDD VSS=VSS
XU471 oai22d1 $PINS A1=copt_net_545 A2=HFSNET_31 B1=copt_net_416 B2=HFSNET_33
+ ZN=active_bank[11] VDD=VDD VSS=VSS
XU472 oai22d1 $PINS A1=copt_net_569 A2=HFSNET_31 B1=copt_net_548 B2=HFSNET_33
+ ZN=active_bank[10] VDD=VDD VSS=VSS
XU473 oai22d1 $PINS A1=copt_net_562 A2=HFSNET_31 B1=copt_net_581 B2=HFSNET_33
+ ZN=active_bank[9] VDD=VDD VSS=VSS
XU474 oai22d1 $PINS A1=copt_net_627 A2=HFSNET_31 B1=copt_net_665 B2=HFSNET_33
+ ZN=active_bank[8] VDD=VDD VSS=VSS
XU475 oai22d1 $PINS A1=copt_net_596 A2=HFSNET_31 B1=copt_net_544 B2=HFSNET_33
+ ZN=active_bank[7] VDD=VDD VSS=VSS
XU476 oai22d1 $PINS A1=copt_net_472 A2=HFSNET_31 B1=copt_net_594 B2=HFSNET_33
+ ZN=active_bank[6] VDD=VDD VSS=VSS
XU477 oai22d1 $PINS A1=copt_net_560 A2=HFSNET_31 B1=copt_net_598 B2=HFSNET_33
+ ZN=active_bank[5] VDD=VDD VSS=VSS
XU478 oai22d1 $PINS A1=copt_net_589 A2=HFSNET_31 B1=copt_net_546 B2=HFSNET_33
+ ZN=active_bank[4] VDD=VDD VSS=VSS
XU479 oai22d1 $PINS A1=copt_net_558 A2=HFSNET_31 B1=copt_net_470 B2=HFSNET_33
+ ZN=active_bank[3] VDD=VDD VSS=VSS
XU480 oai22d1 $PINS A1=copt_net_578 A2=HFSNET_31 B1=copt_net_602 B2=HFSNET_33
+ ZN=active_bank[2] VDD=VDD VSS=VSS
XU481 oai22d1 $PINS A1=n374 A2=HFSNET_29 B1=n246 B2=HFSNET_34 ZN=active_bank[1]
+ VDD=VDD VSS=VSS
XU482 oai22d1 $PINS A1=n375 A2=HFSNET_31 B1=copt_net_723 B2=HFSNET_33
+ ZN=active_bank[0] VDD=VDD VSS=VSS
XU148 an03d1 $PINS A1=load_busy_gOb6 A2=HFSNET_30 A3=array_en Z=n71 VDD=VDD
+ VSS=VSS
XU334 an03d1 $PINS A1=array_en A2=load_busy_gOb6 A3=active_sel Z=n82 VDD=VDD
+ VSS=VSS
Xload_done_reg_reg dfcrq2 $PINS D=copt_net_2357 CP=ZCTSNET_48 CDN=HFSNET_39
+ Q=load_done_gOb7 VDD=VDD VSS=VSS
Xactive_load_reg dfcrq2 $PINS D=n634 CP=ZCTSNET_48 CDN=HFSNET_39 Q=active_load
+ VDD=VDD VSS=VSS
Xk_lat_reg_1_ dfcrq2 $PINS D=n117 CP=ZCTSNET_55 CDN=HFSNET_39 Q=k_lat[1]
+ VDD=VDD VSS=VSS
Xk_lat_reg_2_ dfcrq2 $PINS D=n118 CP=ZCTSNET_48 CDN=HFSNET_39 Q=k_lat[2]
+ VDD=VDD VSS=VSS
Xk_lat_reg_0_ dfcrq2 $PINS D=n116 CP=sbcto_ht1_0 CDN=HFSNET_44 Q=k_lat[0]
+ VDD=VDD VSS=VSS
Xm_lat_reg_2_ dfcrq2 $PINS D=copt_gre_net_3200 CP=sbcto_ht1_0 CDN=HFSNET_47
+ Q=m_lat[2] VDD=VDD VSS=VSS
Xm_lat_reg_1_ dfcrq2 $PINS D=n114 CP=ZCTSNET_48 CDN=HFSNET_39 Q=m_lat[1]
+ VDD=VDD VSS=VSS
Xm_lat_reg_0_ dfcrq2 $PINS D=n113 CP=ZCTSNET_48 CDN=HFSNET_39 Q=m_lat[0]
+ VDD=VDD VSS=VSS
Xcyc_idx_reg_1_ dfcrq2 $PINS D=n633 CP=ZCTSNET_0 CDN=HFSNET_39 Q=cyc_idx[1]
+ VDD=VDD VSS=VSS
Xcyc_idx_reg_0_ dfcrq2 $PINS D=n632 CP=ZCTSNET_48 CDN=HFSNET_39 Q=cyc_idx[0]
+ VDD=VDD VSS=VSS
Xactive_sel_reg dfcrq2 $PINS D=n112 CP=ZCTSNET_54 CDN=HFSNET_44 Q=active_sel
+ VDD=VDD VSS=VSS
XU4 nd02d1 $PINS A1=n4 A2=n3 ZN=rd_data[0] VDD=VDD VSS=VSS
XU44 aon211d1 $PINS C1=n94 C2=n97 B=n96 A=n1 ZN=n89 VDD=VDD VSS=VSS
XU45 inv0d0 $PINS I=n95 ZN=n1 VDD=VDD VSS=VSS
XU78 aoi22d1 $PINS A1=active_bank[13] A2=n652 B1=active_bank[45] B2=n651 ZN=n30
+ VDD=VDD VSS=VSS
XU79 aoi22d1 $PINS A1=active_bank[5] A2=n652 B1=active_bank[37] B2=n651 ZN=n13
+ VDD=VDD VSS=VSS
XU112 aoi22d1 $PINS A1=active_bank[7] A2=n652 B1=active_bank[39] B2=n651 ZN=n17
+ VDD=VDD VSS=VSS
XU113 aoi22d1 $PINS A1=active_bank[71] A2=n650 B1=active_bank[103] B2=n649
+ ZN=n18 VDD=VDD VSS=VSS
XU146 mx02d1 $PINS I0=copt_net_2773 I1=n667 S=n111 Z=n634 VDD=VDD VSS=VSS
XU147 nr02d2 $PINS A1=HFSNET_10 A2=rd_row[0] ZN=n650 VDD=VDD VSS=VSS
XU181 nr02d2 $PINS A1=HFSNET_10 A2=HFSNET_8 ZN=n649 VDD=VDD VSS=VSS
XU182 nr02d2 $PINS A1=HFSNET_8 A2=rd_row[1] ZN=n651 VDD=VDD VSS=VSS
XU215 nr02d2 $PINS A1=rd_row[0] A2=rd_row[1] ZN=n652 VDD=VDD VSS=VSS
XU216 aoi21d1 $PINS B1=n93 B2=n94 A=n91 ZN=n92 VDD=VDD VSS=VSS
XHFSBUF_6323_530 buffd1 $PINS I=HFSNET_31 Z=HFSNET_28 VDD=VDD VSS=VSS
XHFSINV_17180_658 inv0d2 $PINS I=HFSNET_43 ZN=HFSNET_40 VDD=VDD VSS=VSS
XHFSBUF_21543_531 buffd3 $PINS I=HFSNET_31 Z=HFSNET_29 VDD=VDD VSS=VSS
XHFSINV_4012_415 inv0d2 $PINS I=n88 ZN=HFSNET_12 VDD=VDD VSS=VSS
XctmTdsLR_1_1336 aoim22d1 $PINS A1=n28 A2=HFSNET_28 B1=n28 B2=HFSNET_28 Z=n112
+ VDD=VDD VSS=VSS
XHFSINV_3346_417 inv0d2 $PINS I=n79 ZN=HFSNET_14 VDD=VDD VSS=VSS
XZCTSBUF_96192_2569 buffda $PINS I=ZCTSNET_0 Z=ZCTSNET_4 VDD=VDD VSS=VSS
XZCTSBUF_96720_2570 buffd3 $PINS I=ZCTSNET_0 Z=ZCTSNET_5 VDD=VDD VSS=VSS
XHFSINV_6617_419 inv0d1 $PINS I=n2 ZN=HFSNET_16 VDD=VDD VSS=VSS
XZCTSBUF_97063_2571 buffd3 $PINS I=ZCTSNET_0 Z=ZCTSNET_6 VDD=VDD VSS=VSS
XHFSINV_2764_421 inv0d1 $PINS I=n81 ZN=HFSNET_18 VDD=VDD VSS=VSS
Xcopt_h_inst_3191 dl02d1 $PINS I=n258 Z=copt_net_361 VDD=VDD VSS=VSS
XHFSINV_3256_423 inv0d2 $PINS I=n86 ZN=HFSNET_20 VDD=VDD VSS=VSS
Xcopt_h_inst_3192 dl02d1 $PINS I=n198 Z=copt_net_362 VDD=VDD VSS=VSS
XHFSINV_5467_425 inv0d2 $PINS I=n84 ZN=HFSNET_22 VDD=VDD VSS=VSS
Xcopt_h_inst_3193 dl02d1 $PINS I=n354 Z=copt_net_363 VDD=VDD VSS=VSS
XHFSINV_5515_427 inv0d2 $PINS I=n76 ZN=HFSNET_24 VDD=VDD VSS=VSS
Xcopt_h_inst_3195 dl02d1 $PINS I=n317 Z=copt_net_365 VDD=VDD VSS=VSS
XHFSINV_4744_429 inv0d2 $PINS I=n73 ZN=HFSNET_26 VDD=VDD VSS=VSS
Xcopt_h_inst_3196 dl02d1 $PINS I=n278 Z=copt_net_366 VDD=VDD VSS=VSS
XHFSBUF_11697_532 buffd1 $PINS I=HFSNET_31 Z=HFSNET_30 VDD=VDD VSS=VSS
XHFSINV_23109_533 inv0d2 $PINS I=active_sel ZN=HFSNET_31 VDD=VDD VSS=VSS
Xcopt_h_inst_3197 dl02d1 $PINS I=n253 Z=copt_net_367 VDD=VDD VSS=VSS
XHFSBUF_16887_535 buffd1 $PINS I=active_sel Z=HFSNET_33 VDD=VDD VSS=VSS
XU295 inv0d0 $PINS I=n31 ZN=n750 VDD=VDD VSS=VSS
Xcopt_h_inst_3198 dl02d1 $PINS I=n321 Z=copt_net_368 VDD=VDD VSS=VSS
Xcopt_h_inst_3199 dl02d1 $PINS I=n252 Z=copt_net_369 VDD=VDD VSS=VSS
Xcopt_h_inst_3200 dl02d1 $PINS I=n255 Z=copt_net_370 VDD=VDD VSS=VSS
XHFSBUF_21343_536 bufbd1 $PINS I=active_sel Z=HFSNET_34 VDD=VDD VSS=VSS
XHFSBUF_114_537 buffd1 $PINS I=active_sel Z=HFSNET_35 VDD=VDD VSS=VSS
XHFSINV_17345_659 inv0d2 $PINS I=HFSNET_43 ZN=HFSNET_41 VDD=VDD VSS=VSS
XHFSINV_16544_662 inv0d2 $PINS I=HFSNET_43 ZN=HFSNET_44 VDD=VDD VSS=VSS
XHFSINV_16913_663 inv0d2 $PINS I=HFSNET_43 ZN=HFSNET_45 VDD=VDD VSS=VSS
XHFSINV_16794_664 inv0d2 $PINS I=HFSNET_43 ZN=HFSNET_46 VDD=VDD VSS=VSS
XHFSINV_16687_665 inv0d2 $PINS I=HFSNET_43 ZN=HFSNET_47 VDD=VDD VSS=VSS
Xcopt_h_inst_3201 dl02d1 $PINS I=n195 Z=copt_net_371 VDD=VDD VSS=VSS
Xcopt_h_inst_3202 dl02d1 $PINS I=n334 Z=copt_net_372 VDD=VDD VSS=VSS
Xcopt_h_inst_3203 dl02d1 $PINS I=n275 Z=copt_net_373 VDD=VDD VSS=VSS
Xcopt_h_inst_3204 dl02d1 $PINS I=n274 Z=copt_net_374 VDD=VDD VSS=VSS
Xcopt_h_inst_3205 dl02d1 $PINS I=n323 Z=copt_net_375 VDD=VDD VSS=VSS
Xcopt_h_inst_3206 dl02d1 $PINS I=n277 Z=copt_net_376 VDD=VDD VSS=VSS
Xcopt_h_inst_3208 dl02d1 $PINS I=n228 Z=copt_net_378 VDD=VDD VSS=VSS
Xcopt_h_inst_3209 dl02d1 $PINS I=n319 Z=copt_net_379 VDD=VDD VSS=VSS
Xcopt_h_inst_3210 dl02d1 $PINS I=n270 Z=copt_net_380 VDD=VDD VSS=VSS
XU337 nd03d2 $PINS A1=n82 A2=n743 A3=n745 ZN=n88 VDD=VDD VSS=VSS
Xcopt_h_inst_3211 dl02d1 $PINS I=n215 Z=copt_net_381 VDD=VDD VSS=VSS
Xcopt_h_inst_3212 dl02d1 $PINS I=n205 Z=copt_net_382 VDD=VDD VSS=VSS
Xcopt_h_inst_3213 dl02d1 $PINS I=n182 Z=copt_net_383 VDD=VDD VSS=VSS
Xcopt_h_inst_3214 dl02d1 $PINS I=n267 Z=copt_net_384 VDD=VDD VSS=VSS
XU343 nd03d2 $PINS A1=n71 A2=n743 A3=n745 ZN=n79 VDD=VDD VSS=VSS
Xcopt_h_inst_3215 dl02d1 $PINS I=n333 Z=copt_net_385 VDD=VDD VSS=VSS
XU345 nr02d1 $PINS A1=n751 A2=HFSNET_37 ZN=n31 VDD=VDD VSS=VSS
Xcopt_h_inst_3216 dl02d1 $PINS I=n129 Z=copt_net_386 VDD=VDD VSS=VSS
Xcopt_h_inst_3217 dl02d1 $PINS I=n320 Z=copt_net_387 VDD=VDD VSS=VSS
Xcopt_gre_h_inst_5856 dl01d1 $PINS I=n115 Z=copt_gre_net_3200 VDD=VDD VSS=VSS
Xcopt_h_inst_3219 dl02d1 $PINS I=n363 Z=copt_net_389 VDD=VDD VSS=VSS
Xcopt_h_inst_3222 dl02d1 $PINS I=n272 Z=copt_net_392 VDD=VDD VSS=VSS
Xcopt_h_inst_3223 dl02d1 $PINS I=n159 Z=copt_net_393 VDD=VDD VSS=VSS
Xcopt_h_inst_3224 dl02d1 $PINS I=n189 Z=copt_net_394 VDD=VDD VSS=VSS
Xcopt_h_inst_3225 dl02d1 $PINS I=n199 Z=copt_net_395 VDD=VDD VSS=VSS
Xcopt_h_inst_3226 dl02d1 $PINS I=n291 Z=copt_net_396 VDD=VDD VSS=VSS
Xcopt_h_inst_3227 dl02d1 $PINS I=n288 Z=copt_net_397 VDD=VDD VSS=VSS
Xcopt_h_inst_3228 dl02d1 $PINS I=n361 Z=copt_net_398 VDD=VDD VSS=VSS
Xcopt_h_inst_3230 dl02d1 $PINS I=n268 Z=copt_net_400 VDD=VDD VSS=VSS
Xcopt_h_inst_3231 dl02d1 $PINS I=n329 Z=copt_net_401 VDD=VDD VSS=VSS
Xcopt_h_inst_3232 dl02d1 $PINS I=n349 Z=copt_net_402 VDD=VDD VSS=VSS
Xcopt_h_inst_3233 dl02d1 $PINS I=n147 Z=copt_net_403 VDD=VDD VSS=VSS
Xcopt_h_inst_3234 dl02d1 $PINS I=n305 Z=copt_net_404 VDD=VDD VSS=VSS
XHFSINV_227_309 inv0d1 $PINS I=rd_row[0] ZN=HFSNET_8 VDD=VDD VSS=VSS
Xcopt_h_inst_3235 dl02d1 $PINS I=n167 Z=copt_net_405 VDD=VDD VSS=VSS
Xcopt_h_inst_3236 dl02d1 $PINS I=n136 Z=copt_net_406 VDD=VDD VSS=VSS
Xcopt_h_inst_3237 dl02d1 $PINS I=n184 Z=copt_net_407 VDD=VDD VSS=VSS
Xcopt_h_inst_3238 dl02d1 $PINS I=n347 Z=copt_net_408 VDD=VDD VSS=VSS
Xcopt_h_inst_3239 dl02d1 $PINS I=n149 Z=copt_net_409 VDD=VDD VSS=VSS
XU497 inv0d0 $PINS I=n667 ZN=n751 VDD=VDD VSS=VSS
XU498 inv0d1 $PINS I=n69 ZN=n743 VDD=VDD VSS=VSS
XU499 inv0d1 $PINS I=n70 ZN=n745 VDD=VDD VSS=VSS
XU500 an03d1 $PINS A1=n69 A2=n70 A3=n71 Z=n2 VDD=VDD VSS=VSS
XU501 nd03d2 $PINS A1=n82 A2=n70 A3=n69 ZN=n81 VDD=VDD VSS=VSS
XU502 nd03d2 $PINS A1=n82 A2=n745 A3=n69 ZN=n86 VDD=VDD VSS=VSS
XU503 nd03d2 $PINS A1=n82 A2=n743 A3=n70 ZN=n84 VDD=VDD VSS=VSS
XU504 nd03d2 $PINS A1=n71 A2=n745 A3=n69 ZN=n76 VDD=VDD VSS=VSS
XU505 nd03d2 $PINS A1=n71 A2=n743 A3=n70 ZN=n73 VDD=VDD VSS=VSS
Xcopt_h_inst_3240 dl02d1 $PINS I=n259 Z=copt_net_410 VDD=VDD VSS=VSS
XU507 inv0d0 $PINS I=n107 ZN=n740 VDD=VDD VSS=VSS
XU508 nd02d1 $PINS A1=array_en A2=swap ZN=n28 VDD=VDD VSS=VSS
Xcopt_h_inst_3241 dl02d1 $PINS I=n276 Z=copt_net_411 VDD=VDD VSS=VSS
Xcopt_h_inst_3242 dl02d1 $PINS I=n212 Z=copt_net_412 VDD=VDD VSS=VSS
Xcopt_h_inst_3243 dl02d1 $PINS I=n352 Z=copt_net_413 VDD=VDD VSS=VSS
Xcopt_h_inst_3244 dl02d1 $PINS I=n224 Z=copt_net_414 VDD=VDD VSS=VSS
Xcopt_h_inst_3245 dl02d1 $PINS I=n301 Z=copt_net_415 VDD=VDD VSS=VSS
Xcopt_h_inst_3246 dl02d1 $PINS I=n236 Z=copt_net_416 VDD=VDD VSS=VSS
Xcopt_h_inst_3247 dl02d1 $PINS I=n148 Z=copt_net_417 VDD=VDD VSS=VSS
Xcopt_h_inst_3248 dl02d1 $PINS I=n248 Z=copt_net_418 VDD=VDD VSS=VSS
Xcopt_h_inst_3249 dl02d1 $PINS I=n326 Z=copt_net_419 VDD=VDD VSS=VSS
Xcopt_h_inst_3250 dl02d1 $PINS I=n233 Z=copt_net_420 VDD=VDD VSS=VSS
XHFSINV_190_311 inv0d0 $PINS I=rd_row[1] ZN=HFSNET_10 VDD=VDD VSS=VSS
XU520 inv0d0 $PINS I=n100 ZN=n747 VDD=VDD VSS=VSS
XU521 inv0d0 $PINS I=n99 ZN=n748 VDD=VDD VSS=VSS
XU522 nr02d1 $PINS A1=n93 A2=n96 ZN=n95 VDD=VDD VSS=VSS
XU523 buffd1 $PINS I=load_start Z=n667 VDD=VDD VSS=VSS
XU524 nr02d1 $PINS A1=copt_net_2165 A2=n667 ZN=n69 VDD=VDD VSS=VSS
XU525 nr02d1 $PINS A1=n746 A2=n667 ZN=n70 VDD=VDD VSS=VSS
XU526 inv0d0 $PINS I=n91 ZN=n742 VDD=VDD VSS=VSS
XU527 inv0d0 $PINS I=load_m[0] ZN=n752 VDD=VDD VSS=VSS
XU528 nd02d1 $PINS A1=n751 A2=n741 ZN=load_busy_gOb6 VDD=VDD VSS=VSS
XU529 nd02d1 $PINS A1=n34 A2=n750 ZN=n111 VDD=VDD VSS=VSS
XU530 nr02d1 $PINS A1=n741 A2=HFSNET_37 ZN=n109 VDD=VDD VSS=VSS
Xcopt_h_inst_3251 dl02d1 $PINS I=n335 Z=copt_net_421 VDD=VDD VSS=VSS
XU532 nd02d0 $PINS A1=load_row[16] A2=n92 ZN=n52 VDD=VDD VSS=VSS
XU533 nd02d0 $PINS A1=load_row[17] A2=n92 ZN=n53 VDD=VDD VSS=VSS
XU534 nd02d0 $PINS A1=load_row[18] A2=n92 ZN=n54 VDD=VDD VSS=VSS
XU535 nd02d0 $PINS A1=load_row[19] A2=n92 ZN=n55 VDD=VDD VSS=VSS
XU536 nd02d0 $PINS A1=load_row[20] A2=n92 ZN=n56 VDD=VDD VSS=VSS
XU537 nd02d0 $PINS A1=load_row[21] A2=n92 ZN=n57 VDD=VDD VSS=VSS
XU538 nd02d0 $PINS A1=load_row[22] A2=n92 ZN=n58 VDD=VDD VSS=VSS
XU539 nd02d0 $PINS A1=load_row[23] A2=n92 ZN=n59 VDD=VDD VSS=VSS
XU540 nd02d0 $PINS A1=load_row[1] A2=n89 ZN=n37 VDD=VDD VSS=VSS
XU541 nd02d0 $PINS A1=load_row[2] A2=n89 ZN=n38 VDD=VDD VSS=VSS
XU542 nd02d0 $PINS A1=load_row[3] A2=n89 ZN=n39 VDD=VDD VSS=VSS
XU543 nd02d0 $PINS A1=load_row[4] A2=n89 ZN=n40 VDD=VDD VSS=VSS
XU544 nd02d0 $PINS A1=load_row[5] A2=n89 ZN=n41 VDD=VDD VSS=VSS
XU545 nd02d0 $PINS A1=load_row[6] A2=n89 ZN=n42 VDD=VDD VSS=VSS
XU546 nd02d0 $PINS A1=load_row[7] A2=n89 ZN=n43 VDD=VDD VSS=VSS
XU547 nd02d0 $PINS A1=load_row[0] A2=n89 ZN=n68 VDD=VDD VSS=VSS
XU548 nd02d1 $PINS A1=load_row[8] A2=n742 ZN=n44 VDD=VDD VSS=VSS
XU549 nd02d1 $PINS A1=load_row[9] A2=n742 ZN=n45 VDD=VDD VSS=VSS
XU550 nd02d1 $PINS A1=load_row[10] A2=n742 ZN=n46 VDD=VDD VSS=VSS
XU551 nd02d1 $PINS A1=load_row[11] A2=n742 ZN=n47 VDD=VDD VSS=VSS
XU552 nd02d1 $PINS A1=load_row[12] A2=n742 ZN=n48 VDD=VDD VSS=VSS
XU553 nd02d1 $PINS A1=load_row[13] A2=n742 ZN=n49 VDD=VDD VSS=VSS
XU554 nd02d1 $PINS A1=load_row[14] A2=n742 ZN=n50 VDD=VDD VSS=VSS
XU555 nd02d1 $PINS A1=load_row[15] A2=n742 ZN=n51 VDD=VDD VSS=VSS
XU556 inv0d0 $PINS I=cyc_idx[0] ZN=n744 VDD=VDD VSS=VSS
XU557 inv0d0 $PINS I=copt_net_1406 ZN=n746 VDD=VDD VSS=VSS
XU558 inv0d0 $PINS I=m_lat[0] ZN=n749 VDD=VDD VSS=VSS
XU559 nd02d1 $PINS A1=load_row[24] A2=n95 ZN=n60 VDD=VDD VSS=VSS
XU560 nd02d1 $PINS A1=load_row[25] A2=n95 ZN=n61 VDD=VDD VSS=VSS
XU561 nd02d1 $PINS A1=load_row[26] A2=n95 ZN=n62 VDD=VDD VSS=VSS
XU562 nd02d1 $PINS A1=load_row[27] A2=n95 ZN=n63 VDD=VDD VSS=VSS
XU563 nd02d1 $PINS A1=load_row[28] A2=n95 ZN=n64 VDD=VDD VSS=VSS
XU564 nd02d1 $PINS A1=load_row[29] A2=n95 ZN=n65 VDD=VDD VSS=VSS
XU565 nd02d1 $PINS A1=load_row[30] A2=n95 ZN=n66 VDD=VDD VSS=VSS
XU566 nd02d1 $PINS A1=load_row[31] A2=n95 ZN=n67 VDD=VDD VSS=VSS
XU567 nd03d0 $PINS A1=copt_net_2832 A2=n109 A3=copt_net_1406 ZN=n34 VDD=VDD
+ VSS=VSS
XU568 inv0d0 $PINS I=copt_net_2773 ZN=n741 VDD=VDD VSS=VSS
XU569 aoi22d1 $PINS A1=active_bank[64] A2=n650 B1=active_bank[96] B2=n649 ZN=n4
+ VDD=VDD VSS=VSS
XU570 aoi22d1 $PINS A1=active_bank[0] A2=n652 B1=active_bank[32] B2=n651 ZN=n3
+ VDD=VDD VSS=VSS
XU571 aoi22d1 $PINS A1=active_bank[65] A2=n650 B1=active_bank[97] B2=n649 ZN=n6
+ VDD=VDD VSS=VSS
XU572 aoi22d1 $PINS A1=active_bank[1] A2=n652 B1=active_bank[33] B2=n651 ZN=n5
+ VDD=VDD VSS=VSS
XU573 nd02d1 $PINS A1=n6 A2=n5 ZN=rd_data[1] VDD=VDD VSS=VSS
XU574 aoi22d1 $PINS A1=active_bank[66] A2=n650 B1=active_bank[98] B2=n649 ZN=n8
+ VDD=VDD VSS=VSS
XU575 aoi22d1 $PINS A1=active_bank[2] A2=n652 B1=active_bank[34] B2=n651 ZN=n7
+ VDD=VDD VSS=VSS
XU576 nd02d1 $PINS A1=n8 A2=n7 ZN=rd_data[2] VDD=VDD VSS=VSS
XU577 aoi22d1 $PINS A1=active_bank[67] A2=n650 B1=active_bank[99] B2=n649
+ ZN=n10 VDD=VDD VSS=VSS
XU578 aoi22d1 $PINS A1=active_bank[3] A2=n652 B1=active_bank[35] B2=n651 ZN=n9
+ VDD=VDD VSS=VSS
XU579 nd02d1 $PINS A1=n10 A2=n9 ZN=rd_data[3] VDD=VDD VSS=VSS
XU580 aoi22d1 $PINS A1=active_bank[68] A2=n650 B1=active_bank[100] B2=n649
+ ZN=n12 VDD=VDD VSS=VSS
XU581 aoi22d1 $PINS A1=active_bank[4] A2=n652 B1=active_bank[36] B2=n651 ZN=n11
+ VDD=VDD VSS=VSS
XU582 nd02d1 $PINS A1=n12 A2=n11 ZN=rd_data[4] VDD=VDD VSS=VSS
XU583 aoi22d1 $PINS A1=active_bank[69] A2=n650 B1=active_bank[101] B2=n649
+ ZN=n14 VDD=VDD VSS=VSS
XU584 nd02d1 $PINS A1=n14 A2=n13 ZN=rd_data[5] VDD=VDD VSS=VSS
XU585 aoi22d1 $PINS A1=active_bank[70] A2=n650 B1=active_bank[102] B2=n649
+ ZN=n16 VDD=VDD VSS=VSS
XU586 aoi22d1 $PINS A1=active_bank[6] A2=n652 B1=active_bank[38] B2=n651 ZN=n15
+ VDD=VDD VSS=VSS
XU587 nd02d1 $PINS A1=n16 A2=n15 ZN=rd_data[6] VDD=VDD VSS=VSS
XU588 nd02d1 $PINS A1=n18 A2=n17 ZN=rd_data[7] VDD=VDD VSS=VSS
XU589 aoi22d1 $PINS A1=active_bank[72] A2=n650 B1=active_bank[104] B2=n649
+ ZN=n20 VDD=VDD VSS=VSS
XU590 aoi22d1 $PINS A1=active_bank[8] A2=n652 B1=active_bank[40] B2=n651 ZN=n19
+ VDD=VDD VSS=VSS
XU591 nd02d0 $PINS A1=n20 A2=n19 ZN=rd_data[8] VDD=VDD VSS=VSS
XU592 aoi22d1 $PINS A1=active_bank[73] A2=n650 B1=active_bank[105] B2=n649
+ ZN=n22 VDD=VDD VSS=VSS
XU593 aoi22d1 $PINS A1=active_bank[9] A2=n652 B1=active_bank[41] B2=n651 ZN=n21
+ VDD=VDD VSS=VSS
XU594 nd02d0 $PINS A1=n22 A2=n21 ZN=rd_data[9] VDD=VDD VSS=VSS
XU595 aoi22d1 $PINS A1=active_bank[74] A2=n650 B1=active_bank[106] B2=n649
+ ZN=n24 VDD=VDD VSS=VSS
XU596 aoi22d1 $PINS A1=active_bank[10] A2=n652 B1=active_bank[42] B2=n651
+ ZN=n23 VDD=VDD VSS=VSS
XU597 nd02d0 $PINS A1=n24 A2=n23 ZN=rd_data[10] VDD=VDD VSS=VSS
XU598 aoi22d1 $PINS A1=active_bank[75] A2=n650 B1=active_bank[107] B2=n649
+ ZN=n26 VDD=VDD VSS=VSS
XU599 aoi22d1 $PINS A1=active_bank[11] A2=n652 B1=active_bank[43] B2=n651
+ ZN=n25 VDD=VDD VSS=VSS
XU600 nd02d0 $PINS A1=n26 A2=n25 ZN=rd_data[11] VDD=VDD VSS=VSS
XU601 aoi22d1 $PINS A1=active_bank[76] A2=n650 B1=active_bank[108] B2=n649
+ ZN=n29 VDD=VDD VSS=VSS
XU602 aoi22d1 $PINS A1=active_bank[12] A2=n652 B1=active_bank[44] B2=n651
+ ZN=n27 VDD=VDD VSS=VSS
XU603 nd02d0 $PINS A1=n29 A2=n27 ZN=rd_data[12] VDD=VDD VSS=VSS
XU604 aoi22d1 $PINS A1=active_bank[77] A2=n650 B1=active_bank[109] B2=n649
+ ZN=n32 VDD=VDD VSS=VSS
XU605 nd02d0 $PINS A1=n32 A2=n30 ZN=rd_data[13] VDD=VDD VSS=VSS
XU606 aoi22d1 $PINS A1=active_bank[78] A2=n650 B1=active_bank[110] B2=n649
+ ZN=n35 VDD=VDD VSS=VSS
XU607 aoi22d1 $PINS A1=active_bank[14] A2=n652 B1=active_bank[46] B2=n651
+ ZN=n33 VDD=VDD VSS=VSS
XU608 nd02d0 $PINS A1=n35 A2=n33 ZN=rd_data[14] VDD=VDD VSS=VSS
XU609 aoi22d1 $PINS A1=active_bank[79] A2=n650 B1=active_bank[111] B2=n649
+ ZN=n72 VDD=VDD VSS=VSS
XU610 aoi22d1 $PINS A1=active_bank[15] A2=n652 B1=active_bank[47] B2=n651
+ ZN=n36 VDD=VDD VSS=VSS
XU611 nd02d0 $PINS A1=n72 A2=n36 ZN=rd_data[15] VDD=VDD VSS=VSS
XU612 aoi22d1 $PINS A1=active_bank[80] A2=n650 B1=active_bank[112] B2=n649
+ ZN=n75 VDD=VDD VSS=VSS
XU613 aoi22d1 $PINS A1=active_bank[16] A2=n652 B1=active_bank[48] B2=n651
+ ZN=n74 VDD=VDD VSS=VSS
XU614 nd02d0 $PINS A1=n75 A2=n74 ZN=rd_data[16] VDD=VDD VSS=VSS
XU615 aoi22d1 $PINS A1=active_bank[81] A2=n650 B1=active_bank[113] B2=n649
+ ZN=n78 VDD=VDD VSS=VSS
XU616 aoi22d1 $PINS A1=active_bank[17] A2=n652 B1=active_bank[49] B2=n651
+ ZN=n77 VDD=VDD VSS=VSS
XU617 nd02d0 $PINS A1=n78 A2=n77 ZN=rd_data[17] VDD=VDD VSS=VSS
XU618 aoi22d1 $PINS A1=active_bank[82] A2=n650 B1=active_bank[114] B2=n649
+ ZN=n83 VDD=VDD VSS=VSS
XU619 aoi22d1 $PINS A1=active_bank[18] A2=n652 B1=active_bank[50] B2=n651
+ ZN=n80 VDD=VDD VSS=VSS
XU620 nd02d0 $PINS A1=n83 A2=n80 ZN=rd_data[18] VDD=VDD VSS=VSS
XU621 aoi22d1 $PINS A1=n650 A2=active_bank[83] B1=n649 B2=active_bank[115]
+ ZN=n87 VDD=VDD VSS=VSS
XU622 aoi22d1 $PINS A1=active_bank[19] A2=n652 B1=active_bank[51] B2=n651
+ ZN=n85 VDD=VDD VSS=VSS
XU623 nd02d0 $PINS A1=n85 A2=n87 ZN=rd_data[19] VDD=VDD VSS=VSS
XU624 aoi22d1 $PINS A1=active_bank[84] A2=n650 B1=active_bank[116] B2=n649
+ ZN=n98 VDD=VDD VSS=VSS
XU625 aoi22d1 $PINS A1=active_bank[20] A2=n652 B1=active_bank[52] B2=n651
+ ZN=n90 VDD=VDD VSS=VSS
XU626 nd02d0 $PINS A1=n98 A2=n90 ZN=rd_data[20] VDD=VDD VSS=VSS
XU627 aoi22d1 $PINS A1=active_bank[85] A2=n650 B1=active_bank[117] B2=n649
+ ZN=n104 VDD=VDD VSS=VSS
XU628 aoi22d1 $PINS A1=active_bank[21] A2=n652 B1=active_bank[53] B2=n651
+ ZN=n102 VDD=VDD VSS=VSS
XU629 nd02d0 $PINS A1=n104 A2=n102 ZN=rd_data[21] VDD=VDD VSS=VSS
XU630 aoi22d1 $PINS A1=active_bank[86] A2=n650 B1=active_bank[118] B2=n649
+ ZN=n106 VDD=VDD VSS=VSS
XU631 aoi22d1 $PINS A1=active_bank[22] A2=n652 B1=active_bank[54] B2=n651
+ ZN=n105 VDD=VDD VSS=VSS
XU632 nd02d0 $PINS A1=n106 A2=n105 ZN=rd_data[22] VDD=VDD VSS=VSS
XU633 aoi22d1 $PINS A1=n650 A2=active_bank[87] B1=n649 B2=active_bank[119]
+ ZN=n110 VDD=VDD VSS=VSS
XU634 aoi22d1 $PINS A1=active_bank[23] A2=n652 B1=active_bank[55] B2=n651
+ ZN=n108 VDD=VDD VSS=VSS
XU635 nd02d0 $PINS A1=n108 A2=n110 ZN=rd_data[23] VDD=VDD VSS=VSS
XU636 aoi22d1 $PINS A1=active_bank[88] A2=n650 B1=active_bank[120] B2=n649
+ ZN=n636 VDD=VDD VSS=VSS
XU637 aoi22d1 $PINS A1=active_bank[24] A2=n652 B1=active_bank[56] B2=n651
+ ZN=n635 VDD=VDD VSS=VSS
XU638 nd02d0 $PINS A1=n636 A2=n635 ZN=rd_data[24] VDD=VDD VSS=VSS
XU639 aoi22d1 $PINS A1=n650 A2=active_bank[89] B1=n649 B2=active_bank[121]
+ ZN=n638 VDD=VDD VSS=VSS
XU640 aoi22d1 $PINS A1=active_bank[25] A2=n652 B1=active_bank[57] B2=n651
+ ZN=n637 VDD=VDD VSS=VSS
XU641 nd02d0 $PINS A1=n637 A2=n638 ZN=rd_data[25] VDD=VDD VSS=VSS
XU642 aoi22d1 $PINS A1=n650 A2=active_bank[90] B1=n649 B2=active_bank[122]
+ ZN=n640 VDD=VDD VSS=VSS
XU643 aoi22d1 $PINS A1=active_bank[26] A2=n652 B1=active_bank[58] B2=n651
+ ZN=n639 VDD=VDD VSS=VSS
XU644 nd02d0 $PINS A1=n639 A2=n640 ZN=rd_data[26] VDD=VDD VSS=VSS
XU645 aoi22d1 $PINS A1=active_bank[91] A2=n650 B1=active_bank[123] B2=n649
+ ZN=n642 VDD=VDD VSS=VSS
XU646 aoi22d1 $PINS A1=active_bank[27] A2=n652 B1=active_bank[59] B2=n651
+ ZN=n641 VDD=VDD VSS=VSS
XU647 nd02d0 $PINS A1=n642 A2=n641 ZN=rd_data[27] VDD=VDD VSS=VSS
XU648 aoi22d1 $PINS A1=active_bank[92] A2=n650 B1=active_bank[124] B2=n649
+ ZN=n644 VDD=VDD VSS=VSS
XU649 aoi22d1 $PINS A1=active_bank[28] A2=n652 B1=active_bank[60] B2=n651
+ ZN=n643 VDD=VDD VSS=VSS
XU650 nd02d0 $PINS A1=n644 A2=n643 ZN=rd_data[28] VDD=VDD VSS=VSS
XU651 aoi22d1 $PINS A1=n650 A2=active_bank[93] B1=n649 B2=active_bank[125]
+ ZN=n646 VDD=VDD VSS=VSS
XU652 aoi22d1 $PINS A1=active_bank[29] A2=n652 B1=active_bank[61] B2=n651
+ ZN=n645 VDD=VDD VSS=VSS
XU653 nd02d0 $PINS A1=n645 A2=n646 ZN=rd_data[29] VDD=VDD VSS=VSS
XU654 aoi22d1 $PINS A1=n650 A2=active_bank[94] B1=n649 B2=active_bank[126]
+ ZN=n648 VDD=VDD VSS=VSS
XU655 aoi22d1 $PINS A1=active_bank[30] A2=n652 B1=active_bank[62] B2=n651
+ ZN=n647 VDD=VDD VSS=VSS
XU656 nd02d0 $PINS A1=n647 A2=n648 ZN=rd_data[30] VDD=VDD VSS=VSS
XU657 aoi22d1 $PINS A1=active_bank[95] A2=n650 B1=active_bank[127] B2=n649
+ ZN=n654 VDD=VDD VSS=VSS
XU658 aoi22d1 $PINS A1=active_bank[31] A2=n652 B1=active_bank[63] B2=n651
+ ZN=n653 VDD=VDD VSS=VSS
XU659 nd02d0 $PINS A1=n654 A2=n653 ZN=rd_data[31] VDD=VDD VSS=VSS
Xcopt_h_inst_3252 dl02d1 $PINS I=n151 Z=copt_net_422 VDD=VDD VSS=VSS
Xcopt_h_inst_3253 dl02d1 $PINS I=n256 Z=copt_net_423 VDD=VDD VSS=VSS
Xcopt_h_inst_3254 dl02d1 $PINS I=n193 Z=copt_net_424 VDD=VDD VSS=VSS
Xcopt_h_inst_3255 dl02d1 $PINS I=n251 Z=copt_net_425 VDD=VDD VSS=VSS
Xcopt_h_inst_3256 dl02d1 $PINS I=n287 Z=copt_net_426 VDD=VDD VSS=VSS
Xcopt_h_inst_3257 dl02d1 $PINS I=n344 Z=copt_net_427 VDD=VDD VSS=VSS
Xcopt_h_inst_3258 dl02d1 $PINS I=n127 Z=copt_net_428 VDD=VDD VSS=VSS
Xcopt_h_inst_3259 dl02d1 $PINS I=n221 Z=copt_net_429 VDD=VDD VSS=VSS
Xcopt_h_inst_3260 dl02d1 $PINS I=n125 Z=copt_net_430 VDD=VDD VSS=VSS
Xcopt_h_inst_3261 dl02d1 $PINS I=n351 Z=copt_net_431 VDD=VDD VSS=VSS
Xcopt_h_inst_3263 dl02d1 $PINS I=n289 Z=copt_net_433 VDD=VDD VSS=VSS
Xcopt_h_inst_3264 dl02d1 $PINS I=n139 Z=copt_net_434 VDD=VDD VSS=VSS
Xcopt_h_inst_3265 dl02d1 $PINS I=n246 Z=copt_net_435 VDD=VDD VSS=VSS
Xcopt_h_inst_3266 dl02d1 $PINS I=n307 Z=copt_net_436 VDD=VDD VSS=VSS
Xcopt_h_inst_3267 dl02d1 $PINS I=n279 Z=copt_net_437 VDD=VDD VSS=VSS
Xcopt_h_inst_3268 dl02d1 $PINS I=n194 Z=copt_net_438 VDD=VDD VSS=VSS
Xcopt_h_inst_3269 dl02d1 $PINS I=n145 Z=copt_net_439 VDD=VDD VSS=VSS
Xcopt_h_inst_3270 dl02d1 $PINS I=n311 Z=copt_net_440 VDD=VDD VSS=VSS
Xcopt_h_inst_3271 dl02d1 $PINS I=n271 Z=copt_net_441 VDD=VDD VSS=VSS
Xcopt_h_inst_3272 dl02d1 $PINS I=n280 Z=copt_net_442 VDD=VDD VSS=VSS
Xcopt_h_inst_3274 dl02d1 $PINS I=n283 Z=copt_net_444 VDD=VDD VSS=VSS
Xcopt_h_inst_3275 dl02d1 $PINS I=n264 Z=copt_net_445 VDD=VDD VSS=VSS
Xcopt_h_inst_3276 dl02d1 $PINS I=n226 Z=copt_net_446 VDD=VDD VSS=VSS
Xcopt_h_inst_3277 dl02d1 $PINS I=n341 Z=copt_net_447 VDD=VDD VSS=VSS
Xcopt_h_inst_3278 dl02d1 $PINS I=n191 Z=copt_net_448 VDD=VDD VSS=VSS
Xcopt_h_inst_3279 dl02d1 $PINS I=n174 Z=copt_net_449 VDD=VDD VSS=VSS
Xcopt_h_inst_3280 dl02d1 $PINS I=n168 Z=copt_net_450 VDD=VDD VSS=VSS
Xcopt_h_inst_3281 dl02d1 $PINS I=n338 Z=copt_net_451 VDD=VDD VSS=VSS
Xcopt_h_inst_3282 dl02d1 $PINS I=n225 Z=copt_net_452 VDD=VDD VSS=VSS
Xcopt_h_inst_3283 dl02d1 $PINS I=n202 Z=copt_net_453 VDD=VDD VSS=VSS
Xcopt_h_inst_3284 dl02d1 $PINS I=n261 Z=copt_net_454 VDD=VDD VSS=VSS
Xcopt_h_inst_3285 dl02d1 $PINS I=n262 Z=copt_net_455 VDD=VDD VSS=VSS
Xcopt_h_inst_3286 dl02d1 $PINS I=n201 Z=copt_net_456 VDD=VDD VSS=VSS
Xcopt_h_inst_3287 dl02d1 $PINS I=n181 Z=copt_net_457 VDD=VDD VSS=VSS
Xcopt_h_inst_3289 dl02d1 $PINS I=n263 Z=copt_net_459 VDD=VDD VSS=VSS
Xcopt_h_inst_3290 dl02d1 $PINS I=n161 Z=copt_net_460 VDD=VDD VSS=VSS
Xcopt_h_inst_3291 dl02d1 $PINS I=n196 Z=copt_net_461 VDD=VDD VSS=VSS
Xcopt_h_inst_3293 dl02d1 $PINS I=n273 Z=copt_net_463 VDD=VDD VSS=VSS
Xcopt_h_inst_3294 dl02d1 $PINS I=n260 Z=copt_net_464 VDD=VDD VSS=VSS
Xcopt_h_inst_3295 dl02d1 $PINS I=n207 Z=copt_net_465 VDD=VDD VSS=VSS
Xcopt_h_inst_3296 dl02d1 $PINS I=n292 Z=copt_net_466 VDD=VDD VSS=VSS
Xcopt_h_inst_3297 dl02d1 $PINS I=n285 Z=copt_net_467 VDD=VDD VSS=VSS
Xcopt_h_inst_3298 dl02d1 $PINS I=n206 Z=copt_net_468 VDD=VDD VSS=VSS
Xcopt_h_inst_3299 dl02d1 $PINS I=n132 Z=copt_net_469 VDD=VDD VSS=VSS
Xcopt_h_inst_3300 dl02d1 $PINS I=n244 Z=copt_net_470 VDD=VDD VSS=VSS
Xcopt_h_inst_3301 dl02d1 $PINS I=n331 Z=copt_net_471 VDD=VDD VSS=VSS
Xcopt_h_inst_3302 dl02d1 $PINS I=n369 Z=copt_net_472 VDD=VDD VSS=VSS
Xcopt_h_inst_3303 dl02d1 $PINS I=n336 Z=copt_net_473 VDD=VDD VSS=VSS
Xcopt_h_inst_3304 dl02d1 $PINS I=n204 Z=copt_net_474 VDD=VDD VSS=VSS
Xcopt_h_inst_3305 dl02d1 $PINS I=n131 Z=copt_net_475 VDD=VDD VSS=VSS
Xcopt_h_inst_3307 dl02d1 $PINS I=n155 Z=copt_net_477 VDD=VDD VSS=VSS
Xcopt_h_inst_3308 dl02d1 $PINS I=n135 Z=copt_net_478 VDD=VDD VSS=VSS
Xcopt_h_inst_3309 dl02d1 $PINS I=n178 Z=copt_net_479 VDD=VDD VSS=VSS
Xcopt_h_inst_3310 dl02d1 $PINS I=n290 Z=copt_net_480 VDD=VDD VSS=VSS
Xcopt_h_inst_3311 dl02d1 $PINS I=n359 Z=copt_net_481 VDD=VDD VSS=VSS
Xcopt_h_inst_3312 dl02d1 $PINS I=n179 Z=copt_net_482 VDD=VDD VSS=VSS
Xcopt_h_inst_3313 dl02d1 $PINS I=n309 Z=copt_net_483 VDD=VDD VSS=VSS
Xcopt_h_inst_3314 dl02d1 $PINS I=n123 Z=copt_net_484 VDD=VDD VSS=VSS
Xcopt_h_inst_3315 dl02d1 $PINS I=n332 Z=copt_net_485 VDD=VDD VSS=VSS
Xcopt_h_inst_3317 dl02d1 $PINS I=n330 Z=copt_net_487 VDD=VDD VSS=VSS
Xcopt_h_inst_3318 dl02d1 $PINS I=n166 Z=copt_net_488 VDD=VDD VSS=VSS
Xcopt_h_inst_3319 dl02d1 $PINS I=n308 Z=copt_net_489 VDD=VDD VSS=VSS
Xcopt_h_inst_3320 dl02d1 $PINS I=n157 Z=copt_net_490 VDD=VDD VSS=VSS
Xcopt_h_inst_3321 dl02d1 $PINS I=n144 Z=copt_net_491 VDD=VDD VSS=VSS
Xcopt_h_inst_3322 dl02d1 $PINS I=n297 Z=copt_net_492 VDD=VDD VSS=VSS
Xcopt_h_inst_3323 dl02d1 $PINS I=n295 Z=copt_net_493 VDD=VDD VSS=VSS
Xcopt_h_inst_3324 dl02d1 $PINS I=n266 Z=copt_net_494 VDD=VDD VSS=VSS
Xcopt_h_inst_3325 dl02d1 $PINS I=n269 Z=copt_net_495 VDD=VDD VSS=VSS
Xcopt_h_inst_3326 dl02d1 $PINS I=n163 Z=copt_net_496 VDD=VDD VSS=VSS
Xcopt_h_inst_3327 dl02d1 $PINS I=n164 Z=copt_net_497 VDD=VDD VSS=VSS
Xcopt_h_inst_3328 dl02d1 $PINS I=n183 Z=copt_net_498 VDD=VDD VSS=VSS
Xcopt_h_inst_3329 dl02d1 $PINS I=n175 Z=copt_net_499 VDD=VDD VSS=VSS
Xcopt_h_inst_3330 dl02d1 $PINS I=n143 Z=copt_net_500 VDD=VDD VSS=VSS
Xcopt_h_inst_3331 dl02d1 $PINS I=n353 Z=copt_net_501 VDD=VDD VSS=VSS
Xcopt_h_inst_3332 dl02d1 $PINS I=n142 Z=copt_net_502 VDD=VDD VSS=VSS
Xcopt_h_inst_3333 dl02d1 $PINS I=n310 Z=copt_net_503 VDD=VDD VSS=VSS
Xcopt_h_inst_3334 dl02d1 $PINS I=n337 Z=copt_net_504 VDD=VDD VSS=VSS
Xcopt_h_inst_3335 dl02d1 $PINS I=n208 Z=copt_net_505 VDD=VDD VSS=VSS
Xcopt_h_inst_3336 dl02d1 $PINS I=n192 Z=copt_net_506 VDD=VDD VSS=VSS
Xcopt_h_inst_3337 dl02d1 $PINS I=n223 Z=copt_net_507 VDD=VDD VSS=VSS
Xcopt_h_inst_3338 dl02d1 $PINS I=n150 Z=copt_net_508 VDD=VDD VSS=VSS
Xcopt_h_inst_3339 dl02d1 $PINS I=n203 Z=copt_net_509 VDD=VDD VSS=VSS
Xcopt_h_inst_3340 dl02d1 $PINS I=n128 Z=copt_net_510 VDD=VDD VSS=VSS
Xcopt_h_inst_3341 dl02d1 $PINS I=n265 Z=copt_net_511 VDD=VDD VSS=VSS
Xcopt_h_inst_3342 dl02d1 $PINS I=n355 Z=copt_net_512 VDD=VDD VSS=VSS
Xcopt_h_inst_3344 dl02d1 $PINS I=n227 Z=copt_net_514 VDD=VDD VSS=VSS
Xcopt_h_inst_3346 dl02d1 $PINS I=n340 Z=copt_net_516 VDD=VDD VSS=VSS
Xcopt_h_inst_3347 dl02d1 $PINS I=n356 Z=copt_net_517 VDD=VDD VSS=VSS
Xcopt_h_inst_3348 dl02d1 $PINS I=n324 Z=copt_net_518 VDD=VDD VSS=VSS
Xcopt_h_inst_3349 dl02d1 $PINS I=n171 Z=copt_net_519 VDD=VDD VSS=VSS
Xcopt_h_inst_3350 dl02d1 $PINS I=n342 Z=copt_net_520 VDD=VDD VSS=VSS
Xcopt_h_inst_3351 dl02d1 $PINS I=n327 Z=copt_net_521 VDD=VDD VSS=VSS
Xcopt_h_inst_3352 dl02d1 $PINS I=n172 Z=copt_net_522 VDD=VDD VSS=VSS
Xcopt_h_inst_3353 dl02d1 $PINS I=n306 Z=copt_net_523 VDD=VDD VSS=VSS
Xcopt_h_inst_3355 dl02d1 $PINS I=n312 Z=copt_net_525 VDD=VDD VSS=VSS
Xcopt_h_inst_3356 dl02d1 $PINS I=n176 Z=copt_net_526 VDD=VDD VSS=VSS
Xcopt_h_inst_3357 dl02d1 $PINS I=n325 Z=copt_net_527 VDD=VDD VSS=VSS
Xcopt_h_inst_3358 dl02d1 $PINS I=n293 Z=copt_net_528 VDD=VDD VSS=VSS
Xcopt_h_inst_3359 dl02d1 $PINS I=n357 Z=copt_net_529 VDD=VDD VSS=VSS
Xcopt_h_inst_3360 dl02d1 $PINS I=n216 Z=copt_net_530 VDD=VDD VSS=VSS
Xcopt_h_inst_3361 dl02d1 $PINS I=n130 Z=copt_net_531 VDD=VDD VSS=VSS
Xcopt_h_inst_3362 dl02d1 $PINS I=n169 Z=copt_net_532 VDD=VDD VSS=VSS
Xcopt_h_inst_3363 dl02d1 $PINS I=n282 Z=copt_net_533 VDD=VDD VSS=VSS
Xcopt_h_inst_3364 dl02d1 $PINS I=n219 Z=copt_net_534 VDD=VDD VSS=VSS
Xcopt_h_inst_3365 dl02d1 $PINS I=n134 Z=copt_net_535 VDD=VDD VSS=VSS
Xcopt_h_inst_3366 dl02d1 $PINS I=n214 Z=copt_net_536 VDD=VDD VSS=VSS
Xcopt_h_inst_3367 dl02d1 $PINS I=n358 Z=copt_net_537 VDD=VDD VSS=VSS
Xcopt_h_inst_3368 dl02d1 $PINS I=n322 Z=copt_net_538 VDD=VDD VSS=VSS
Xcopt_h_inst_3369 dl02d1 $PINS I=n210 Z=copt_net_539 VDD=VDD VSS=VSS
Xcopt_h_inst_3370 dl02d1 $PINS I=n162 Z=copt_net_540 VDD=VDD VSS=VSS
Xcopt_h_inst_3371 dl02d1 $PINS I=n339 Z=copt_net_541 VDD=VDD VSS=VSS
Xcopt_h_inst_3372 dl02d1 $PINS I=n137 Z=copt_net_542 VDD=VDD VSS=VSS
Xcopt_h_inst_3373 dl02d1 $PINS I=n362 Z=copt_net_543 VDD=VDD VSS=VSS
Xcopt_h_inst_3374 dl02d1 $PINS I=n240 Z=copt_net_544 VDD=VDD VSS=VSS
Xcopt_h_inst_3375 dl02d1 $PINS I=n364 Z=copt_net_545 VDD=VDD VSS=VSS
Xcopt_h_inst_3376 dl02d1 $PINS I=n243 Z=copt_net_546 VDD=VDD VSS=VSS
Xcopt_h_inst_3377 dl02d1 $PINS I=n229 Z=copt_net_547 VDD=VDD VSS=VSS
Xcopt_h_inst_3378 dl02d1 $PINS I=n237 Z=copt_net_548 VDD=VDD VSS=VSS
Xcopt_h_inst_3379 dl02d1 $PINS I=n197 Z=copt_net_549 VDD=VDD VSS=VSS
Xcopt_h_inst_3380 dl02d1 $PINS I=n230 Z=copt_net_550 VDD=VDD VSS=VSS
Xcopt_h_inst_3381 dl02d1 $PINS I=n257 Z=copt_net_551 VDD=VDD VSS=VSS
Xcopt_h_inst_3382 dl02d1 $PINS I=n165 Z=copt_net_552 VDD=VDD VSS=VSS
Xcopt_h_inst_3383 dl02d1 $PINS I=n187 Z=copt_net_553 VDD=VDD VSS=VSS
Xcopt_h_inst_3384 dl02d1 $PINS I=n303 Z=copt_net_554 VDD=VDD VSS=VSS
Xcopt_h_inst_3385 dl02d1 $PINS I=n180 Z=copt_net_555 VDD=VDD VSS=VSS
Xcopt_h_inst_3386 dl02d1 $PINS I=n232 Z=copt_net_556 VDD=VDD VSS=VSS
Xcopt_h_inst_3387 dl02d1 $PINS I=n120 Z=copt_net_557 VDD=VDD VSS=VSS
Xcopt_h_inst_3388 dl02d1 $PINS I=n372 Z=copt_net_558 VDD=VDD VSS=VSS
Xcopt_h_inst_3389 dl02d1 $PINS I=n299 Z=copt_net_559 VDD=VDD VSS=VSS
Xcopt_h_inst_3390 dl02d1 $PINS I=n370 Z=copt_net_560 VDD=VDD VSS=VSS
Xcopt_h_inst_3391 dl02d1 $PINS I=n314 Z=copt_net_561 VDD=VDD VSS=VSS
Xcopt_h_inst_3392 dl02d1 $PINS I=n366 Z=copt_net_562 VDD=VDD VSS=VSS
Xcopt_h_inst_3393 dl02d1 $PINS I=n231 Z=copt_net_563 VDD=VDD VSS=VSS
Xcopt_h_inst_3394 dl02d1 $PINS I=n186 Z=copt_net_564 VDD=VDD VSS=VSS
Xcopt_h_inst_3396 dl02d1 $PINS I=n302 Z=copt_net_566 VDD=VDD VSS=VSS
Xcopt_h_inst_3397 dl02d1 $PINS I=n298 Z=copt_net_567 VDD=VDD VSS=VSS
Xcopt_h_inst_3398 dl02d1 $PINS I=n250 Z=copt_net_568 VDD=VDD VSS=VSS
Xcopt_h_inst_3399 dl02d1 $PINS I=n365 Z=copt_net_569 VDD=VDD VSS=VSS
Xcopt_h_inst_3400 dl02d1 $PINS I=n375 Z=copt_net_570 VDD=VDD VSS=VSS
Xcopt_h_inst_3401 dl02d1 $PINS I=n200 Z=copt_net_571 VDD=VDD VSS=VSS
Xcopt_h_inst_3402 dl02d1 $PINS I=n146 Z=copt_net_572 VDD=VDD VSS=VSS
Xcopt_h_inst_3403 dl02d1 $PINS I=n296 Z=copt_net_573 VDD=VDD VSS=VSS
Xcopt_h_inst_3404 dl02d1 $PINS I=n138 Z=copt_net_574 VDD=VDD VSS=VSS
Xcopt_h_inst_3405 dl01d1 $PINS I=n138 Z=copt_net_575 VDD=VDD VSS=VSS
Xcopt_h_inst_3406 dl02d1 $PINS I=n300 Z=copt_net_576 VDD=VDD VSS=VSS
Xcopt_h_inst_3408 dl02d1 $PINS I=n373 Z=copt_net_578 VDD=VDD VSS=VSS
Xcopt_h_inst_3409 dl02d1 $PINS I=n346 Z=copt_net_579 VDD=VDD VSS=VSS
Xcopt_h_inst_3410 dl02d1 $PINS I=n154 Z=copt_net_580 VDD=VDD VSS=VSS
Xcopt_h_inst_3411 dl02d1 $PINS I=n238 Z=copt_net_581 VDD=VDD VSS=VSS
Xcopt_h_inst_3412 dl02d1 $PINS I=n140 Z=copt_net_582 VDD=VDD VSS=VSS
Xcopt_h_inst_3413 dl02d1 $PINS I=n235 Z=copt_net_583 VDD=VDD VSS=VSS
Xcopt_h_inst_3414 dl02d1 $PINS I=n160 Z=copt_net_584 VDD=VDD VSS=VSS
Xcopt_h_inst_3415 dl02d1 $PINS I=n294 Z=copt_net_585 VDD=VDD VSS=VSS
Xcopt_h_inst_3416 dl01d1 $PINS I=n294 Z=copt_net_586 VDD=VDD VSS=VSS
Xcopt_h_inst_3418 dl02d1 $PINS I=n141 Z=copt_net_588 VDD=VDD VSS=VSS
Xcopt_h_inst_3419 dl02d1 $PINS I=n371 Z=copt_net_589 VDD=VDD VSS=VSS
Xcopt_h_inst_3420 dl02d1 $PINS I=n328 Z=copt_net_590 VDD=VDD VSS=VSS
Xcopt_h_inst_3421 dl02d1 $PINS I=n315 Z=copt_net_591 VDD=VDD VSS=VSS
Xcopt_h_inst_3422 dl02d1 $PINS I=n343 Z=copt_net_592 VDD=VDD VSS=VSS
Xcopt_h_inst_3423 dl02d1 $PINS I=n152 Z=copt_net_593 VDD=VDD VSS=VSS
Xcopt_h_inst_3424 dl02d1 $PINS I=n241 Z=copt_net_594 VDD=VDD VSS=VSS
Xcopt_h_inst_3426 dl02d1 $PINS I=n368 Z=copt_net_596 VDD=VDD VSS=VSS
Xcopt_h_inst_3427 dl02d1 $PINS I=n304 Z=copt_net_597 VDD=VDD VSS=VSS
Xcopt_h_inst_3428 dl02d1 $PINS I=n242 Z=copt_net_598 VDD=VDD VSS=VSS
Xcopt_h_inst_3429 dl02d1 $PINS I=n133 Z=copt_net_599 VDD=VDD VSS=VSS
Xcopt_h_inst_3430 dl02d1 $PINS I=n360 Z=copt_net_600 VDD=VDD VSS=VSS
Xcopt_h_inst_3432 dl02d1 $PINS I=n245 Z=copt_net_602 VDD=VDD VSS=VSS
Xcopt_h_inst_3436 dl02d1 $PINS I=n284 Z=copt_net_606 VDD=VDD VSS=VSS
Xcopt_h_inst_3447 dl02d1 $PINS I=n122 Z=copt_net_617 VDD=VDD VSS=VSS
Xcopt_h_inst_3456 dl02d1 $PINS I=n367 Z=copt_net_626 VDD=VDD VSS=VSS
Xcopt_h_inst_3457 dl01d1 $PINS I=n367 Z=copt_net_627 VDD=VDD VSS=VSS
Xcopt_h_inst_3459 dl02d1 $PINS I=n188 Z=copt_net_629 VDD=VDD VSS=VSS
Xcopt_h_inst_3460 dl02d1 $PINS I=n220 Z=copt_net_630 VDD=VDD VSS=VSS
Xcopt_h_inst_3465 dl02d1 $PINS I=n254 Z=copt_net_635 VDD=VDD VSS=VSS
Xcopt_h_inst_3466 dl02d1 $PINS I=n177 Z=copt_net_636 VDD=VDD VSS=VSS
Xcopt_h_inst_3474 dl02d1 $PINS I=n234 Z=copt_net_644 VDD=VDD VSS=VSS
Xcopt_h_inst_3475 dl02d1 $PINS I=n316 Z=copt_net_645 VDD=VDD VSS=VSS
Xcopt_h_inst_3476 dl02d1 $PINS I=n318 Z=copt_net_646 VDD=VDD VSS=VSS
Xcopt_h_inst_3482 dl02d1 $PINS I=n190 Z=copt_net_652 VDD=VDD VSS=VSS
Xcopt_h_inst_3485 dl02d1 $PINS I=n158 Z=copt_net_655 VDD=VDD VSS=VSS
Xcopt_h_inst_3486 dl02d1 $PINS I=n173 Z=copt_net_656 VDD=VDD VSS=VSS
Xcopt_h_inst_3495 dl02d1 $PINS I=n239 Z=copt_net_665 VDD=VDD VSS=VSS
Xcopt_h_inst_3514 dl02d1 $PINS I=n286 Z=copt_net_684 VDD=VDD VSS=VSS
Xcopt_h_inst_3515 dl02d1 $PINS I=n156 Z=copt_net_685 VDD=VDD VSS=VSS
Xcopt_h_inst_3516 dl02d1 $PINS I=n348 Z=copt_net_686 VDD=VDD VSS=VSS
Xcopt_h_inst_3519 dl02d1 $PINS I=n124 Z=copt_net_689 VDD=VDD VSS=VSS
Xcopt_h_inst_3521 dl02d1 $PINS I=n218 Z=copt_net_691 VDD=VDD VSS=VSS
Xcopt_h_inst_3532 dl02d1 $PINS I=n126 Z=copt_net_702 VDD=VDD VSS=VSS
Xcopt_h_inst_3544 dl02d1 $PINS I=n350 Z=copt_net_714 VDD=VDD VSS=VSS
Xcopt_h_inst_3545 dl02d1 $PINS I=n222 Z=copt_net_715 VDD=VDD VSS=VSS
Xcopt_h_inst_3551 dl02d1 $PINS I=n374 Z=copt_net_721 VDD=VDD VSS=VSS
Xcopt_h_inst_3553 dl02d1 $PINS I=n247 Z=copt_net_723 VDD=VDD VSS=VSS
Xcopt_h_inst_3563 dl02d1 $PINS I=n170 Z=copt_net_732 VDD=VDD VSS=VSS
Xcopt_h_inst_3567 dl02d1 $PINS I=n209 Z=copt_net_736 VDD=VDD VSS=VSS
Xcopt_h_inst_3607 dl02d1 $PINS I=n213 Z=copt_net_776 VDD=VDD VSS=VSS
Xcopt_h_inst_3645 dl02d1 $PINS I=n211 Z=copt_net_813 VDD=VDD VSS=VSS
Xcopt_h_inst_3708 dl02d1 $PINS I=n281 Z=copt_net_876 VDD=VDD VSS=VSS
Xcopt_h_inst_3712 dl02d1 $PINS I=n313 Z=copt_net_880 VDD=VDD VSS=VSS
Xcopt_h_inst_3719 dl02d1 $PINS I=n249 Z=copt_net_887 VDD=VDD VSS=VSS
Xcopt_h_inst_3743 dl02d1 $PINS I=n185 Z=copt_net_911 VDD=VDD VSS=VSS
Xcopt_h_inst_3762 dl02d1 $PINS I=n345 Z=copt_net_930 VDD=VDD VSS=VSS
Xcopt_h_inst_3764 dl02d1 $PINS I=n217 Z=copt_net_932 VDD=VDD VSS=VSS
Xcopt_h_inst_3777 dl02d1 $PINS I=n153 Z=copt_net_945 VDD=VDD VSS=VSS
Xcopt_h_inst_3811 dl02d1 $PINS I=n121 Z=copt_net_979 VDD=VDD VSS=VSS
Xcopt_h_inst_3880 dl02d1 $PINS I=k_lat[2] Z=copt_net_1048 VDD=VDD VSS=VSS
Xcopt_h_inst_3949 dl01d1 $PINS I=n749 Z=copt_net_1117 VDD=VDD VSS=VSS
Xcopt_h_inst_4238 dl02d1 $PINS I=cyc_idx[1] Z=copt_net_1406 VDD=VDD VSS=VSS
Xcopt_h_inst_4274 dl02d1 $PINS I=m_lat[1] Z=copt_net_1442 VDD=VDD VSS=VSS
Xcopt_h_inst_4382 dl02d1 $PINS I=k_lat[0] Z=copt_net_1550 VDD=VDD VSS=VSS
Xcopt_h_inst_4554 dl02d1 $PINS I=k_lat[1] Z=copt_net_1722 VDD=VDD VSS=VSS
Xcopt_h_inst_4797 dl02d1 $PINS I=m_lat[2] Z=copt_net_1964 VDD=VDD VSS=VSS
Xcopt_h_inst_4998 dl01d1 $PINS I=n744 Z=copt_net_2165 VDD=VDD VSS=VSS
Xcopt_h_inst_5190 dl02d1 $PINS I=n119 Z=copt_net_2357 VDD=VDD VSS=VSS
Xcopt_h_inst_5606 dl02d1 $PINS I=active_load Z=copt_net_2773 VDD=VDD VSS=VSS
Xcopt_h_inst_5666 dl01d1 $PINS I=cyc_idx[0] Z=copt_net_2832 VDD=VDD VSS=VSS
.ENDS

.SUBCKT unpu_wbuf ZCTSNET_58 rst_n array_en load_start load_k[2] load_k[1]
+ load_k[0] load_n[2] load_n[1] load_n[0] load_row[31] load_row[30]
+ load_row[29] load_row[28] load_row[27] load_row[26] load_row[25] load_row[24]
+ load_row[23] load_row[22] load_row[21] load_row[20] load_row[19] load_row[18]
+ load_row[17] load_row[16] load_row[15] load_row[14] load_row[13] load_row[12]
+ load_row[11] load_row[10] load_row[9] load_row[8] load_row[7] load_row[6]
+ load_row[5] load_row[4] load_row[3] load_row[2] load_row[1] load_row[0]
+ load_busy load_done swap weight_load[15] weight_load[14] weight_load[13]
+ weight_load[12] weight_load[11] weight_load[10] weight_load[9] weight_load[8]
+ weight_load[7] weight_load[6] weight_load[5] weight_load[4] weight_load[3]
+ weight_load[2] weight_load[1] weight_load[0] weight_in[127] weight_in[126]
+ weight_in[125] weight_in[124] weight_in[123] weight_in[122] weight_in[121]
+ weight_in[120] weight_in[119] weight_in[118] weight_in[117] weight_in[116]
+ weight_in[115] weight_in[114] weight_in[113] weight_in[112] weight_in[111]
+ weight_in[110] weight_in[109] weight_in[108] weight_in[107] weight_in[106]
+ weight_in[105] weight_in[104] weight_in[103] weight_in[102] weight_in[101]
+ weight_in[100] weight_in[99] weight_in[98] weight_in[97] weight_in[96]
+ weight_in[95] weight_in[94] weight_in[93] weight_in[92] weight_in[91]
+ weight_in[90] weight_in[89] weight_in[88] weight_in[87] weight_in[86]
+ weight_in[85] weight_in[84] weight_in[83] weight_in[82] weight_in[81]
+ weight_in[80] weight_in[79] weight_in[78] weight_in[77] weight_in[76]
+ weight_in[75] weight_in[74] weight_in[73] weight_in[72] weight_in[71]
+ weight_in[70] weight_in[69] weight_in[68] weight_in[67] weight_in[66]
+ weight_in[65] weight_in[64] weight_in[63] weight_in[62] weight_in[61]
+ weight_in[60] weight_in[59] weight_in[58] weight_in[57] weight_in[56]
+ weight_in[55] weight_in[54] weight_in[53] weight_in[52] weight_in[51]
+ weight_in[50] weight_in[49] weight_in[48] weight_in[47] weight_in[46]
+ weight_in[45] weight_in[44] weight_in[43] weight_in[42] weight_in[41]
+ weight_in[40] weight_in[39] weight_in[38] weight_in[37] weight_in[36]
+ weight_in[35] weight_in[34] weight_in[33] weight_in[32] weight_in[31]
+ weight_in[30] weight_in[29] weight_in[28] weight_in[27] weight_in[26]
+ weight_in[25] weight_in[24] weight_in[23] weight_in[22] weight_in[21]
+ weight_in[20] weight_in[19] weight_in[18] weight_in[17] weight_in[16]
+ weight_in[15] weight_in[14] weight_in[13] weight_in[12] weight_in[11]
+ weight_in[10] weight_in[9] weight_in[8] weight_in[7] weight_in[6]
+ weight_in[5] weight_in[4] weight_in[3] weight_in[2] weight_in[1] weight_in[0]
+ VDD VSS ZCTSNET_60 ZCTSNET_61 ZCTSNET_62 ZCTSNET_63 ZCTSNET_64 ZCTSNET_65
+ ZCTSNET_66 ZCTSNET_68 ZCTSNET_70 HFSNET_41 HFSNET_42 HFSNET_43 HFSNET_44
+ HFSNET_46 HFSNET_47 HFSNET_48 HFSNET_49 HFSNET_51 HFSNET_52 HFSNET_54
+ HFSNET_55 HFSNET_56 ZCTSNET_3 ZCTSNET_4 ZCTSNET_6 ZCTSNET_9
*.CONNECT weight_load[0] swap
*.CONNECT weight_load[15] weight_load[0]
*.CONNECT weight_load[14] weight_load[0]
*.CONNECT weight_load[13] weight_load[0]
*.CONNECT weight_load[12] weight_load[0]
*.CONNECT weight_load[11] weight_load[0]
*.CONNECT weight_load[10] weight_load[0]
*.CONNECT weight_load[9] weight_load[0]
*.CONNECT weight_load[8] weight_load[0]
*.CONNECT weight_load[7] weight_load[0]
*.CONNECT weight_load[6] weight_load[0]
*.CONNECT weight_load[5] weight_load[0]
*.CONNECT weight_load[4] weight_load[0]
*.CONNECT weight_load[3] weight_load[0]
*.CONNECT weight_load[2] weight_load[0]
*.CONNECT weight_load[1] weight_load[0]
Xcyc_idx_reg_0_ dfcrn2 $PINS D=n627 CP=ZCTSNET_62 CDN=HFSNET_47 QN=n626 VDD=VDD
+ VSS=VSS
Xcyc_idx_reg_1_ dfcrn2 $PINS D=n628 CP=ZCTSNET_62 CDN=HFSNET_47 QN=n625 VDD=VDD
+ VSS=VSS
XU3 oai22d1 $PINS A1=HFSNET_35 A2=n258 B1=HFSNET_39 B2=n130 ZN=weight_in[127]
+ VDD=VDD VSS=VSS
XU4 oai22d1 $PINS A1=HFSNET_35 A2=copt_net_1308 B1=HFSNET_39 B2=copt_net_2066
+ ZN=weight_in[126] VDD=VDD VSS=VSS
XU5 oai22d1 $PINS A1=HFSNET_35 A2=copt_net_2146 B1=HFSNET_39 B2=copt_net_1851
+ ZN=weight_in[125] VDD=VDD VSS=VSS
XU6 oai22d1 $PINS A1=HFSNET_35 A2=copt_net_1040 B1=HFSNET_39 B2=copt_net_2164
+ ZN=weight_in[124] VDD=VDD VSS=VSS
XU7 oai22d1 $PINS A1=HFSNET_35 A2=n274 B1=HFSNET_39 B2=n146 ZN=weight_in[123]
+ VDD=VDD VSS=VSS
XU8 oai22d1 $PINS A1=HFSNET_35 A2=n278 B1=HFSNET_39 B2=n150 ZN=weight_in[122]
+ VDD=VDD VSS=VSS
XU9 oai22d1 $PINS A1=HFSNET_35 A2=n282 B1=HFSNET_39 B2=n154 ZN=weight_in[121]
+ VDD=VDD VSS=VSS
XU10 oai22d1 $PINS A1=HFSNET_35 A2=n286 B1=HFSNET_39 B2=n158 ZN=weight_in[120]
+ VDD=VDD VSS=VSS
XU11 oai22d1 $PINS A1=HFSNET_35 A2=copt_net_2536 B1=HFSNET_39 B2=copt_net_1977
+ ZN=weight_in[119] VDD=VDD VSS=VSS
XU12 oai22d1 $PINS A1=HFSNET_35 A2=copt_net_1432 B1=HFSNET_39 B2=copt_net_2067
+ ZN=weight_in[118] VDD=VDD VSS=VSS
XU13 oai22d1 $PINS A1=HFSNET_33 A2=copt_net_2664 B1=HFSNET_37 B2=copt_net_2116
+ ZN=weight_in[117] VDD=VDD VSS=VSS
XU14 oai22d1 $PINS A1=HFSNET_35 A2=copt_net_1137 B1=HFSNET_39 B2=copt_net_2024
+ ZN=weight_in[116] VDD=VDD VSS=VSS
XU15 oai22d1 $PINS A1=HFSNET_35 A2=copt_net_758 B1=HFSNET_39 B2=n178
+ ZN=weight_in[115] VDD=VDD VSS=VSS
XU16 oai22d1 $PINS A1=HFSNET_33 A2=copt_net_1225 B1=HFSNET_37 B2=n182
+ ZN=weight_in[114] VDD=VDD VSS=VSS
XU17 oai22d1 $PINS A1=HFSNET_33 A2=copt_net_1861 B1=HFSNET_37 B2=n186
+ ZN=weight_in[113] VDD=VDD VSS=VSS
XU18 oai22d1 $PINS A1=HFSNET_35 A2=copt_net_1939 B1=HFSNET_39 B2=copt_net_2021
+ ZN=weight_in[112] VDD=VDD VSS=VSS
XU19 oai22d1 $PINS A1=HFSNET_34 A2=copt_net_643 B1=HFSNET_38 B2=copt_net_1241
+ ZN=weight_in[111] VDD=VDD VSS=VSS
XU20 oai22d1 $PINS A1=HFSNET_34 A2=copt_net_1112 B1=HFSNET_38 B2=n198
+ ZN=weight_in[110] VDD=VDD VSS=VSS
XU21 oai22d1 $PINS A1=HFSNET_34 A2=copt_net_878 B1=HFSNET_38 B2=copt_net_1580
+ ZN=weight_in[109] VDD=VDD VSS=VSS
XU22 oai22d1 $PINS A1=HFSNET_34 A2=copt_net_1238 B1=HFSNET_38 B2=copt_net_2479
+ ZN=weight_in[108] VDD=VDD VSS=VSS
XU23 oai22d1 $PINS A1=HFSNET_34 A2=copt_net_1206 B1=HFSNET_38 B2=copt_net_2444
+ ZN=weight_in[107] VDD=VDD VSS=VSS
XU24 oai22d1 $PINS A1=HFSNET_34 A2=copt_net_2034 B1=HFSNET_38 B2=copt_net_1982
+ ZN=weight_in[106] VDD=VDD VSS=VSS
XU25 oai22d1 $PINS A1=HFSNET_34 A2=copt_net_2071 B1=HFSNET_38 B2=copt_net_1682
+ ZN=weight_in[105] VDD=VDD VSS=VSS
XU26 oai22d1 $PINS A1=HFSNET_34 A2=n646 B1=HFSNET_38 B2=copt_net_1090
+ ZN=weight_in[104] VDD=VDD VSS=VSS
XU27 oai22d1 $PINS A1=HFSNET_34 A2=copt_net_1097 B1=HFSNET_38 B2=copt_net_1992
+ ZN=weight_in[103] VDD=VDD VSS=VSS
XU28 oai22d1 $PINS A1=HFSNET_40 A2=n648 B1=HFSNET_36 B2=copt_net_1789
+ ZN=weight_in[102] VDD=VDD VSS=VSS
XU29 oai22d1 $PINS A1=HFSNET_40 A2=n649 B1=HFSNET_36 B2=copt_net_1217
+ ZN=weight_in[101] VDD=VDD VSS=VSS
XU30 oai22d1 $PINS A1=HFSNET_40 A2=copt_net_1496 B1=HFSNET_36 B2=copt_net_1549
+ ZN=weight_in[100] VDD=VDD VSS=VSS
XU31 oai22d1 $PINS A1=HFSNET_40 A2=copt_net_1882 B1=HFSNET_36 B2=copt_net_2581
+ ZN=weight_in[99] VDD=VDD VSS=VSS
XU32 oai22d1 $PINS A1=HFSNET_40 A2=copt_net_1641 B1=HFSNET_36 B2=copt_net_2112
+ ZN=weight_in[98] VDD=VDD VSS=VSS
XU33 oai22d1 $PINS A1=HFSNET_40 A2=copt_net_1365 B1=HFSNET_36 B2=copt_net_2080
+ ZN=weight_in[97] VDD=VDD VSS=VSS
XU34 oai22d1 $PINS A1=HFSNET_40 A2=copt_net_1936 B1=HFSNET_36 B2=copt_net_1301
+ ZN=weight_in[96] VDD=VDD VSS=VSS
XU35 oai22d1 $PINS A1=HFSNET_35 A2=copt_net_2729 B1=HFSNET_39 B2=n129
+ ZN=weight_in[95] VDD=VDD VSS=VSS
XU36 oai22d1 $PINS A1=HFSNET_35 A2=copt_net_2684 B1=HFSNET_39 B2=copt_net_1118
+ ZN=weight_in[94] VDD=VDD VSS=VSS
XU37 oai22d1 $PINS A1=HFSNET_35 A2=copt_net_2448 B1=HFSNET_39 B2=copt_net_2012
+ ZN=weight_in[93] VDD=VDD VSS=VSS
XU38 oai22d1 $PINS A1=HFSNET_35 A2=n269 B1=HFSNET_39 B2=copt_net_2224
+ ZN=weight_in[92] VDD=VDD VSS=VSS
XU39 oai22d1 $PINS A1=HFSNET_35 A2=copt_net_2154 B1=HFSNET_39 B2=copt_net_2347
+ ZN=weight_in[91] VDD=VDD VSS=VSS
XU40 oai22d1 $PINS A1=HFSNET_35 A2=n277 B1=HFSNET_39 B2=n149 ZN=weight_in[90]
+ VDD=VDD VSS=VSS
XU41 oai22d1 $PINS A1=HFSNET_35 A2=n281 B1=HFSNET_39 B2=copt_net_2150
+ ZN=weight_in[89] VDD=VDD VSS=VSS
XU42 oai22d1 $PINS A1=HFSNET_35 A2=copt_net_2007 B1=HFSNET_39 B2=n157
+ ZN=weight_in[88] VDD=VDD VSS=VSS
XU43 oai22d1 $PINS A1=HFSNET_33 A2=copt_net_2681 B1=HFSNET_37 B2=copt_net_1539
+ ZN=weight_in[87] VDD=VDD VSS=VSS
XU44 oai22d1 $PINS A1=HFSNET_35 A2=copt_net_1429 B1=HFSNET_39 B2=n165
+ ZN=weight_in[86] VDD=VDD VSS=VSS
XU45 oai22d1 $PINS A1=HFSNET_33 A2=copt_net_2447 B1=HFSNET_37 B2=copt_net_2193
+ ZN=weight_in[85] VDD=VDD VSS=VSS
XU46 oai22d1 $PINS A1=HFSNET_33 A2=copt_net_2424 B1=HFSNET_37 B2=copt_net_1409
+ ZN=weight_in[84] VDD=VDD VSS=VSS
XU47 oai22d1 $PINS A1=HFSNET_33 A2=copt_net_2631 B1=HFSNET_37 B2=copt_net_1506
+ ZN=weight_in[83] VDD=VDD VSS=VSS
XU48 oai22d1 $PINS A1=HFSNET_33 A2=copt_net_2555 B1=HFSNET_37 B2=copt_net_2339
+ ZN=weight_in[82] VDD=VDD VSS=VSS
XU49 oai22d1 $PINS A1=HFSNET_33 A2=copt_net_1985 B1=HFSNET_37 B2=n185
+ ZN=weight_in[81] VDD=VDD VSS=VSS
XU50 oai22d1 $PINS A1=HFSNET_35 A2=copt_net_2544 B1=HFSNET_39 B2=copt_net_2011
+ ZN=weight_in[80] VDD=VDD VSS=VSS
XU51 oai22d1 $PINS A1=HFSNET_34 A2=n328 B1=HFSNET_38 B2=n193 ZN=weight_in[79]
+ VDD=VDD VSS=VSS
XU52 oai22d1 $PINS A1=HFSNET_34 A2=n343 B1=HFSNET_38 B2=copt_net_1635
+ ZN=weight_in[78] VDD=VDD VSS=VSS
XU53 oai22d1 $PINS A1=HFSNET_34 A2=n351 B1=HFSNET_38 B2=copt_net_2550
+ ZN=weight_in[77] VDD=VDD VSS=VSS
XU54 oai22d1 $PINS A1=HFSNET_34 A2=copt_net_2355 B1=HFSNET_38 B2=copt_net_1821
+ ZN=weight_in[76] VDD=VDD VSS=VSS
XU55 oai22d1 $PINS A1=HFSNET_34 A2=copt_net_2630 B1=HFSNET_38 B2=copt_net_1316
+ ZN=weight_in[75] VDD=VDD VSS=VSS
XU56 oai22d1 $PINS A1=HFSNET_34 A2=copt_net_2014 B1=HFSNET_38 B2=copt_net_2100
+ ZN=weight_in[74] VDD=VDD VSS=VSS
XU57 oai22d1 $PINS A1=HFSNET_34 A2=n641 B1=HFSNET_38 B2=n217 ZN=weight_in[73]
+ VDD=VDD VSS=VSS
XU58 oai22d1 $PINS A1=HFSNET_34 A2=copt_net_1677 B1=HFSNET_38 B2=copt_net_2237
+ ZN=weight_in[72] VDD=VDD VSS=VSS
XU59 oai22d1 $PINS A1=HFSNET_40 A2=n232 B1=HFSNET_36 B2=copt_net_1924
+ ZN=weight_in[71] VDD=VDD VSS=VSS
XU60 oai22d1 $PINS A1=HFSNET_40 A2=copt_net_1307 B1=HFSNET_36 B2=n107
+ ZN=weight_in[70] VDD=VDD VSS=VSS
XU61 oai22d1 $PINS A1=HFSNET_40 A2=copt_net_2593 B1=HFSNET_36 B2=copt_net_1338
+ ZN=weight_in[69] VDD=VDD VSS=VSS
XU62 oai22d1 $PINS A1=HFSNET_40 A2=copt_net_2535 B1=HFSNET_36 B2=copt_net_1898
+ ZN=weight_in[68] VDD=VDD VSS=VSS
XU63 oai22d1 $PINS A1=HFSNET_40 A2=n245 B1=HFSNET_36 B2=copt_net_946
+ ZN=weight_in[67] VDD=VDD VSS=VSS
XU64 oai22d1 $PINS A1=HFSNET_40 A2=copt_net_2163 B1=HFSNET_36 B2=copt_net_1483
+ ZN=weight_in[66] VDD=VDD VSS=VSS
XU65 oai22d1 $PINS A1=HFSNET_40 A2=copt_net_1328 B1=HFSNET_36 B2=n100
+ ZN=weight_in[65] VDD=VDD VSS=VSS
XU66 oai22d1 $PINS A1=HFSNET_40 A2=n253 B1=HFSNET_36 B2=copt_net_1902
+ ZN=weight_in[64] VDD=VDD VSS=VSS
XU67 oai22d1 $PINS A1=HFSNET_35 A2=copt_net_2692 B1=HFSNET_39 B2=copt_net_853
+ ZN=weight_in[63] VDD=VDD VSS=VSS
XU68 oai22d1 $PINS A1=HFSNET_35 A2=copt_net_355 B1=HFSNET_39 B2=copt_net_2619
+ ZN=weight_in[62] VDD=VDD VSS=VSS
XU69 oai22d1 $PINS A1=HFSNET_35 A2=copt_net_1291 B1=HFSNET_39 B2=copt_net_2350
+ ZN=weight_in[61] VDD=VDD VSS=VSS
XU70 oai22d1 $PINS A1=HFSNET_35 A2=copt_net_2573 B1=HFSNET_39 B2=copt_net_1947
+ ZN=weight_in[60] VDD=VDD VSS=VSS
XU71 oai22d1 $PINS A1=HFSNET_35 A2=copt_net_2467 B1=HFSNET_39 B2=copt_net_1508
+ ZN=weight_in[59] VDD=VDD VSS=VSS
XU72 oai22d1 $PINS A1=HFSNET_35 A2=n276 B1=HFSNET_39 B2=copt_net_1665
+ ZN=weight_in[58] VDD=VDD VSS=VSS
XU73 oai22d1 $PINS A1=HFSNET_35 A2=n280 B1=HFSNET_39 B2=copt_net_1835
+ ZN=weight_in[57] VDD=VDD VSS=VSS
XU74 oai22d1 $PINS A1=HFSNET_35 A2=n284 B1=HFSNET_39 B2=copt_net_2155
+ ZN=weight_in[56] VDD=VDD VSS=VSS
XU75 oai22d1 $PINS A1=HFSNET_33 A2=n290 B1=HFSNET_37 B2=n160 ZN=weight_in[55]
+ VDD=VDD VSS=VSS
XU76 oai22d1 $PINS A1=HFSNET_33 A2=copt_net_2482 B1=HFSNET_37 B2=copt_net_1698
+ ZN=weight_in[54] VDD=VDD VSS=VSS
XU77 oai22d1 $PINS A1=HFSNET_33 A2=n299 B1=HFSNET_37 B2=copt_net_1006
+ ZN=weight_in[53] VDD=VDD VSS=VSS
XU78 oai22d1 $PINS A1=HFSNET_33 A2=copt_net_710 B1=HFSNET_37 B2=n172
+ ZN=weight_in[52] VDD=VDD VSS=VSS
XU79 oai22d1 $PINS A1=HFSNET_33 A2=copt_net_1575 B1=HFSNET_37 B2=copt_net_1327
+ ZN=weight_in[51] VDD=VDD VSS=VSS
XU80 oai22d1 $PINS A1=HFSNET_33 A2=copt_net_319 B1=HFSNET_37 B2=copt_net_2035
+ ZN=weight_in[50] VDD=VDD VSS=VSS
XU81 oai22d1 $PINS A1=HFSNET_33 A2=copt_net_1158 B1=HFSNET_37 B2=copt_net_2353
+ ZN=weight_in[49] VDD=VDD VSS=VSS
XU82 oai22d1 $PINS A1=HFSNET_35 A2=copt_net_2562 B1=HFSNET_39 B2=copt_net_1024
+ ZN=weight_in[48] VDD=VDD VSS=VSS
XU83 oai22d1 $PINS A1=HFSNET_33 A2=copt_net_513 B1=HFSNET_37 B2=copt_net_1994
+ ZN=weight_in[47] VDD=VDD VSS=VSS
XU84 oai22d1 $PINS A1=HFSNET_33 A2=copt_net_1476 B1=HFSNET_38 B2=copt_net_2506
+ ZN=weight_in[46] VDD=VDD VSS=VSS
XU85 oai22d1 $PINS A1=HFSNET_34 A2=copt_net_1299 B1=HFSNET_38 B2=n200
+ ZN=weight_in[45] VDD=VDD VSS=VSS
XU86 oai22d1 $PINS A1=HFSNET_34 A2=copt_net_1724 B1=HFSNET_38 B2=n204
+ ZN=weight_in[44] VDD=VDD VSS=VSS
XU87 oai22d1 $PINS A1=HFSNET_34 A2=copt_net_1228 B1=HFSNET_38 B2=copt_net_1553
+ ZN=weight_in[43] VDD=VDD VSS=VSS
XU88 oai22d2 $PINS A1=HFSNET_34 A2=copt_net_2216 B1=HFSNET_38 B2=copt_net_1871
+ ZN=weight_in[42] VDD=VDD VSS=VSS
XU89 oai22d1 $PINS A1=HFSNET_34 A2=copt_net_2334 B1=HFSNET_38 B2=copt_net_1564
+ ZN=weight_in[41] VDD=VDD VSS=VSS
XU90 oai22d1 $PINS A1=HFSNET_34 A2=copt_net_2075 B1=HFSNET_38 B2=copt_net_2208
+ ZN=weight_in[40] VDD=VDD VSS=VSS
XU91 oai22d1 $PINS A1=HFSNET_40 A2=copt_net_2209 B1=HFSNET_36 B2=copt_net_1651
+ ZN=weight_in[39] VDD=VDD VSS=VSS
XU92 oai22d1 $PINS A1=HFSNET_40 A2=copt_net_1638 B1=HFSNET_36 B2=copt_net_1402
+ ZN=weight_in[38] VDD=VDD VSS=VSS
XU93 oai22d1 $PINS A1=HFSNET_40 A2=copt_net_2759 B1=HFSNET_36 B2=copt_net_1163
+ ZN=weight_in[37] VDD=VDD VSS=VSS
XU94 oai22d1 $PINS A1=HFSNET_40 A2=copt_net_2772 B1=HFSNET_36 B2=copt_net_2079
+ ZN=weight_in[36] VDD=VDD VSS=VSS
XU95 oai22d1 $PINS A1=HFSNET_40 A2=copt_net_1515 B1=HFSNET_36 B2=copt_net_1864
+ ZN=weight_in[35] VDD=VDD VSS=VSS
XU96 oai22d1 $PINS A1=HFSNET_40 A2=n248 B1=HFSNET_36 B2=n120 ZN=weight_in[34]
+ VDD=VDD VSS=VSS
XU97 oai22d1 $PINS A1=HFSNET_40 A2=copt_net_2124 B1=HFSNET_36 B2=copt_net_2310
+ ZN=weight_in[33] VDD=VDD VSS=VSS
XU98 oai22d1 $PINS A1=HFSNET_40 A2=copt_net_2504 B1=HFSNET_36 B2=copt_net_1911
+ ZN=weight_in[32] VDD=VDD VSS=VSS
XU99 oai22d1 $PINS A1=HFSNET_35 A2=copt_net_728 B1=HFSNET_39 B2=copt_net_1232
+ ZN=weight_in[31] VDD=VDD VSS=VSS
XU100 oai22d1 $PINS A1=HFSNET_35 A2=n259 B1=HFSNET_39 B2=copt_net_486
+ ZN=weight_in[30] VDD=VDD VSS=VSS
XU101 oai22d1 $PINS A1=HFSNET_35 A2=copt_net_1191 B1=HFSNET_39 B2=copt_net_1111
+ ZN=weight_in[29] VDD=VDD VSS=VSS
XU102 oai22d1 $PINS A1=HFSNET_35 A2=n267 B1=HFSNET_39 B2=copt_net_1174
+ ZN=weight_in[28] VDD=VDD VSS=VSS
XU103 oai22d1 $PINS A1=HFSNET_35 A2=copt_net_1116 B1=HFSNET_39 B2=n143
+ ZN=weight_in[27] VDD=VDD VSS=VSS
XU104 oai22d1 $PINS A1=HFSNET_35 A2=copt_net_994 B1=HFSNET_39 B2=copt_net_1302
+ ZN=weight_in[26] VDD=VDD VSS=VSS
XU105 oai22d1 $PINS A1=HFSNET_35 A2=n279 B1=HFSNET_39 B2=copt_net_1081
+ ZN=weight_in[25] VDD=VDD VSS=VSS
XU106 oai22d1 $PINS A1=HFSNET_35 A2=copt_net_1440 B1=HFSNET_39 B2=copt_net_1143
+ ZN=weight_in[24] VDD=VDD VSS=VSS
XU107 oai22d2 $PINS A1=HFSNET_33 A2=n289 B1=HFSNET_37 B2=copt_net_1162
+ ZN=weight_in[23] VDD=VDD VSS=VSS
XU108 oai22d1 $PINS A1=HFSNET_33 A2=copt_net_733 B1=HFSNET_37 B2=copt_net_1337
+ ZN=weight_in[22] VDD=VDD VSS=VSS
XU109 oai22d1 $PINS A1=HFSNET_33 A2=copt_net_1376 B1=HFSNET_37 B2=copt_net_1311
+ ZN=weight_in[21] VDD=VDD VSS=VSS
XU110 oai22d1 $PINS A1=HFSNET_33 A2=copt_net_1128 B1=HFSNET_37 B2=copt_net_1261
+ ZN=weight_in[20] VDD=VDD VSS=VSS
XU111 oai22d1 $PINS A1=HFSNET_34 A2=copt_net_1285 B1=HFSNET_38 B2=copt_net_1375
+ ZN=weight_in[19] VDD=VDD VSS=VSS
XU112 oai22d1 $PINS A1=HFSNET_34 A2=n311 B1=HFSNET_38 B2=copt_net_1269
+ ZN=weight_in[18] VDD=VDD VSS=VSS
XU113 oai22d1 $PINS A1=HFSNET_33 A2=copt_net_1073 B1=HFSNET_37 B2=copt_net_1348
+ ZN=weight_in[17] VDD=VDD VSS=VSS
XU114 oai22d1 $PINS A1=HFSNET_33 A2=copt_net_340 B1=HFSNET_37 B2=copt_net_1274
+ ZN=weight_in[16] VDD=VDD VSS=VSS
XU115 oai22d1 $PINS A1=HFSNET_33 A2=n325 B1=HFSNET_37 B2=copt_net_2191
+ ZN=weight_in[15] VDD=VDD VSS=VSS
XU116 oai22d1 $PINS A1=HFSNET_34 A2=copt_net_1441 B1=HFSNET_38 B2=copt_net_1288
+ ZN=weight_in[14] VDD=VDD VSS=VSS
XU117 oai22d1 $PINS A1=HFSNET_34 A2=copt_net_1293 B1=HFSNET_38 B2=copt_net_1872
+ ZN=weight_in[13] VDD=VDD VSS=VSS
XU118 oai22d1 $PINS A1=HFSNET_34 A2=copt_net_1189 B1=HFSNET_38 B2=n203
+ ZN=weight_in[12] VDD=VDD VSS=VSS
XU119 oai22d1 $PINS A1=HFSNET_34 A2=n631 B1=HFSNET_38 B2=n207 ZN=weight_in[11]
+ VDD=VDD VSS=VSS
XU120 oai22d1 $PINS A1=HFSNET_34 A2=copt_net_2074 B1=HFSNET_38 B2=copt_net_1407
+ ZN=weight_in[10] VDD=VDD VSS=VSS
XU121 oai22d1 $PINS A1=HFSNET_34 A2=copt_net_1865 B1=HFSNET_38 B2=copt_net_1601
+ ZN=weight_in[9] VDD=VDD VSS=VSS
XU122 oai22d1 $PINS A1=HFSNET_34 A2=copt_net_1219 B1=HFSNET_38 B2=copt_net_1178
+ ZN=weight_in[8] VDD=VDD VSS=VSS
XU123 oai22d1 $PINS A1=HFSNET_40 A2=copt_net_2548 B1=HFSNET_36 B2=copt_net_1582
+ ZN=weight_in[7] VDD=VDD VSS=VSS
XU124 oai22d1 $PINS A1=HFSNET_40 A2=copt_net_1331 B1=HFSNET_36 B2=copt_net_2561
+ ZN=weight_in[6] VDD=VDD VSS=VSS
XU125 oai22d1 $PINS A1=HFSNET_40 A2=n236 B1=HFSNET_36 B2=copt_net_1230
+ ZN=weight_in[5] VDD=VDD VSS=VSS
XU126 oai22d1 $PINS A1=HFSNET_40 A2=copt_net_2502 B1=HFSNET_36 B2=copt_net_1009
+ ZN=weight_in[4] VDD=VDD VSS=VSS
XU127 oai22d1 $PINS A1=HFSNET_40 A2=copt_net_1658 B1=HFSNET_36
+ B2=copt_gre_net_3203 ZN=weight_in[3] VDD=VDD VSS=VSS
XU128 oai22d1 $PINS A1=HFSNET_40 A2=copt_net_1257 B1=HFSNET_36 B2=copt_net_2404
+ ZN=weight_in[2] VDD=VDD VSS=VSS
XU129 oai22d1 $PINS A1=HFSNET_40 A2=gre_a_INV_127_3 B1=HFSNET_36
+ B2=copt_net_1245 ZN=weight_in[1] VDD=VDD VSS=VSS
XU130 oai22d1 $PINS A1=HFSNET_40 A2=copt_net_1290 B1=HFSNET_36 B2=copt_net_1455
+ ZN=weight_in[0] VDD=VDD VSS=VSS
XU131 oai22d1 $PINS A1=HFSNET_24 A2=n649 B1=copt_net_2593 B2=copt_net_237
+ ZN=n361 VDD=VDD VSS=VSS
XU133 oai22d1 $PINS A1=HFSNET_24 A2=copt_net_2767 B1=copt_net_1306
+ B2=copt_net_237 ZN=n362 VDD=VDD VSS=VSS
XU135 oai22d1 $PINS A1=HFSNET_27 A2=copt_net_1097 B1=n232 B2=HFSNET_31 ZN=n363
+ VDD=VDD VSS=VSS
XU137 oai22d1 $PINS A1=HFSNET_25 A2=copt_net_2674 B1=copt_net_1677 B2=HFSNET_29
+ ZN=n364 VDD=VDD VSS=VSS
XU139 oai22d1 $PINS A1=HFSNET_26 A2=copt_net_1677 B1=copt_net_2075 B2=HFSNET_30
+ ZN=n365 VDD=VDD VSS=VSS
XU141 oai22d1 $PINS A1=HFSNET_26 A2=copt_net_2075 B1=copt_net_1219 B2=HFSNET_30
+ ZN=n366 VDD=VDD VSS=VSS
XU143 oai22d1 $PINS A1=HFSNET_27 A2=copt_net_1219 B1=n288 B2=load_row[8]
+ ZN=n367 VDD=VDD VSS=VSS
XU145 oai22d1 $PINS A1=HFSNET_26 A2=copt_net_2071 B1=n641 B2=HFSNET_30 ZN=n368
+ VDD=VDD VSS=VSS
XU147 oai22d1 $PINS A1=HFSNET_26 A2=n641 B1=copt_net_2334 B2=HFSNET_30 ZN=n369
+ VDD=VDD VSS=VSS
XU149 oai22d1 $PINS A1=HFSNET_27 A2=copt_net_2334 B1=copt_net_1865 B2=HFSNET_31
+ ZN=n370 VDD=VDD VSS=VSS
XU151 oai22d1 $PINS A1=HFSNET_27 A2=copt_net_1865 B1=n288 B2=load_row[9]
+ ZN=n371 VDD=VDD VSS=VSS
XU153 oai22d1 $PINS A1=HFSNET_26 A2=copt_net_2034 B1=copt_net_2014 B2=HFSNET_30
+ ZN=n372 VDD=VDD VSS=VSS
XU155 oai22d1 $PINS A1=HFSNET_26 A2=copt_net_2014 B1=copt_net_2216 B2=HFSNET_30
+ ZN=n373 VDD=VDD VSS=VSS
XU157 oai22d1 $PINS A1=HFSNET_26 A2=copt_net_2216 B1=copt_net_2074 B2=HFSNET_30
+ ZN=n374 VDD=VDD VSS=VSS
XU159 oai22d2 $PINS A1=HFSNET_27 A2=copt_net_2074 B1=n288 B2=load_row[10]
+ ZN=n375 VDD=VDD VSS=VSS
XU161 oai22d1 $PINS A1=HFSNET_26 A2=copt_net_1206 B1=copt_net_2630 B2=HFSNET_30
+ ZN=n376 VDD=VDD VSS=VSS
XU163 oai22d1 $PINS A1=HFSNET_25 A2=copt_net_2630 B1=copt_net_1229 B2=HFSNET_29
+ ZN=n377 VDD=VDD VSS=VSS
XU165 oai22d1 $PINS A1=HFSNET_26 A2=copt_net_1228 B1=n631 B2=HFSNET_30 ZN=n378
+ VDD=VDD VSS=VSS
XU167 oai22d1 $PINS A1=HFSNET_28 A2=n631 B1=n288 B2=copt_net_2849 ZN=n379
+ VDD=VDD VSS=VSS
XU169 oai22d1 $PINS A1=HFSNET_27 A2=copt_net_1238 B1=copt_net_2356 B2=HFSNET_31
+ ZN=n380 VDD=VDD VSS=VSS
XU171 oai22d1 $PINS A1=HFSNET_26 A2=copt_net_2355 B1=copt_net_1723 B2=HFSNET_30
+ ZN=n381 VDD=VDD VSS=VSS
XU173 oai22d1 $PINS A1=HFSNET_26 A2=copt_net_1723 B1=copt_net_1188 B2=HFSNET_30
+ ZN=n382 VDD=VDD VSS=VSS
XU175 oai22d1 $PINS A1=HFSNET_26 A2=copt_net_1188 B1=n288 B2=n664 ZN=n383
+ VDD=VDD VSS=VSS
XU177 oai22d1 $PINS A1=HFSNET_27 A2=copt_net_878 B1=n351 B2=HFSNET_31 ZN=n384
+ VDD=VDD VSS=VSS
XU179 oai22d1 $PINS A1=HFSNET_26 A2=n351 B1=copt_net_1299 B2=HFSNET_30 ZN=n385
+ VDD=VDD VSS=VSS
XU181 oai22d1 $PINS A1=HFSNET_26 A2=copt_net_1299 B1=copt_net_1293 B2=HFSNET_30
+ ZN=n386 VDD=VDD VSS=VSS
XU183 oai22d1 $PINS A1=HFSNET_26 A2=copt_net_1293 B1=n288 B2=load_row[13]
+ ZN=n387 VDD=VDD VSS=VSS
XU185 oai22d1 $PINS A1=HFSNET_27 A2=copt_net_1112 B1=n343 B2=HFSNET_31 ZN=n388
+ VDD=VDD VSS=VSS
XU187 oai22d1 $PINS A1=HFSNET_26 A2=n343 B1=copt_net_1476 B2=HFSNET_30 ZN=n389
+ VDD=VDD VSS=VSS
XU189 oai22d1 $PINS A1=HFSNET_26 A2=copt_net_1475 B1=copt_net_1441 B2=HFSNET_30
+ ZN=n390 VDD=VDD VSS=VSS
XU191 oai22d1 $PINS A1=HFSNET_27 A2=copt_net_1441 B1=n288 B2=n666 ZN=n391
+ VDD=VDD VSS=VSS
XU193 oai22d1 $PINS A1=HFSNET_27 A2=copt_net_643 B1=n328 B2=HFSNET_31 ZN=n392
+ VDD=VDD VSS=VSS
XU195 oai22d1 $PINS A1=HFSNET_25 A2=copt_net_2720 B1=copt_net_513 B2=HFSNET_29
+ ZN=n393 VDD=VDD VSS=VSS
XU197 oai22d1 $PINS A1=HFSNET_25 A2=copt_net_513 B1=n325 B2=HFSNET_29 ZN=n394
+ VDD=VDD VSS=VSS
XU199 oai22d1 $PINS A1=HFSNET_25 A2=n325 B1=n288 B2=n667 ZN=n395 VDD=VDD
+ VSS=VSS
XU202 oai22d1 $PINS A1=HFSNET_28 A2=copt_net_1939 B1=copt_net_2544
+ B2=copt_net_237 ZN=n396 VDD=VDD VSS=VSS
XU204 oai22d1 $PINS A1=HFSNET_28 A2=copt_net_2544 B1=copt_net_2562
+ B2=copt_net_237 ZN=n397 VDD=VDD VSS=VSS
XU206 oai22d1 $PINS A1=HFSNET_25 A2=copt_net_2562 B1=copt_net_340 B2=HFSNET_29
+ ZN=n398 VDD=VDD VSS=VSS
XU208 oai22d1 $PINS A1=HFSNET_25 A2=copt_net_340 B1=n298 B2=n668 ZN=n399
+ VDD=VDD VSS=VSS
XU210 oai22d1 $PINS A1=HFSNET_25 A2=copt_net_1860 B1=copt_net_1985 B2=HFSNET_29
+ ZN=n400 VDD=VDD VSS=VSS
XU212 oai22d1 $PINS A1=HFSNET_25 A2=copt_net_1985 B1=copt_net_1158 B2=HFSNET_29
+ ZN=n401 VDD=VDD VSS=VSS
XU214 oai22d1 $PINS A1=HFSNET_26 A2=copt_net_1158 B1=copt_net_1073 B2=HFSNET_30
+ ZN=n402 VDD=VDD VSS=VSS
XU216 oai22d1 $PINS A1=HFSNET_27 A2=copt_net_1074 B1=n298 B2=n669 ZN=n403
+ VDD=VDD VSS=VSS
XU218 oai22d1 $PINS A1=HFSNET_25 A2=copt_net_1225 B1=copt_net_2555 B2=HFSNET_29
+ ZN=n404 VDD=VDD VSS=VSS
XU220 oai22d1 $PINS A1=HFSNET_26 A2=copt_net_2555 B1=copt_net_319 B2=HFSNET_30
+ ZN=n405 VDD=VDD VSS=VSS
XU222 oai22d1 $PINS A1=HFSNET_26 A2=copt_net_319 B1=n311 B2=HFSNET_30 ZN=n406
+ VDD=VDD VSS=VSS
XU224 oai22d1 $PINS A1=HFSNET_26 A2=copt_net_1296 B1=n298 B2=n670 ZN=n407
+ VDD=VDD VSS=VSS
XU226 oai22d1 $PINS A1=HFSNET_25 A2=copt_net_758 B1=copt_net_2631 B2=HFSNET_29
+ ZN=n408 VDD=VDD VSS=VSS
XU228 oai22d1 $PINS A1=HFSNET_25 A2=copt_net_2631 B1=copt_net_1575 B2=HFSNET_29
+ ZN=n409 VDD=VDD VSS=VSS
XU230 oai22d1 $PINS A1=HFSNET_26 A2=copt_net_1575 B1=copt_net_1285 B2=HFSNET_30
+ ZN=n410 VDD=VDD VSS=VSS
XU232 oai22d1 $PINS A1=HFSNET_26 A2=copt_net_1285 B1=n298 B2=n671 ZN=n411
+ VDD=VDD VSS=VSS
XU234 oai22d1 $PINS A1=HFSNET_25 A2=copt_net_1137 B1=copt_net_2424 B2=HFSNET_29
+ ZN=n412 VDD=VDD VSS=VSS
XU236 oai22d1 $PINS A1=HFSNET_26 A2=copt_net_2424 B1=copt_net_710 B2=HFSNET_30
+ ZN=n413 VDD=VDD VSS=VSS
XU238 oai22d1 $PINS A1=HFSNET_26 A2=copt_net_710 B1=copt_net_1128 B2=HFSNET_30
+ ZN=n414 VDD=VDD VSS=VSS
XU240 oai22d1 $PINS A1=HFSNET_26 A2=copt_net_1128 B1=n298 B2=n672 ZN=n415
+ VDD=VDD VSS=VSS
XU242 oai22d1 $PINS A1=HFSNET_28 A2=copt_net_2664 B1=copt_net_2447
+ B2=copt_net_237 ZN=n416 VDD=VDD VSS=VSS
XU244 oai22d1 $PINS A1=HFSNET_28 A2=copt_net_2447 B1=n299 B2=copt_net_237
+ ZN=n417 VDD=VDD VSS=VSS
XU246 oai22d1 $PINS A1=HFSNET_25 A2=n299 B1=copt_net_1376 B2=HFSNET_29 ZN=n418
+ VDD=VDD VSS=VSS
XU248 oai22d1 $PINS A1=HFSNET_25 A2=copt_net_1376 B1=n298 B2=n673 ZN=n419
+ VDD=VDD VSS=VSS
XU250 oai22d1 $PINS A1=HFSNET_25 A2=copt_net_1432 B1=copt_net_1429 B2=HFSNET_29
+ ZN=n420 VDD=VDD VSS=VSS
XU252 oai22d1 $PINS A1=HFSNET_25 A2=copt_net_1429 B1=copt_net_2482 B2=HFSNET_29
+ ZN=n421 VDD=VDD VSS=VSS
XU254 oai22d1 $PINS A1=HFSNET_25 A2=copt_net_2482 B1=copt_net_733 B2=HFSNET_29
+ ZN=n422 VDD=VDD VSS=VSS
XU256 oai22d1 $PINS A1=HFSNET_25 A2=copt_net_733 B1=n298 B2=n674 ZN=n423
+ VDD=VDD VSS=VSS
XU258 oai22d1 $PINS A1=HFSNET_28 A2=copt_net_2536 B1=copt_net_2681
+ B2=copt_net_237 ZN=n424 VDD=VDD VSS=VSS
XU260 oai22d1 $PINS A1=HFSNET_28 A2=copt_net_2681 B1=n290 B2=copt_net_237
+ ZN=n425 VDD=VDD VSS=VSS
XU262 oai22d1 $PINS A1=HFSNET_25 A2=n290 B1=copt_net_1263 B2=HFSNET_29 ZN=n426
+ VDD=VDD VSS=VSS
XU264 oai22d2 $PINS A1=HFSNET_25 A2=copt_net_1263 B1=n298 B2=n675 ZN=n427
+ VDD=VDD VSS=VSS
XU267 oai22d1 $PINS A1=HFSNET_28 A2=copt_net_2463 B1=copt_net_2007
+ B2=copt_net_237 ZN=n428 VDD=VDD VSS=VSS
XU269 oai22d1 $PINS A1=HFSNET_25 A2=copt_net_2007 B1=copt_net_2510 B2=HFSNET_29
+ ZN=n429 VDD=VDD VSS=VSS
XU271 oai22d1 $PINS A1=HFSNET_25 A2=copt_net_2510 B1=copt_net_1440 B2=HFSNET_29
+ ZN=n430 VDD=VDD VSS=VSS
XU273 oai22d1 $PINS A1=HFSNET_28 A2=copt_net_1440 B1=n308 B2=n676 ZN=n431
+ VDD=VDD VSS=VSS
XU275 oai22d1 $PINS A1=HFSNET_25 A2=copt_net_2065 B1=copt_net_2231 B2=HFSNET_29
+ ZN=n432 VDD=VDD VSS=VSS
XU277 oai22d1 $PINS A1=HFSNET_25 A2=copt_net_2231 B1=n280 B2=HFSNET_29 ZN=n433
+ VDD=VDD VSS=VSS
XU279 oai22d1 $PINS A1=HFSNET_25 A2=n280 B1=copt_net_1675 B2=HFSNET_29 ZN=n434
+ VDD=VDD VSS=VSS
XU281 oai22d1 $PINS A1=HFSNET_28 A2=copt_net_1675 B1=n308 B2=n677 ZN=n435
+ VDD=VDD VSS=VSS
XU283 oai22d1 $PINS A1=HFSNET_28 A2=copt_net_2092 B1=n277 B2=copt_net_237
+ ZN=n436 VDD=VDD VSS=VSS
XU285 oai22d1 $PINS A1=HFSNET_28 A2=n277 B1=n276 B2=copt_net_237 ZN=n437
+ VDD=VDD VSS=VSS
XU287 oai22d1 $PINS A1=HFSNET_28 A2=n276 B1=copt_net_994 B2=copt_net_237
+ ZN=n438 VDD=VDD VSS=VSS
XU289 oai22d1 $PINS A1=HFSNET_24 A2=copt_net_994 B1=n308 B2=n678 ZN=n439
+ VDD=VDD VSS=VSS
XU291 oai22d1 $PINS A1=HFSNET_28 A2=copt_net_2551 B1=copt_net_2154 B2=HFSNET_29
+ ZN=n440 VDD=VDD VSS=VSS
XU293 oai22d1 $PINS A1=HFSNET_25 A2=copt_net_2154 B1=copt_net_2467 B2=HFSNET_29
+ ZN=n441 VDD=VDD VSS=VSS
XU295 oai22d1 $PINS A1=HFSNET_28 A2=copt_net_2467 B1=copt_net_1116
+ B2=copt_net_237 ZN=n442 VDD=VDD VSS=VSS
XU297 oai22d1 $PINS A1=HFSNET_28 A2=copt_net_1116 B1=n308 B2=n679 ZN=n443
+ VDD=VDD VSS=VSS
XU299 oai22d1 $PINS A1=HFSNET_28 A2=copt_net_1040 B1=n269 B2=copt_net_237
+ ZN=n444 VDD=VDD VSS=VSS
XU301 oai22d1 $PINS A1=HFSNET_24 A2=copt_net_2709 B1=copt_net_2573
+ B2=copt_net_237 ZN=n445 VDD=VDD VSS=VSS
XU303 oai22d1 $PINS A1=HFSNET_24 A2=copt_net_2573 B1=copt_net_1540
+ B2=copt_net_237 ZN=n446 VDD=VDD VSS=VSS
XU305 oai22d1 $PINS A1=HFSNET_28 A2=copt_net_1540 B1=n308 B2=n680 ZN=n447
+ VDD=VDD VSS=VSS
XU307 oai22d1 $PINS A1=HFSNET_28 A2=copt_net_2146 B1=copt_net_2448
+ B2=copt_net_237 ZN=n448 VDD=VDD VSS=VSS
XU309 oai22d1 $PINS A1=HFSNET_28 A2=copt_net_2448 B1=copt_net_1291
+ B2=copt_net_237 ZN=n449 VDD=VDD VSS=VSS
XU311 oai22d1 $PINS A1=HFSNET_24 A2=copt_net_1291 B1=copt_net_1191
+ B2=copt_net_237 ZN=n450 VDD=VDD VSS=VSS
XU313 oai22d1 $PINS A1=HFSNET_24 A2=copt_net_1191 B1=n308 B2=n681 ZN=n451
+ VDD=VDD VSS=VSS
XU315 oai22d1 $PINS A1=HFSNET_28 A2=copt_net_1308 B1=copt_net_2684
+ B2=copt_net_237 ZN=n452 VDD=VDD VSS=VSS
XU317 oai22d1 $PINS A1=HFSNET_28 A2=copt_net_2684 B1=copt_net_355
+ B2=copt_net_237 ZN=n453 VDD=VDD VSS=VSS
XU319 oai22d1 $PINS A1=HFSNET_28 A2=copt_net_355 B1=copt_net_1437
+ B2=copt_net_237 ZN=n454 VDD=VDD VSS=VSS
XU321 oai22d1 $PINS A1=HFSNET_28 A2=copt_net_1437 B1=n308 B2=n682 ZN=n455
+ VDD=VDD VSS=VSS
XU323 oai22d1 $PINS A1=HFSNET_28 A2=copt_net_2166 B1=copt_net_2729
+ B2=copt_net_237 ZN=n456 VDD=VDD VSS=VSS
XU325 oai22d1 $PINS A1=HFSNET_28 A2=copt_net_2729 B1=copt_net_2692
+ B2=copt_net_237 ZN=n457 VDD=VDD VSS=VSS
XU327 oai22d1 $PINS A1=HFSNET_28 A2=copt_net_2692 B1=copt_net_728
+ B2=copt_net_237 ZN=n458 VDD=VDD VSS=VSS
XU329 oai22d1 $PINS A1=HFSNET_24 A2=copt_net_728 B1=n308 B2=n683 ZN=n459
+ VDD=VDD VSS=VSS
XU332 oai22d1 $PINS A1=HFSNET_27 A2=copt_net_1936 B1=n253 B2=HFSNET_31 ZN=n460
+ VDD=VDD VSS=VSS
XU334 oai22d1 $PINS A1=HFSNET_27 A2=n253 B1=copt_net_2504 B2=HFSNET_31 ZN=n461
+ VDD=VDD VSS=VSS
XU336 oai22d1 $PINS A1=HFSNET_27 A2=copt_net_2504 B1=copt_net_1290 B2=HFSNET_31
+ ZN=n462 VDD=VDD VSS=VSS
XU338 oai22d1 $PINS A1=HFSNET_27 A2=copt_net_1290 B1=n318 B2=n652 ZN=n463
+ VDD=VDD VSS=VSS
XU340 oai22d1 $PINS A1=HFSNET_27 A2=copt_net_1642 B1=copt_net_2163 B2=HFSNET_31
+ ZN=n464 VDD=VDD VSS=VSS
XU342 oai22d1 $PINS A1=HFSNET_27 A2=copt_net_2163 B1=n248 B2=HFSNET_31 ZN=n465
+ VDD=VDD VSS=VSS
XU344 oai22d1 $PINS A1=HFSNET_27 A2=n248 B1=copt_net_1257 B2=HFSNET_31 ZN=n466
+ VDD=VDD VSS=VSS
XU346 oai22d1 $PINS A1=HFSNET_27 A2=copt_net_1257 B1=n318 B2=n654 ZN=n467
+ VDD=VDD VSS=VSS
XU348 oai22d1 $PINS A1=HFSNET_27 A2=copt_net_1882 B1=n245 B2=HFSNET_31 ZN=n468
+ VDD=VDD VSS=VSS
XU350 oai22d1 $PINS A1=HFSNET_27 A2=n245 B1=copt_net_1515 B2=HFSNET_31 ZN=n469
+ VDD=VDD VSS=VSS
XU352 oai22d1 $PINS A1=HFSNET_27 A2=copt_net_1515 B1=copt_net_1658 B2=HFSNET_31
+ ZN=n470 VDD=VDD VSS=VSS
XU354 oai22d1 $PINS A1=HFSNET_27 A2=copt_net_1658 B1=n318 B2=n655 ZN=n471
+ VDD=VDD VSS=VSS
XU356 oai22d1 $PINS A1=HFSNET_27 A2=copt_net_1496 B1=copt_net_2535 B2=HFSNET_31
+ ZN=n472 VDD=VDD VSS=VSS
XU358 oai22d1 $PINS A1=HFSNET_28 A2=copt_net_2535 B1=copt_net_2772
+ B2=copt_net_237 ZN=n473 VDD=VDD VSS=VSS
XU360 oai22d1 $PINS A1=HFSNET_24 A2=copt_net_2772 B1=copt_net_2502
+ B2=copt_net_237 ZN=n474 VDD=VDD VSS=VSS
XU362 oai22d1 $PINS A1=HFSNET_24 A2=copt_net_2502 B1=n318 B2=HFSNET_13 ZN=n475
+ VDD=VDD VSS=VSS
XU364 oai22d1 $PINS A1=HFSNET_28 A2=copt_net_2593 B1=copt_net_2759
+ B2=copt_net_237 ZN=n476 VDD=VDD VSS=VSS
XU366 oai22d1 $PINS A1=HFSNET_28 A2=copt_net_2759 B1=n236 B2=copt_net_237
+ ZN=n477 VDD=VDD VSS=VSS
XU368 oai22d1 $PINS A1=HFSNET_24 A2=n236 B1=n318 B2=n657 ZN=n478 VDD=VDD
+ VSS=VSS
XU370 oai22d1 $PINS A1=HFSNET_24 A2=copt_net_1307 B1=copt_net_1638
+ B2=copt_net_237 ZN=n479 VDD=VDD VSS=VSS
XU372 oai22d1 $PINS A1=HFSNET_24 A2=copt_net_1638 B1=copt_net_1331
+ B2=copt_net_237 ZN=n480 VDD=VDD VSS=VSS
XU374 oai22d1 $PINS A1=HFSNET_24 A2=copt_net_1331 B1=n318 B2=n658 ZN=n481
+ VDD=VDD VSS=VSS
XU376 oai22d1 $PINS A1=HFSNET_27 A2=n232 B1=copt_net_2209 B2=HFSNET_31 ZN=n482
+ VDD=VDD VSS=VSS
XU378 oai22d1 $PINS A1=HFSNET_27 A2=copt_net_2209 B1=copt_net_2548 B2=HFSNET_31
+ ZN=n483 VDD=VDD VSS=VSS
XU380 oai22d1 $PINS A1=HFSNET_27 A2=copt_net_2548 B1=n318 B2=n659 ZN=n484
+ VDD=VDD VSS=VSS
XU382 oai22d1 $PINS A1=HFSNET_27 A2=copt_net_1365 B1=copt_net_1329 B2=HFSNET_31
+ ZN=n485 VDD=VDD VSS=VSS
XU384 oai22d1 $PINS A1=HFSNET_27 A2=copt_net_1328 B1=copt_net_2124 B2=HFSNET_31
+ ZN=n486 VDD=VDD VSS=VSS
XU386 oai22d2 $PINS A1=HFSNET_27 A2=copt_net_2124 B1=gre_a_INV_127_3
+ B2=HFSNET_31 ZN=n487 VDD=VDD VSS=VSS
XU388 oai22d1 $PINS A1=HFSNET_27 A2=gre_a_INV_127_3 B1=n318 B2=HFSNET_15
+ ZN=n488 VDD=VDD VSS=VSS
XU392 nd13d1 $PINS A1=copt_net_2726 A2=load_busy_gOb4 A3=HFSNET_41 ZN=n287
+ VDD=VDD VSS=VSS
XU393 oai22d1 $PINS A1=HFSNET_18 A2=copt_net_1217 B1=copt_net_1338 B2=n329
+ ZN=n489 VDD=VDD VSS=VSS
XU395 oai22d1 $PINS A1=HFSNET_18 A2=copt_net_1789 B1=n107 B2=n329 ZN=n490
+ VDD=VDD VSS=VSS
XU397 oai22d1 $PINS A1=HFSNET_16 A2=copt_net_1992 B1=copt_net_1924 B2=HFSNET_23
+ ZN=n491 VDD=VDD VSS=VSS
XU399 oai22d1 $PINS A1=HFSNET_19 A2=copt_net_1090 B1=copt_net_2237 B2=HFSNET_21
+ ZN=n492 VDD=VDD VSS=VSS
XU401 oai22d1 $PINS A1=HFSNET_19 A2=copt_net_2237 B1=copt_net_2208 B2=HFSNET_21
+ ZN=n493 VDD=VDD VSS=VSS
XU403 oai22d1 $PINS A1=HFSNET_19 A2=copt_net_2208 B1=copt_net_1178 B2=HFSNET_21
+ ZN=n494 VDD=VDD VSS=VSS
XU405 oai22d1 $PINS A1=HFSNET_19 A2=copt_net_1178 B1=load_row[8] B2=n330
+ ZN=n495 VDD=VDD VSS=VSS
XU408 oai22d1 $PINS A1=HFSNET_19 A2=copt_net_1682 B1=n217 B2=HFSNET_21 ZN=n496
+ VDD=VDD VSS=VSS
XU410 oai22d1 $PINS A1=HFSNET_19 A2=n217 B1=copt_net_1564 B2=HFSNET_21 ZN=n497
+ VDD=VDD VSS=VSS
XU412 oai22d1 $PINS A1=HFSNET_19 A2=copt_net_1564 B1=copt_net_1602 B2=HFSNET_21
+ ZN=n498 VDD=VDD VSS=VSS
XU414 oai22d1 $PINS A1=HFSNET_19 A2=copt_net_1601 B1=load_row[9] B2=n330
+ ZN=n499 VDD=VDD VSS=VSS
XU417 oai22d1 $PINS A1=HFSNET_19 A2=copt_net_1982 B1=copt_net_2100 B2=HFSNET_21
+ ZN=n500 VDD=VDD VSS=VSS
XU419 oai22d1 $PINS A1=HFSNET_19 A2=copt_net_2100 B1=copt_net_1871 B2=HFSNET_21
+ ZN=n501 VDD=VDD VSS=VSS
XU421 oai22d1 $PINS A1=HFSNET_19 A2=copt_net_1871 B1=copt_net_1407 B2=HFSNET_21
+ ZN=n502 VDD=VDD VSS=VSS
XU423 oai22d2 $PINS A1=HFSNET_19 A2=copt_net_1407 B1=load_row[10] B2=n330
+ ZN=n503 VDD=VDD VSS=VSS
XU426 oai22d1 $PINS A1=HFSNET_19 A2=copt_net_2444 B1=copt_net_1316 B2=HFSNET_21
+ ZN=n504 VDD=VDD VSS=VSS
XU428 oai22d1 $PINS A1=HFSNET_19 A2=copt_net_1316 B1=copt_net_1553 B2=HFSNET_21
+ ZN=n505 VDD=VDD VSS=VSS
XU430 oai22d1 $PINS A1=HFSNET_19 A2=copt_net_1553 B1=n207 B2=HFSNET_21 ZN=n506
+ VDD=VDD VSS=VSS
XU432 oai22d1 $PINS A1=HFSNET_19 A2=n207 B1=copt_net_2849 B2=n330 ZN=n507
+ VDD=VDD VSS=VSS
XU435 oai22d1 $PINS A1=HFSNET_19 A2=copt_net_2479 B1=copt_net_1821 B2=HFSNET_21
+ ZN=n508 VDD=VDD VSS=VSS
XU437 oai22d1 $PINS A1=HFSNET_19 A2=copt_net_1821 B1=n204 B2=HFSNET_21 ZN=n509
+ VDD=VDD VSS=VSS
XU439 oai22d1 $PINS A1=HFSNET_19 A2=n204 B1=copt_net_1237 B2=HFSNET_21 ZN=n510
+ VDD=VDD VSS=VSS
XU441 oai22d4 $PINS A1=HFSNET_19 A2=copt_net_1237 B1=n664 B2=n330 ZN=n511
+ VDD=VDD VSS=VSS
XU444 oai22d1 $PINS A1=HFSNET_19 A2=copt_net_1580 B1=copt_net_2550 B2=HFSNET_21
+ ZN=n512 VDD=VDD VSS=VSS
XU446 oai22d1 $PINS A1=HFSNET_19 A2=copt_net_2550 B1=n200 B2=HFSNET_21 ZN=n513
+ VDD=VDD VSS=VSS
XU448 oai22d1 $PINS A1=HFSNET_19 A2=n200 B1=copt_net_1872 B2=HFSNET_21 ZN=n514
+ VDD=VDD VSS=VSS
XU450 oai22d1 $PINS A1=HFSNET_19 A2=copt_net_1872 B1=load_row[13] B2=n330
+ ZN=n515 VDD=VDD VSS=VSS
XU453 oai22d1 $PINS A1=HFSNET_19 A2=copt_net_2546 B1=copt_net_1635 B2=HFSNET_21
+ ZN=n516 VDD=VDD VSS=VSS
XU455 oai22d1 $PINS A1=HFSNET_19 A2=copt_net_1634 B1=copt_net_2506 B2=HFSNET_21
+ ZN=n517 VDD=VDD VSS=VSS
XU457 oai22d1 $PINS A1=HFSNET_19 A2=copt_net_2506 B1=copt_net_1288 B2=HFSNET_21
+ ZN=n518 VDD=VDD VSS=VSS
XU459 oai22d1 $PINS A1=HFSNET_16 A2=copt_net_1288 B1=n666 B2=n330 ZN=n519
+ VDD=VDD VSS=VSS
XU462 oai22d1 $PINS A1=HFSNET_18 A2=copt_net_1241 B1=n193 B2=n329 ZN=n520
+ VDD=VDD VSS=VSS
XU464 oai22d1 $PINS A1=HFSNET_17 A2=copt_net_2620 B1=copt_net_1994 B2=HFSNET_22
+ ZN=n521 VDD=VDD VSS=VSS
XU466 oai22d1 $PINS A1=HFSNET_17 A2=copt_net_1994 B1=copt_net_2191 B2=HFSNET_22
+ ZN=n522 VDD=VDD VSS=VSS
XU468 oai22d1 $PINS A1=HFSNET_18 A2=copt_net_2191 B1=n667 B2=n330 ZN=n523
+ VDD=VDD VSS=VSS
XU472 oai22d1 $PINS A1=HFSNET_18 A2=copt_net_2021 B1=copt_net_2011 B2=n329
+ ZN=n524 VDD=VDD VSS=VSS
XU474 oai22d1 $PINS A1=HFSNET_18 A2=copt_net_2011 B1=copt_net_1024 B2=n329
+ ZN=n525 VDD=VDD VSS=VSS
XU476 oai22d1 $PINS A1=HFSNET_18 A2=copt_net_1024 B1=copt_net_1274 B2=n329
+ ZN=n526 VDD=VDD VSS=VSS
XU478 oai22d1 $PINS A1=HFSNET_17 A2=copt_net_1274 B1=n668 B2=n331 ZN=n527
+ VDD=VDD VSS=VSS
XU481 oai22d1 $PINS A1=HFSNET_17 A2=copt_net_2093 B1=copt_net_1889 B2=HFSNET_22
+ ZN=n528 VDD=VDD VSS=VSS
XU483 oai22d1 $PINS A1=HFSNET_17 A2=copt_net_1889 B1=copt_net_2353 B2=HFSNET_22
+ ZN=n529 VDD=VDD VSS=VSS
XU485 oai22d1 $PINS A1=HFSNET_19 A2=copt_net_2353 B1=copt_net_1348 B2=HFSNET_21
+ ZN=n530 VDD=VDD VSS=VSS
XU487 oai22d1 $PINS A1=HFSNET_19 A2=copt_net_1348 B1=n669 B2=n331 ZN=n531
+ VDD=VDD VSS=VSS
XU490 oai22d1 $PINS A1=HFSNET_17 A2=copt_net_1917 B1=copt_net_2339 B2=HFSNET_22
+ ZN=n532 VDD=VDD VSS=VSS
XU492 oai22d1 $PINS A1=HFSNET_19 A2=copt_net_2339 B1=copt_net_2035 B2=HFSNET_21
+ ZN=n533 VDD=VDD VSS=VSS
XU494 oai22d1 $PINS A1=HFSNET_19 A2=copt_net_2035 B1=copt_net_1269 B2=HFSNET_21
+ ZN=n534 VDD=VDD VSS=VSS
XU496 oai22d1 $PINS A1=HFSNET_19 A2=copt_net_1269 B1=n670 B2=n331 ZN=n535
+ VDD=VDD VSS=VSS
XU499 oai22d1 $PINS A1=HFSNET_17 A2=n178 B1=copt_net_1506 B2=HFSNET_22 ZN=n536
+ VDD=VDD VSS=VSS
XU501 oai22d1 $PINS A1=HFSNET_17 A2=copt_net_1506 B1=copt_net_1327 B2=HFSNET_22
+ ZN=n537 VDD=VDD VSS=VSS
XU503 oai22d1 $PINS A1=HFSNET_17 A2=copt_net_1327 B1=copt_net_1375 B2=HFSNET_22
+ ZN=n538 VDD=VDD VSS=VSS
XU505 oai22d1 $PINS A1=HFSNET_17 A2=copt_net_1375 B1=n671 B2=n331 ZN=n539
+ VDD=VDD VSS=VSS
XU508 oai22d1 $PINS A1=HFSNET_17 A2=copt_net_2024 B1=copt_net_1409 B2=HFSNET_22
+ ZN=n540 VDD=VDD VSS=VSS
XU510 oai22d1 $PINS A1=HFSNET_17 A2=copt_net_1408 B1=n172 B2=HFSNET_22 ZN=n541
+ VDD=VDD VSS=VSS
XU512 oai22d1 $PINS A1=HFSNET_17 A2=n172 B1=copt_net_1261 B2=HFSNET_22 ZN=n542
+ VDD=VDD VSS=VSS
XU514 oai22d1 $PINS A1=HFSNET_17 A2=copt_net_1261 B1=n672 B2=n331 ZN=n543
+ VDD=VDD VSS=VSS
XU517 oai22d1 $PINS A1=HFSNET_17 A2=copt_net_2116 B1=copt_net_2193 B2=HFSNET_22
+ ZN=n544 VDD=VDD VSS=VSS
XU519 oai22d1 $PINS A1=HFSNET_17 A2=copt_net_2193 B1=copt_net_1006 B2=HFSNET_22
+ ZN=n545 VDD=VDD VSS=VSS
XU521 oai22d1 $PINS A1=HFSNET_17 A2=copt_net_1006 B1=copt_net_1311 B2=HFSNET_22
+ ZN=n546 VDD=VDD VSS=VSS
XU523 oai22d1 $PINS A1=HFSNET_17 A2=copt_net_1311 B1=n673 B2=n331 ZN=n547
+ VDD=VDD VSS=VSS
XU526 oai22d1 $PINS A1=HFSNET_17 A2=copt_net_2067 B1=n165 B2=HFSNET_22 ZN=n548
+ VDD=VDD VSS=VSS
XU528 oai22d1 $PINS A1=HFSNET_17 A2=n165 B1=copt_net_1698 B2=HFSNET_22 ZN=n549
+ VDD=VDD VSS=VSS
XU530 oai22d1 $PINS A1=HFSNET_17 A2=copt_net_1698 B1=copt_net_1337 B2=HFSNET_22
+ ZN=n550 VDD=VDD VSS=VSS
XU532 oai22d1 $PINS A1=HFSNET_17 A2=copt_net_1337 B1=n674 B2=n331 ZN=n551
+ VDD=VDD VSS=VSS
XU535 oai22d1 $PINS A1=HFSNET_17 A2=copt_net_1976 B1=copt_net_1539 B2=HFSNET_22
+ ZN=n552 VDD=VDD VSS=VSS
XU537 oai22d1 $PINS A1=HFSNET_17 A2=copt_net_1539 B1=n160 B2=HFSNET_22 ZN=n553
+ VDD=VDD VSS=VSS
XU539 oai22d1 $PINS A1=HFSNET_17 A2=n160 B1=copt_net_1162 B2=HFSNET_22 ZN=n554
+ VDD=VDD VSS=VSS
XU541 oai22d1 $PINS A1=HFSNET_17 A2=copt_net_1162 B1=n675 B2=n331 ZN=n555
+ VDD=VDD VSS=VSS
XU544 oai221d1 $PINS B1=load_n[0] B2=n333 C1=copt_net_1849 C2=n334 A=n92
+ ZN=n332 VDD=VDD VSS=VSS
XU548 oai22d1 $PINS A1=HFSNET_17 A2=copt_net_2169 B1=n157 B2=HFSNET_22 ZN=n556
+ VDD=VDD VSS=VSS
XU550 oai22d1 $PINS A1=HFSNET_17 A2=n157 B1=copt_net_2155 B2=HFSNET_22 ZN=n557
+ VDD=VDD VSS=VSS
XU552 oai22d1 $PINS A1=HFSNET_17 A2=copt_net_2155 B1=copt_net_1143 B2=HFSNET_22
+ ZN=n558 VDD=VDD VSS=VSS
XU554 oai22d1 $PINS A1=HFSNET_17 A2=copt_net_1143 B1=n676 B2=n336 ZN=n559
+ VDD=VDD VSS=VSS
XU557 oai22d1 $PINS A1=HFSNET_17 A2=copt_net_2030 B1=copt_net_2150 B2=HFSNET_22
+ ZN=n560 VDD=VDD VSS=VSS
XU559 oai22d1 $PINS A1=HFSNET_17 A2=copt_net_2149 B1=copt_net_1835 B2=HFSNET_22
+ ZN=n561 VDD=VDD VSS=VSS
XU561 oai22d1 $PINS A1=HFSNET_17 A2=copt_net_1836 B1=copt_net_1081 B2=HFSNET_22
+ ZN=n562 VDD=VDD VSS=VSS
XU563 oai22d1 $PINS A1=HFSNET_17 A2=copt_net_1082 B1=n677 B2=n336 ZN=n563
+ VDD=VDD VSS=VSS
XU566 oai22d1 $PINS A1=HFSNET_18 A2=copt_net_1979 B1=copt_net_2346 B2=n329
+ ZN=n564 VDD=VDD VSS=VSS
XU568 oai22d1 $PINS A1=HFSNET_18 A2=copt_net_2346 B1=copt_net_1665 B2=n329
+ ZN=n565 VDD=VDD VSS=VSS
XU570 oai22d1 $PINS A1=HFSNET_18 A2=copt_net_1665 B1=copt_net_1302 B2=n329
+ ZN=n566 VDD=VDD VSS=VSS
XU572 oai22d1 $PINS A1=HFSNET_18 A2=copt_net_1302 B1=n678 B2=n336 ZN=n567
+ VDD=VDD VSS=VSS
XU575 oai22d1 $PINS A1=HFSNET_17 A2=copt_net_1941 B1=copt_net_2347 B2=HFSNET_22
+ ZN=n568 VDD=VDD VSS=VSS
XU577 oai22d1 $PINS A1=HFSNET_17 A2=copt_net_2347 B1=copt_net_1508 B2=HFSNET_22
+ ZN=n569 VDD=VDD VSS=VSS
XU579 oai22d1 $PINS A1=HFSNET_17 A2=copt_net_1508 B1=n143 B2=HFSNET_22 ZN=n570
+ VDD=VDD VSS=VSS
XU581 oai22d1 $PINS A1=HFSNET_18 A2=n143 B1=n679 B2=n336 ZN=n571 VDD=VDD
+ VSS=VSS
XU584 oai22d1 $PINS A1=HFSNET_18 A2=copt_net_2164 B1=copt_net_2224 B2=n329
+ ZN=n572 VDD=VDD VSS=VSS
XU586 oai22d1 $PINS A1=HFSNET_18 A2=copt_net_2224 B1=copt_net_1947 B2=n329
+ ZN=n573 VDD=VDD VSS=VSS
XU588 oai22d1 $PINS A1=HFSNET_18 A2=copt_net_1947 B1=copt_net_1174 B2=n329
+ ZN=n574 VDD=VDD VSS=VSS
XU590 oai22d1 $PINS A1=HFSNET_18 A2=copt_net_1174 B1=n680 B2=n336 ZN=n575
+ VDD=VDD VSS=VSS
XU593 oai22d1 $PINS A1=HFSNET_18 A2=copt_net_1851 B1=copt_net_2012 B2=n329
+ ZN=n576 VDD=VDD VSS=VSS
XU595 oai22d1 $PINS A1=HFSNET_18 A2=copt_net_2012 B1=copt_net_2350 B2=n329
+ ZN=n577 VDD=VDD VSS=VSS
XU597 oai22d1 $PINS A1=HFSNET_18 A2=copt_net_2350 B1=copt_net_1111 B2=n329
+ ZN=n578 VDD=VDD VSS=VSS
XU599 oai22d1 $PINS A1=HFSNET_18 A2=copt_net_1111 B1=n681 B2=n336 ZN=n579
+ VDD=VDD VSS=VSS
XU602 oai22d1 $PINS A1=HFSNET_18 A2=copt_net_2066 B1=copt_net_1118 B2=n329
+ ZN=n580 VDD=VDD VSS=VSS
XU604 oai22d1 $PINS A1=HFSNET_18 A2=copt_net_1118 B1=copt_net_2619 B2=n329
+ ZN=n581 VDD=VDD VSS=VSS
XU606 oai22d1 $PINS A1=HFSNET_18 A2=copt_net_2619 B1=copt_net_486 B2=n329
+ ZN=n582 VDD=VDD VSS=VSS
XU608 oai22d1 $PINS A1=HFSNET_18 A2=copt_net_486 B1=n682 B2=n336 ZN=n583
+ VDD=VDD VSS=VSS
XU611 oai22d1 $PINS A1=HFSNET_18 A2=copt_net_2117 B1=copt_net_2632 B2=n329
+ ZN=n584 VDD=VDD VSS=VSS
XU613 oai22d1 $PINS A1=HFSNET_18 A2=copt_net_2632 B1=copt_net_853 B2=n329
+ ZN=n585 VDD=VDD VSS=VSS
XU615 oai22d1 $PINS A1=HFSNET_18 A2=copt_net_853 B1=copt_net_1232 B2=n329
+ ZN=n586 VDD=VDD VSS=VSS
XU617 oai22d1 $PINS A1=HFSNET_18 A2=copt_net_1231 B1=n683 B2=n336 ZN=n587
+ VDD=VDD VSS=VSS
XU622 oai22d1 $PINS A1=HFSNET_18 A2=copt_net_1301 B1=copt_net_1902 B2=n329
+ ZN=n588 VDD=VDD VSS=VSS
XU624 oai22d1 $PINS A1=HFSNET_16 A2=copt_net_1902 B1=copt_net_1911 B2=HFSNET_23
+ ZN=n589 VDD=VDD VSS=VSS
XU626 oai22d1 $PINS A1=HFSNET_16 A2=copt_net_1911 B1=copt_net_1454 B2=HFSNET_23
+ ZN=n590 VDD=VDD VSS=VSS
XU628 oai22d1 $PINS A1=HFSNET_16 A2=copt_net_1454 B1=n652 B2=n338 ZN=n591
+ VDD=VDD VSS=VSS
XU631 oai22d1 $PINS A1=HFSNET_16 A2=copt_net_2112 B1=copt_net_1483 B2=HFSNET_23
+ ZN=n592 VDD=VDD VSS=VSS
XU633 oai22d1 $PINS A1=HFSNET_16 A2=copt_net_1483 B1=copt_net_2125 B2=HFSNET_23
+ ZN=n593 VDD=VDD VSS=VSS
XU635 oai22d1 $PINS A1=HFSNET_16 A2=copt_net_2125 B1=copt_net_2404 B2=HFSNET_23
+ ZN=n594 VDD=VDD VSS=VSS
XU637 oai22d2 $PINS A1=HFSNET_16 A2=copt_net_2404 B1=n654 B2=n338 ZN=n595
+ VDD=VDD VSS=VSS
XU640 oai22d1 $PINS A1=HFSNET_16 A2=copt_net_2581 B1=copt_net_946 B2=HFSNET_23
+ ZN=n596 VDD=VDD VSS=VSS
XU642 oai22d1 $PINS A1=HFSNET_16 A2=copt_net_946 B1=copt_net_1864 B2=HFSNET_23
+ ZN=n597 VDD=VDD VSS=VSS
XU644 oai22d1 $PINS A1=HFSNET_16 A2=copt_net_1864 B1=copt_gre_net_3203
+ B2=HFSNET_23 ZN=n598 VDD=VDD VSS=VSS
XU646 oai22d1 $PINS A1=HFSNET_16 A2=copt_gre_net_3203 B1=n655 B2=n338 ZN=n599
+ VDD=VDD VSS=VSS
XU649 oai22d1 $PINS A1=HFSNET_16 A2=copt_net_1549 B1=copt_net_1898 B2=HFSNET_23
+ ZN=n600 VDD=VDD VSS=VSS
XU651 oai22d1 $PINS A1=HFSNET_16 A2=copt_net_1898 B1=copt_net_2079 B2=HFSNET_23
+ ZN=n601 VDD=VDD VSS=VSS
XU653 oai22d1 $PINS A1=HFSNET_16 A2=copt_net_2079 B1=copt_net_1009 B2=HFSNET_23
+ ZN=n602 VDD=VDD VSS=VSS
XU655 oai22d1 $PINS A1=HFSNET_16 A2=copt_net_1009 B1=HFSNET_13 B2=n338 ZN=n603
+ VDD=VDD VSS=VSS
XU658 oai22d1 $PINS A1=HFSNET_18 A2=copt_net_1338 B1=copt_net_1163 B2=n329
+ ZN=n604 VDD=VDD VSS=VSS
XU660 oai22d1 $PINS A1=HFSNET_18 A2=copt_net_1163 B1=copt_net_1230 B2=n329
+ ZN=n605 VDD=VDD VSS=VSS
XU662 oai22d1 $PINS A1=HFSNET_16 A2=copt_net_1230 B1=n657 B2=n338 ZN=n606
+ VDD=VDD VSS=VSS
XU665 oai22d1 $PINS A1=HFSNET_16 A2=n107 B1=copt_net_1403 B2=HFSNET_23 ZN=n607
+ VDD=VDD VSS=VSS
XU667 oai22d1 $PINS A1=HFSNET_16 A2=copt_net_1402 B1=copt_net_2561 B2=HFSNET_23
+ ZN=n608 VDD=VDD VSS=VSS
XU669 oai22d1 $PINS A1=HFSNET_16 A2=copt_net_2561 B1=n658 B2=n338 ZN=n609
+ VDD=VDD VSS=VSS
XU672 oai22d1 $PINS A1=HFSNET_16 A2=copt_net_1924 B1=copt_net_1651 B2=HFSNET_23
+ ZN=n610 VDD=VDD VSS=VSS
XU674 oai22d1 $PINS A1=HFSNET_16 A2=copt_net_1651 B1=copt_net_1582 B2=HFSNET_23
+ ZN=n611 VDD=VDD VSS=VSS
XU676 oai22d1 $PINS A1=HFSNET_16 A2=copt_net_1582 B1=n659 B2=n338 ZN=n612
+ VDD=VDD VSS=VSS
XU679 oai22d1 $PINS A1=HFSNET_16 A2=copt_net_2080 B1=n100 B2=HFSNET_23 ZN=n613
+ VDD=VDD VSS=VSS
XU681 oai22d1 $PINS A1=HFSNET_16 A2=n100 B1=copt_net_2310 B2=HFSNET_23 ZN=n614
+ VDD=VDD VSS=VSS
XU683 oai22d1 $PINS A1=HFSNET_16 A2=copt_net_2310 B1=copt_net_1245 B2=HFSNET_23
+ ZN=n615 VDD=VDD VSS=VSS
XU685 oai22d1 $PINS A1=HFSNET_16 A2=copt_net_1245 B1=HFSNET_15 B2=n338 ZN=n616
+ VDD=VDD VSS=VSS
XU687 oai21d1 $PINS B1=n339 B2=n340 A=n335 ZN=n327 VDD=VDD VSS=VSS
XU688 oai221d1 $PINS B1=load_n[1] B2=n333 C1=copt_net_1834 C2=n334 A=n93
+ ZN=n335 VDD=VDD VSS=VSS
XU692 oai21d1 $PINS B1=load_k[2] B2=n651 A=n344 ZN=n340 VDD=VDD VSS=VSS
XctmTdsLR_1_1334 nd02d1 $PINS A1=HFSNET_41 A2=weight_load[0] ZN=tmp_net124
+ VDD=VDD VSS=VSS
Xgre_a_INV_127_inst_5796 inv0d0 $PINS I=bank_b[1] ZN=gre_a_INV_127_3 VDD=VDD
+ VSS=VSS
XctmTdsLR_1_1348 xr02d1 $PINS A1=tmp_net124 A2=copt_net_2726 Z=HFSNET_40
+ VDD=VDD VSS=VSS
XU697 aoi22d1 $PINS A1=load_n[0] A2=load_start B1=copt_net_1849 B2=n651 ZN=n339
+ VDD=VDD VSS=VSS
XU705 aor22d1 $PINS A1=load_k[0] A2=n352 B1=copt_net_2005 B2=n650 Z=n618
+ VDD=VDD VSS=VSS
XU706 aor22d1 $PINS A1=load_k[1] A2=n352 B1=copt_net_1808 B2=n650 Z=n619
+ VDD=VDD VSS=VSS
XU707 oaim22d1 $PINS A1=n352 A2=copt_net_1192 B1=n352 B2=load_k[2] ZN=n620
+ VDD=VDD VSS=VSS
XU709 aor22d1 $PINS A1=load_n[0] A2=n352 B1=n650 B2=copt_net_1849 Z=n621
+ VDD=VDD VSS=VSS
XU710 aor22d1 $PINS A1=n352 A2=load_n[1] B1=n650 B2=copt_net_1834 Z=n622
+ VDD=VDD VSS=VSS
XU711 oai22d1 $PINS A1=n650 A2=load_n[2] B1=n352 B2=copt_net_1771 ZN=n623
+ VDD=VDD VSS=VSS
XU714 oaim21d1 $PINS B1=copt_net_1487 B2=array_en A=n355 ZN=n624 VDD=VDD
+ VSS=VSS
XU715 oai21d1 $PINS B1=copt_net_1938 B2=n356 A=n357 ZN=n627 VDD=VDD VSS=VSS
XU716 oai21d1 $PINS B1=load_start B2=copt_net_1938 A=n356 ZN=n357 VDD=VDD
+ VSS=VSS
XU717 aon211d1 $PINS C1=load_start C2=n356 B=copt_net_1054 A=n358 ZN=n628
+ VDD=VDD VSS=VSS
XU720 oai31d1 $PINS B1=n90 B2=n350 B3=array_en A=n650 ZN=n356 VDD=VDD VSS=VSS
XU721 oaim22d1 $PINS A1=n90 A2=n360 B1=n360 B2=load_start ZN=n629 VDD=VDD
+ VSS=VSS
XU619 an03d1 $PINS A1=n333 A2=n334 A3=n93 Z=n317 VDD=VDD VSS=VSS
Xload_done_reg_reg dfcrq2 $PINS D=n624 CP=ZCTSNET_62 CDN=HFSNET_47
+ Q=load_done_gOb5 VDD=VDD VSS=VSS
Xbank_b_reg_0__3__1_ dfcrq2 $PINS D=n485 CP=ZCTSNET_61 CDN=HFSNET_50
+ Q=bank_b[25] VDD=VDD VSS=VSS
Xbank_b_reg_0__3__4_ dfcrq2 $PINS D=n472 CP=ZCTSNET_68 CDN=HFSNET_50
+ Q=bank_b[28] VDD=VDD VSS=VSS
Xbank_b_reg_0__3__3_ dfcrq2 $PINS D=n468 CP=ZCTSNET_58 CDN=HFSNET_49
+ Q=bank_b[27] VDD=VDD VSS=VSS
Xbank_b_reg_0__3__2_ dfcrq2 $PINS D=n464 CP=ZCTSNET_61 CDN=HFSNET_49
+ Q=bank_b[26] VDD=VDD VSS=VSS
Xbank_b_reg_0__3__0_ dfcrq2 $PINS D=n460 CP=ZCTSNET_68 CDN=HFSNET_50
+ Q=bank_b[24] VDD=VDD VSS=VSS
Xbank_b_reg_3__3__7_ dfcrq2 $PINS D=n456 CP=ZCTSNET_65 CDN=HFSNET_45
+ Q=bank_b[127] VDD=VDD VSS=VSS
Xbank_b_reg_3__3__6_ dfcrq2 $PINS D=n452 CP=ZCTSNET_62 CDN=HFSNET_45
+ Q=bank_b[126] VDD=VDD VSS=VSS
Xbank_b_reg_3__3__5_ dfcrq2 $PINS D=n448 CP=ZCTSNET_65 CDN=HFSNET_45
+ Q=bank_b[125] VDD=VDD VSS=VSS
Xbank_b_reg_3__3__4_ dfcrq2 $PINS D=n444 CP=ZCTSNET_62 CDN=HFSNET_45
+ Q=bank_b[124] VDD=VDD VSS=VSS
Xbank_b_reg_3__3__3_ dfcrq2 $PINS D=n440 CP=ZCTSNET_4 CDN=HFSNET_53
+ Q=bank_b[123] VDD=VDD VSS=VSS
Xbank_b_reg_3__3__2_ dfcrq2 $PINS D=n436 CP=ZCTSNET_9 CDN=HFSNET_45
+ Q=bank_b[122] VDD=VDD VSS=VSS
Xbank_b_reg_3__3__1_ dfcrq2 $PINS D=n432 CP=ZCTSNET_65 CDN=HFSNET_53
+ Q=bank_b[121] VDD=VDD VSS=VSS
Xbank_b_reg_3__3__0_ dfcrq2 $PINS D=n428 CP=ZCTSNET_4 CDN=HFSNET_50
+ Q=bank_b[120] VDD=VDD VSS=VSS
Xbank_b_reg_2__3__7_ dfcrq2 $PINS D=n424 CP=ZCTSNET_4 CDN=HFSNET_50
+ Q=bank_b[95] VDD=VDD VSS=VSS
Xbank_b_reg_2__3__6_ dfcrq2 $PINS D=n420 CP=ZCTSNET_9 CDN=HFSNET_45
+ Q=bank_b[94] VDD=VDD VSS=VSS
Xbank_b_reg_2__3__5_ dfcrq2 $PINS D=n416 CP=ZCTSNET_4 CDN=HFSNET_50
+ Q=bank_b[93] VDD=VDD VSS=VSS
Xbank_b_reg_2__3__4_ dfcrq2 $PINS D=n412 CP=ZCTSNET_9 CDN=rst_n Q=bank_b[92]
+ VDD=VDD VSS=VSS
Xbank_b_reg_2__3__3_ dfcrq2 $PINS D=n408 CP=ZCTSNET_9 CDN=HFSNET_45
+ Q=bank_b[91] VDD=VDD VSS=VSS
Xbank_b_reg_2__3__2_ dfcrq2 $PINS D=n404 CP=ZCTSNET_68 CDN=HFSNET_53
+ Q=bank_b[90] VDD=VDD VSS=VSS
Xbank_b_reg_2__3__1_ dfcrq2 $PINS D=n400 CP=ZCTSNET_4 CDN=HFSNET_53
+ Q=bank_b[89] VDD=VDD VSS=VSS
Xbank_b_reg_2__3__0_ dfcrq2 $PINS D=n396 CP=ZCTSNET_68 CDN=HFSNET_45
+ Q=bank_b[88] VDD=VDD VSS=VSS
Xbank_b_reg_1__3__7_ dfcrq2 $PINS D=n392 CP=ZCTSNET_61 CDN=HFSNET_49
+ Q=bank_b[63] VDD=VDD VSS=VSS
Xbank_b_reg_1__3__6_ dfcrq2 $PINS D=n388 CP=ZCTSNET_68 CDN=HFSNET_55
+ Q=bank_b[62] VDD=VDD VSS=VSS
Xbank_b_reg_1__3__5_ dfcrq2 $PINS D=n384 CP=ZCTSNET_61 CDN=HFSNET_50
+ Q=bank_b[61] VDD=VDD VSS=VSS
Xbank_b_reg_1__3__4_ dfcrq2 $PINS D=n380 CP=ZCTSNET_68 CDN=HFSNET_50
+ Q=bank_b[60] VDD=VDD VSS=VSS
Xbank_b_reg_1__3__3_ dfcrq2 $PINS D=n376 CP=ZCTSNET_68 CDN=HFSNET_50
+ Q=bank_b[59] VDD=VDD VSS=VSS
Xbank_b_reg_1__3__2_ dfcrq2 $PINS D=n372 CP=ZCTSNET_68 CDN=HFSNET_50
+ Q=bank_b[58] VDD=VDD VSS=VSS
Xbank_b_reg_1__3__1_ dfcrq2 $PINS D=n368 CP=ZCTSNET_68 CDN=HFSNET_53
+ Q=bank_b[57] VDD=VDD VSS=VSS
Xbank_b_reg_1__3__0_ dfcrq2 $PINS D=n364 CP=ZCTSNET_4 CDN=rst_n Q=bank_b[56]
+ VDD=VDD VSS=VSS
Xbank_b_reg_0__3__7_ dfcrq2 $PINS D=n363 CP=ZCTSNET_68 CDN=HFSNET_51
+ Q=bank_b[31] VDD=VDD VSS=VSS
Xbank_b_reg_0__3__6_ dfcrq2 $PINS D=n362 CP=ZCTSNET_4 CDN=HFSNET_45
+ Q=bank_b[30] VDD=VDD VSS=VSS
Xbank_b_reg_0__3__5_ dfcrq2 $PINS D=n361 CP=ZCTSNET_68 CDN=HFSNET_55
+ Q=bank_b[29] VDD=VDD VSS=VSS
Xbank_b_reg_0__0__1_ dfcrq2 $PINS D=n488 CP=ZCTSNET_68 CDN=HFSNET_51
+ Q=bank_b[1] VDD=VDD VSS=VSS
Xbank_b_reg_0__1__1_ dfcrq2 $PINS D=n487 CP=ZCTSNET_68 CDN=HFSNET_51
+ Q=bank_b[9] VDD=VDD VSS=VSS
Xbank_b_reg_0__2__1_ dfcrq2 $PINS D=n486 CP=ZCTSNET_61 CDN=HFSNET_49
+ Q=bank_b[17] VDD=VDD VSS=VSS
Xbank_b_reg_0__0__7_ dfcrq2 $PINS D=n484 CP=ZCTSNET_66 CDN=HFSNET_53
+ Q=bank_b[7] VDD=VDD VSS=VSS
Xbank_b_reg_0__1__7_ dfcrq2 $PINS D=n483 CP=ZCTSNET_66 CDN=HFSNET_46
+ Q=bank_b[15] VDD=VDD VSS=VSS
Xbank_b_reg_0__2__7_ dfcrq2 $PINS D=n482 CP=ZCTSNET_6 CDN=HFSNET_48
+ Q=bank_b[23] VDD=VDD VSS=VSS
Xbank_b_reg_0__0__6_ dfcrq2 $PINS D=n481 CP=ZCTSNET_62 CDN=HFSNET_55
+ Q=bank_b[6] VDD=VDD VSS=VSS
Xbank_b_reg_0__1__6_ dfcrq2 $PINS D=n480 CP=ZCTSNET_62 CDN=HFSNET_55
+ Q=bank_b[14] VDD=VDD VSS=VSS
Xbank_b_reg_0__2__6_ dfcrq2 $PINS D=n479 CP=ZCTSNET_62 CDN=HFSNET_50
+ Q=bank_b[22] VDD=VDD VSS=VSS
Xbank_b_reg_0__0__5_ dfcrq2 $PINS D=n478 CP=ZCTSNET_4 CDN=HFSNET_45 Q=bank_b[5]
+ VDD=VDD VSS=VSS
Xbank_b_reg_0__1__5_ dfcrq2 $PINS D=n477 CP=ZCTSNET_4 CDN=rst_n Q=bank_b[13]
+ VDD=VDD VSS=VSS
Xbank_b_reg_0__2__5_ dfcrq2 $PINS D=n476 CP=ZCTSNET_65 CDN=rst_n Q=bank_b[21]
+ VDD=VDD VSS=VSS
Xbank_b_reg_0__0__4_ dfcrq2 $PINS D=n475 CP=ZCTSNET_68 CDN=HFSNET_50
+ Q=bank_b[4] VDD=VDD VSS=VSS
Xbank_b_reg_0__1__4_ dfcrq2 $PINS D=n474 CP=ZCTSNET_4 CDN=HFSNET_45
+ Q=bank_b[12] VDD=VDD VSS=VSS
Xbank_b_reg_0__2__4_ dfcrq2 $PINS D=n473 CP=ZCTSNET_65 CDN=HFSNET_45
+ Q=bank_b[20] VDD=VDD VSS=VSS
Xbank_b_reg_0__0__3_ dfcrq2 $PINS D=n471 CP=ZCTSNET_61 CDN=HFSNET_50
+ Q=bank_b[3] VDD=VDD VSS=VSS
Xbank_b_reg_0__1__3_ dfcrq2 $PINS D=n470 CP=ZCTSNET_61 CDN=HFSNET_49
+ Q=bank_b[11] VDD=VDD VSS=VSS
Xbank_b_reg_0__2__3_ dfcrq2 $PINS D=n469 CP=ZCTSNET_61 CDN=HFSNET_49
+ Q=bank_b[19] VDD=VDD VSS=VSS
Xbank_b_reg_0__0__2_ dfcrq2 $PINS D=n467 CP=ZCTSNET_61 CDN=HFSNET_50
+ Q=bank_b[2] VDD=VDD VSS=VSS
Xbank_b_reg_0__1__2_ dfcrq2 $PINS D=n466 CP=ZCTSNET_61 CDN=HFSNET_49
+ Q=bank_b[10] VDD=VDD VSS=VSS
Xbank_b_reg_0__2__2_ dfcrq2 $PINS D=n465 CP=ZCTSNET_61 CDN=HFSNET_50
+ Q=bank_b[18] VDD=VDD VSS=VSS
Xbank_b_reg_0__0__0_ dfcrq2 $PINS D=n463 CP=ZCTSNET_61 CDN=HFSNET_50
+ Q=bank_b[0] VDD=VDD VSS=VSS
Xbank_b_reg_0__1__0_ dfcrq2 $PINS D=n462 CP=ZCTSNET_68 CDN=HFSNET_51
+ Q=bank_b[8] VDD=VDD VSS=VSS
Xbank_b_reg_0__2__0_ dfcrq2 $PINS D=n461 CP=ZCTSNET_68 CDN=HFSNET_50
+ Q=bank_b[16] VDD=VDD VSS=VSS
Xbank_b_reg_3__0__7_ dfcrq2 $PINS D=n459 CP=ZCTSNET_62 CDN=HFSNET_45
+ Q=bank_b[103] VDD=VDD VSS=VSS
Xbank_b_reg_3__1__7_ dfcrq2 $PINS D=n458 CP=ZCTSNET_65 CDN=HFSNET_45
+ Q=bank_b[111] VDD=VDD VSS=VSS
Xbank_b_reg_3__2__7_ dfcrq2 $PINS D=n457 CP=ZCTSNET_65 CDN=HFSNET_53
+ Q=bank_b[119] VDD=VDD VSS=VSS
Xbank_b_reg_3__0__6_ dfcrq2 $PINS D=n455 CP=ZCTSNET_65 CDN=HFSNET_45
+ Q=bank_b[102] VDD=VDD VSS=VSS
Xbank_b_reg_3__1__6_ dfcrq2 $PINS D=n454 CP=ZCTSNET_62 CDN=HFSNET_45
+ Q=bank_b[110] VDD=VDD VSS=VSS
Xbank_b_reg_3__2__6_ dfcrq2 $PINS D=n453 CP=ZCTSNET_65 CDN=HFSNET_45
+ Q=bank_b[118] VDD=VDD VSS=VSS
Xbank_b_reg_3__0__5_ dfcrq2 $PINS D=n451 CP=ZCTSNET_62 CDN=HFSNET_50
+ Q=bank_b[101] VDD=VDD VSS=VSS
Xbank_b_reg_3__1__5_ dfcrq2 $PINS D=n450 CP=ZCTSNET_62 CDN=HFSNET_45
+ Q=bank_b[109] VDD=VDD VSS=VSS
Xbank_b_reg_3__2__5_ dfcrq2 $PINS D=n449 CP=ZCTSNET_65 CDN=HFSNET_45
+ Q=bank_b[117] VDD=VDD VSS=VSS
Xbank_b_reg_3__0__4_ dfcrq2 $PINS D=n447 CP=ZCTSNET_65 CDN=rst_n Q=bank_b[100]
+ VDD=VDD VSS=VSS
Xbank_b_reg_3__1__4_ dfcrq2 $PINS D=n446 CP=ZCTSNET_68 CDN=HFSNET_50
+ Q=bank_b[108] VDD=VDD VSS=VSS
Xbank_b_reg_3__2__4_ dfcrq2 $PINS D=n445 CP=ZCTSNET_68 CDN=HFSNET_50
+ Q=bank_b[116] VDD=VDD VSS=VSS
Xbank_b_reg_3__0__3_ dfcrq2 $PINS D=n443 CP=ZCTSNET_62 CDN=HFSNET_45
+ Q=bank_b[99] VDD=VDD VSS=VSS
Xbank_b_reg_3__1__3_ dfcrq2 $PINS D=n442 CP=ZCTSNET_9 CDN=HFSNET_45
+ Q=bank_b[107] VDD=VDD VSS=VSS
Xbank_b_reg_3__2__3_ dfcrq2 $PINS D=n441 CP=ZCTSNET_65 CDN=HFSNET_53
+ Q=bank_b[115] VDD=VDD VSS=VSS
Xbank_b_reg_3__0__2_ dfcrq2 $PINS D=n439 CP=ZCTSNET_62 CDN=HFSNET_50
+ Q=bank_b[98] VDD=VDD VSS=VSS
Xbank_b_reg_3__1__2_ dfcrq2 $PINS D=n438 CP=ZCTSNET_65 CDN=HFSNET_45
+ Q=bank_b[106] VDD=VDD VSS=VSS
Xbank_b_reg_3__2__2_ dfcrq2 $PINS D=n437 CP=ZCTSNET_9 CDN=HFSNET_45
+ Q=bank_b[114] VDD=VDD VSS=VSS
Xbank_b_reg_3__0__1_ dfcrq2 $PINS D=n435 CP=ZCTSNET_65 CDN=HFSNET_45
+ Q=bank_b[97] VDD=VDD VSS=VSS
Xbank_b_reg_3__1__1_ dfcrq2 $PINS D=n434 CP=ZCTSNET_9 CDN=HFSNET_53
+ Q=bank_b[105] VDD=VDD VSS=VSS
Xbank_b_reg_3__2__1_ dfcrq2 $PINS D=n433 CP=ZCTSNET_65 CDN=rst_n Q=bank_b[113]
+ VDD=VDD VSS=VSS
Xbank_b_reg_3__0__0_ dfcrq2 $PINS D=n431 CP=ZCTSNET_65 CDN=HFSNET_45
+ Q=bank_b[96] VDD=VDD VSS=VSS
Xbank_b_reg_3__1__0_ dfcrq2 $PINS D=n430 CP=ZCTSNET_68 CDN=HFSNET_46
+ Q=bank_b[104] VDD=VDD VSS=VSS
Xbank_b_reg_3__2__0_ dfcrq2 $PINS D=n429 CP=ZCTSNET_9 CDN=HFSNET_45
+ Q=bank_b[112] VDD=VDD VSS=VSS
Xbank_b_reg_2__0__7_ dfcrq2 $PINS D=n427 CP=ZCTSNET_66 CDN=HFSNET_53
+ Q=bank_b[71] VDD=VDD VSS=VSS
Xbank_b_reg_2__1__7_ dfcrq2 $PINS D=n426 CP=ZCTSNET_4 CDN=HFSNET_45
+ Q=bank_b[79] VDD=VDD VSS=VSS
Xbank_b_reg_2__2__7_ dfcrq2 $PINS D=n425 CP=ZCTSNET_4 CDN=HFSNET_45
+ Q=bank_b[87] VDD=VDD VSS=VSS
Xbank_b_reg_2__0__6_ dfcrq2 $PINS D=n423 CP=ZCTSNET_65 CDN=HFSNET_53
+ Q=bank_b[70] VDD=VDD VSS=VSS
Xbank_b_reg_2__1__6_ dfcrq2 $PINS D=n422 CP=ZCTSNET_4 CDN=HFSNET_50
+ Q=bank_b[78] VDD=VDD VSS=VSS
Xbank_b_reg_2__2__6_ dfcrq2 $PINS D=n421 CP=ZCTSNET_9 CDN=HFSNET_53
+ Q=bank_b[86] VDD=VDD VSS=VSS
Xbank_b_reg_2__0__5_ dfcrq2 $PINS D=n419 CP=ZCTSNET_66 CDN=HFSNET_46
+ Q=bank_b[69] VDD=VDD VSS=VSS
Xbank_b_reg_2__1__5_ dfcrq2 $PINS D=n418 CP=ZCTSNET_4 CDN=HFSNET_50
+ Q=bank_b[77] VDD=VDD VSS=VSS
Xbank_b_reg_2__2__5_ dfcrq2 $PINS D=n417 CP=ZCTSNET_68 CDN=HFSNET_50
+ Q=bank_b[85] VDD=VDD VSS=VSS
Xbank_b_reg_2__0__4_ dfcrq2 $PINS D=n415 CP=ZCTSNET_66 CDN=HFSNET_46
+ Q=bank_b[68] VDD=VDD VSS=VSS
Xbank_b_reg_2__1__4_ dfcrq2 $PINS D=n414 CP=ZCTSNET_68 CDN=HFSNET_51
+ Q=bank_b[76] VDD=VDD VSS=VSS
Xbank_b_reg_2__2__4_ dfcrq2 $PINS D=n413 CP=ZCTSNET_68 CDN=HFSNET_51
+ Q=bank_b[84] VDD=VDD VSS=VSS
Xbank_b_reg_2__0__3_ dfcrq2 $PINS D=n411 CP=ZCTSNET_68 CDN=HFSNET_50
+ Q=bank_b[67] VDD=VDD VSS=VSS
Xbank_b_reg_2__1__3_ dfcrq2 $PINS D=n410 CP=ZCTSNET_68 CDN=HFSNET_51
+ Q=bank_b[75] VDD=VDD VSS=VSS
Xbank_b_reg_2__2__3_ dfcrq2 $PINS D=n409 CP=ZCTSNET_66 CDN=HFSNET_53
+ Q=bank_b[83] VDD=VDD VSS=VSS
Xbank_b_reg_2__0__2_ dfcrq2 $PINS D=n407 CP=ZCTSNET_66 CDN=HFSNET_53
+ Q=bank_b[66] VDD=VDD VSS=VSS
Xbank_b_reg_2__1__2_ dfcrq2 $PINS D=n406 CP=ZCTSNET_68 CDN=HFSNET_51
+ Q=bank_b[74] VDD=VDD VSS=VSS
Xbank_b_reg_2__2__2_ dfcrq2 $PINS D=n405 CP=ZCTSNET_66 CDN=HFSNET_53
+ Q=bank_b[82] VDD=VDD VSS=VSS
Xbank_b_reg_2__0__1_ dfcrq2 $PINS D=n403 CP=ZCTSNET_68 CDN=HFSNET_50
+ Q=bank_b[65] VDD=VDD VSS=VSS
Xbank_b_reg_2__1__1_ dfcrq2 $PINS D=n402 CP=ZCTSNET_68 CDN=HFSNET_53
+ Q=bank_b[73] VDD=VDD VSS=VSS
Xbank_b_reg_2__2__1_ dfcrq2 $PINS D=n401 CP=ZCTSNET_68 CDN=HFSNET_53
+ Q=bank_b[81] VDD=VDD VSS=VSS
Xbank_b_reg_2__0__0_ dfcrq2 $PINS D=n399 CP=ZCTSNET_68 CDN=HFSNET_53
+ Q=bank_b[64] VDD=VDD VSS=VSS
Xbank_b_reg_2__1__0_ dfcrq2 $PINS D=n398 CP=ZCTSNET_4 CDN=HFSNET_53
+ Q=bank_b[72] VDD=VDD VSS=VSS
Xbank_b_reg_2__2__0_ dfcrq2 $PINS D=n397 CP=ZCTSNET_4 CDN=HFSNET_53
+ Q=bank_b[80] VDD=VDD VSS=VSS
Xbank_b_reg_1__0__7_ dfcrq2 $PINS D=n395 CP=ZCTSNET_66 CDN=HFSNET_53
+ Q=bank_b[39] VDD=VDD VSS=VSS
Xbank_b_reg_1__1__7_ dfcrq2 $PINS D=n394 CP=ZCTSNET_68 CDN=HFSNET_53
+ Q=bank_b[47] VDD=VDD VSS=VSS
Xbank_b_reg_1__2__7_ dfcrq2 $PINS D=n393 CP=ZCTSNET_66 CDN=HFSNET_53
+ Q=bank_b[55] VDD=VDD VSS=VSS
Xbank_b_reg_1__0__6_ dfcrq2 $PINS D=n391 CP=ZCTSNET_68 CDN=HFSNET_50
+ Q=bank_b[38] VDD=VDD VSS=VSS
Xbank_b_reg_1__1__6_ dfcrq2 $PINS D=n390 CP=ZCTSNET_68 CDN=HFSNET_53
+ Q=bank_b[46] VDD=VDD VSS=VSS
Xbank_b_reg_1__2__6_ dfcrq2 $PINS D=n389 CP=ZCTSNET_68 CDN=HFSNET_51
+ Q=bank_b[54] VDD=VDD VSS=VSS
Xbank_b_reg_1__0__5_ dfcrq2 $PINS D=n387 CP=ZCTSNET_68 CDN=HFSNET_53
+ Q=bank_b[37] VDD=VDD VSS=VSS
Xbank_b_reg_1__1__5_ dfcrq2 $PINS D=n386 CP=ZCTSNET_68 CDN=HFSNET_51
+ Q=bank_b[45] VDD=VDD VSS=VSS
Xbank_b_reg_1__2__5_ dfcrq2 $PINS D=n385 CP=ZCTSNET_68 CDN=HFSNET_51
+ Q=bank_b[53] VDD=VDD VSS=VSS
Xbank_b_reg_1__0__4_ dfcrq2 $PINS D=n383 CP=ZCTSNET_68 CDN=HFSNET_51
+ Q=bank_b[36] VDD=VDD VSS=VSS
Xbank_b_reg_1__1__4_ dfcrq2 $PINS D=n382 CP=ZCTSNET_68 CDN=HFSNET_51
+ Q=bank_b[44] VDD=VDD VSS=VSS
Xbank_b_reg_1__2__4_ dfcrq2 $PINS D=n381 CP=ZCTSNET_68 CDN=HFSNET_53
+ Q=bank_b[52] VDD=VDD VSS=VSS
Xbank_b_reg_1__0__3_ dfcrq2 $PINS D=n379 CP=ZCTSNET_68 CDN=HFSNET_50
+ Q=bank_b[35] VDD=VDD VSS=VSS
Xbank_b_reg_1__1__3_ dfcrq2 $PINS D=n378 CP=ZCTSNET_68 CDN=HFSNET_53
+ Q=bank_b[43] VDD=VDD VSS=VSS
Xbank_b_reg_1__2__3_ dfcrq2 $PINS D=n377 CP=ZCTSNET_66 CDN=HFSNET_53
+ Q=bank_b[51] VDD=VDD VSS=VSS
Xbank_b_reg_1__0__2_ dfcrq2 $PINS D=n375 CP=ZCTSNET_68 CDN=HFSNET_51
+ Q=bank_b[34] VDD=VDD VSS=VSS
Xbank_b_reg_1__1__2_ dfcrq2 $PINS D=n374 CP=ZCTSNET_68 CDN=HFSNET_55
+ Q=bank_b[42] VDD=VDD VSS=VSS
Xbank_b_reg_1__2__2_ dfcrq2 $PINS D=n373 CP=ZCTSNET_68 CDN=HFSNET_53
+ Q=bank_b[50] VDD=VDD VSS=VSS
Xbank_b_reg_1__0__1_ dfcrq2 $PINS D=n371 CP=ZCTSNET_68 CDN=HFSNET_51
+ Q=bank_b[33] VDD=VDD VSS=VSS
Xbank_b_reg_1__1__1_ dfcrq2 $PINS D=n370 CP=ZCTSNET_68 CDN=HFSNET_50
+ Q=bank_b[41] VDD=VDD VSS=VSS
Xbank_b_reg_1__2__1_ dfcrq2 $PINS D=n369 CP=ZCTSNET_68 CDN=HFSNET_53
+ Q=bank_b[49] VDD=VDD VSS=VSS
Xbank_b_reg_1__0__0_ dfcrq2 $PINS D=n367 CP=ZCTSNET_68 CDN=HFSNET_51
+ Q=bank_b[32] VDD=VDD VSS=VSS
Xbank_b_reg_1__1__0_ dfcrq2 $PINS D=n366 CP=ZCTSNET_68 CDN=HFSNET_51
+ Q=bank_b[40] VDD=VDD VSS=VSS
Xbank_b_reg_1__2__0_ dfcrq2 $PINS D=n365 CP=ZCTSNET_68 CDN=HFSNET_53
+ Q=bank_b[48] VDD=VDD VSS=VSS
Xbank_a_reg_0__3__1_ dfcrq2 $PINS D=n613 CP=ZCTSNET_6 CDN=HFSNET_48
+ Q=bank_a[25] VDD=VDD VSS=VSS
Xbank_a_reg_0__3__4_ dfcrq2 $PINS D=n600 CP=ZCTSNET_61 CDN=HFSNET_50
+ Q=bank_a[28] VDD=VDD VSS=VSS
Xbank_a_reg_0__3__3_ dfcrq2 $PINS D=n596 CP=ZCTSNET_6 CDN=HFSNET_48
+ Q=bank_a[27] VDD=VDD VSS=VSS
Xbank_a_reg_0__3__2_ dfcrq2 $PINS D=n592 CP=ZCTSNET_58 CDN=HFSNET_48
+ Q=bank_a[26] VDD=VDD VSS=VSS
Xbank_a_reg_0__3__0_ dfcrq2 $PINS D=n588 CP=ZCTSNET_62 CDN=HFSNET_55
+ Q=bank_a[24] VDD=VDD VSS=VSS
Xbank_a_reg_3__3__7_ dfcrq2 $PINS D=n584 CP=ZCTSNET_70 CDN=HFSNET_55
+ Q=bank_a[127] VDD=VDD VSS=VSS
Xbank_a_reg_3__3__6_ dfcrq2 $PINS D=n580 CP=ZCTSNET_62 CDN=HFSNET_55
+ Q=bank_a[126] VDD=VDD VSS=VSS
Xbank_a_reg_3__3__5_ dfcrq2 $PINS D=n576 CP=ZCTSNET_70 CDN=HFSNET_54
+ Q=bank_a[125] VDD=VDD VSS=VSS
Xbank_a_reg_3__3__4_ dfcrq2 $PINS D=n572 CP=ZCTSNET_70 CDN=HFSNET_54
+ Q=bank_a[124] VDD=VDD VSS=VSS
Xbank_a_reg_3__3__3_ dfcrq2 $PINS D=n568 CP=ZCTSNET_9 CDN=HFSNET_45
+ Q=bank_a[123] VDD=VDD VSS=VSS
Xbank_a_reg_3__3__2_ dfcrq2 $PINS D=n564 CP=ZCTSNET_65 CDN=HFSNET_45
+ Q=bank_a[122] VDD=VDD VSS=VSS
Xbank_a_reg_3__3__1_ dfcrq2 $PINS D=n560 CP=ZCTSNET_9 CDN=HFSNET_43
+ Q=bank_a[121] VDD=VDD VSS=VSS
Xbank_a_reg_3__3__0_ dfcrq2 $PINS D=n556 CP=ZCTSNET_65 CDN=HFSNET_43
+ Q=bank_a[120] VDD=VDD VSS=VSS
Xbank_a_reg_2__3__7_ dfcrq2 $PINS D=n552 CP=ZCTSNET_9 CDN=rst_n Q=bank_a[95]
+ VDD=VDD VSS=VSS
Xbank_a_reg_2__3__6_ dfcrq2 $PINS D=n548 CP=ZCTSNET_9 CDN=rst_n Q=bank_a[94]
+ VDD=VDD VSS=VSS
Xbank_a_reg_2__3__5_ dfcrq2 $PINS D=n544 CP=ZCTSNET_65 CDN=rst_n Q=bank_a[93]
+ VDD=VDD VSS=VSS
Xbank_a_reg_2__3__4_ dfcrq2 $PINS D=n540 CP=ZCTSNET_65 CDN=rst_n Q=bank_a[92]
+ VDD=VDD VSS=VSS
Xbank_a_reg_2__3__3_ dfcrq2 $PINS D=n536 CP=ZCTSNET_65 CDN=rst_n Q=bank_a[91]
+ VDD=VDD VSS=VSS
Xbank_a_reg_2__3__2_ dfcrq2 $PINS D=n532 CP=ZCTSNET_66 CDN=HFSNET_46
+ Q=bank_a[90] VDD=VDD VSS=VSS
Xbank_a_reg_2__3__1_ dfcrq2 $PINS D=n528 CP=ZCTSNET_66 CDN=HFSNET_46
+ Q=bank_a[89] VDD=VDD VSS=VSS
Xbank_a_reg_2__3__0_ dfcrq2 $PINS D=n524 CP=ZCTSNET_68 CDN=HFSNET_50
+ Q=bank_a[88] VDD=VDD VSS=VSS
Xbank_a_reg_1__3__7_ dfcrq2 $PINS D=n520 CP=ZCTSNET_68 CDN=HFSNET_55
+ Q=bank_a[63] VDD=VDD VSS=VSS
Xbank_a_reg_1__3__6_ dfcrq2 $PINS D=n516 CP=ZCTSNET_63 CDN=HFSNET_44
+ Q=bank_a[62] VDD=VDD VSS=VSS
Xbank_a_reg_1__3__5_ dfcrq2 $PINS D=n512 CP=ZCTSNET_68 CDN=HFSNET_51
+ Q=bank_a[61] VDD=VDD VSS=VSS
Xbank_a_reg_1__3__4_ dfcrq2 $PINS D=n508 CP=ZCTSNET_68 CDN=HFSNET_51
+ Q=bank_a[60] VDD=VDD VSS=VSS
Xbank_a_reg_1__3__3_ dfcrq2 $PINS D=n504 CP=ZCTSNET_68 CDN=HFSNET_51
+ Q=bank_a[59] VDD=VDD VSS=VSS
Xbank_a_reg_1__3__2_ dfcrq2 $PINS D=n500 CP=ZCTSNET_68 CDN=HFSNET_51
+ Q=bank_a[58] VDD=VDD VSS=VSS
Xbank_a_reg_1__3__1_ dfcrq2 $PINS D=n496 CP=ZCTSNET_61 CDN=HFSNET_49
+ Q=bank_a[57] VDD=VDD VSS=VSS
Xbank_a_reg_1__3__0_ dfcrq2 $PINS D=n492 CP=ZCTSNET_61 CDN=HFSNET_49
+ Q=bank_a[56] VDD=VDD VSS=VSS
Xbank_a_reg_0__3__7_ dfcrq2 $PINS D=n491 CP=ZCTSNET_61 CDN=HFSNET_49
+ Q=bank_a[31] VDD=VDD VSS=VSS
Xbank_a_reg_0__3__6_ dfcrq2 $PINS D=n490 CP=ZCTSNET_68 CDN=HFSNET_55
+ Q=bank_a[30] VDD=VDD VSS=VSS
Xbank_a_reg_0__3__5_ dfcrq2 $PINS D=n489 CP=ZCTSNET_62 CDN=HFSNET_55
+ Q=bank_a[29] VDD=VDD VSS=VSS
Xbank_a_reg_0__0__1_ dfcrq2 $PINS D=n616 CP=ZCTSNET_61 CDN=HFSNET_48
+ Q=bank_a[1] VDD=VDD VSS=VSS
Xbank_a_reg_0__1__1_ dfcrq2 $PINS D=n615 CP=ZCTSNET_6 CDN=HFSNET_48 Q=bank_a[9]
+ VDD=VDD VSS=VSS
Xbank_a_reg_0__2__1_ dfcrq2 $PINS D=n614 CP=ZCTSNET_6 CDN=HFSNET_48
+ Q=bank_a[17] VDD=VDD VSS=VSS
Xbank_a_reg_0__0__7_ dfcrq2 $PINS D=n612 CP=ZCTSNET_61 CDN=HFSNET_48
+ Q=bank_a[7] VDD=VDD VSS=VSS
Xbank_a_reg_0__1__7_ dfcrq2 $PINS D=n611 CP=ZCTSNET_61 CDN=HFSNET_50
+ Q=bank_a[15] VDD=VDD VSS=VSS
Xbank_a_reg_0__2__7_ dfcrq2 $PINS D=n610 CP=ZCTSNET_61 CDN=HFSNET_50
+ Q=bank_a[23] VDD=VDD VSS=VSS
Xbank_a_reg_0__0__6_ dfcrq2 $PINS D=n609 CP=ZCTSNET_6 CDN=HFSNET_47 Q=bank_a[6]
+ VDD=VDD VSS=VSS
Xbank_a_reg_0__1__6_ dfcrq2 $PINS D=n608 CP=ZCTSNET_68 CDN=HFSNET_50
+ Q=bank_a[14] VDD=VDD VSS=VSS
Xbank_a_reg_0__2__6_ dfcrq2 $PINS D=n607 CP=ZCTSNET_61 CDN=HFSNET_50
+ Q=bank_a[22] VDD=VDD VSS=VSS
Xbank_a_reg_0__0__5_ dfcrq2 $PINS D=n606 CP=ZCTSNET_62 CDN=HFSNET_47
+ Q=bank_a[5] VDD=VDD VSS=VSS
Xbank_a_reg_0__1__5_ dfcrq2 $PINS D=n605 CP=ZCTSNET_62 CDN=HFSNET_50
+ Q=bank_a[13] VDD=VDD VSS=VSS
Xbank_a_reg_0__2__5_ dfcrq2 $PINS D=n604 CP=ZCTSNET_62 CDN=HFSNET_50
+ Q=bank_a[21] VDD=VDD VSS=VSS
Xbank_a_reg_0__0__4_ dfcrq2 $PINS D=n603 CP=ZCTSNET_62 CDN=HFSNET_47
+ Q=bank_a[4] VDD=VDD VSS=VSS
Xbank_a_reg_0__1__4_ dfcrq2 $PINS D=n602 CP=ZCTSNET_61 CDN=HFSNET_47
+ Q=bank_a[12] VDD=VDD VSS=VSS
Xbank_a_reg_0__2__4_ dfcrq2 $PINS D=n601 CP=ZCTSNET_61 CDN=HFSNET_47
+ Q=bank_a[20] VDD=VDD VSS=VSS
Xbank_a_reg_0__0__3_ dfcrq2 $PINS D=n599 CP=ZCTSNET_6 CDN=HFSNET_47 Q=bank_a[3]
+ VDD=VDD VSS=VSS
Xbank_a_reg_0__1__3_ dfcrq2 $PINS D=n598 CP=ZCTSNET_6 CDN=HFSNET_48
+ Q=bank_a[11] VDD=VDD VSS=VSS
Xbank_a_reg_0__2__3_ dfcrq2 $PINS D=n597 CP=ZCTSNET_60 CDN=HFSNET_48
+ Q=bank_a[19] VDD=VDD VSS=VSS
Xbank_a_reg_0__0__2_ dfcrq2 $PINS D=n595 CP=ZCTSNET_6 CDN=HFSNET_48 Q=bank_a[2]
+ VDD=VDD VSS=VSS
Xbank_a_reg_0__1__2_ dfcrq2 $PINS D=n594 CP=ZCTSNET_6 CDN=HFSNET_48
+ Q=bank_a[10] VDD=VDD VSS=VSS
Xbank_a_reg_0__2__2_ dfcrq2 $PINS D=n593 CP=ZCTSNET_58 CDN=HFSNET_48
+ Q=bank_a[18] VDD=VDD VSS=VSS
Xbank_a_reg_0__0__0_ dfcrq2 $PINS D=n591 CP=ZCTSNET_61 CDN=HFSNET_48
+ Q=bank_a[0] VDD=VDD VSS=VSS
Xbank_a_reg_0__1__0_ dfcrq2 $PINS D=n590 CP=ZCTSNET_61 CDN=HFSNET_48
+ Q=bank_a[8] VDD=VDD VSS=VSS
Xbank_a_reg_0__2__0_ dfcrq2 $PINS D=n589 CP=ZCTSNET_62 CDN=HFSNET_55
+ Q=bank_a[16] VDD=VDD VSS=VSS
Xbank_a_reg_3__0__7_ dfcrq2 $PINS D=n587 CP=ZCTSNET_62 CDN=HFSNET_55
+ Q=bank_a[103] VDD=VDD VSS=VSS
Xbank_a_reg_3__1__7_ dfcrq2 $PINS D=n586 CP=ZCTSNET_62 CDN=HFSNET_55
+ Q=bank_a[111] VDD=VDD VSS=VSS
Xbank_a_reg_3__2__7_ dfcrq2 $PINS D=n585 CP=ZCTSNET_70 CDN=HFSNET_55
+ Q=bank_a[119] VDD=VDD VSS=VSS
Xbank_a_reg_3__0__6_ dfcrq2 $PINS D=n583 CP=ZCTSNET_62 CDN=HFSNET_55
+ Q=bank_a[102] VDD=VDD VSS=VSS
Xbank_a_reg_3__1__6_ dfcrq2 $PINS D=n582 CP=ZCTSNET_70 CDN=HFSNET_55
+ Q=bank_a[110] VDD=VDD VSS=VSS
Xbank_a_reg_3__2__6_ dfcrq2 $PINS D=n581 CP=ZCTSNET_62 CDN=HFSNET_55
+ Q=bank_a[118] VDD=VDD VSS=VSS
Xbank_a_reg_3__0__5_ dfcrq2 $PINS D=n579 CP=ZCTSNET_62 CDN=HFSNET_55
+ Q=bank_a[101] VDD=VDD VSS=VSS
Xbank_a_reg_3__1__5_ dfcrq2 $PINS D=n578 CP=ZCTSNET_70 CDN=HFSNET_55
+ Q=bank_a[109] VDD=VDD VSS=VSS
Xbank_a_reg_3__2__5_ dfcrq2 $PINS D=n577 CP=ZCTSNET_70 CDN=HFSNET_54
+ Q=bank_a[117] VDD=VDD VSS=VSS
Xbank_a_reg_3__0__4_ dfcrq2 $PINS D=n575 CP=ZCTSNET_70 CDN=HFSNET_55
+ Q=bank_a[100] VDD=VDD VSS=VSS
Xbank_a_reg_3__1__4_ dfcrq2 $PINS D=n574 CP=ZCTSNET_70 CDN=HFSNET_54
+ Q=bank_a[108] VDD=VDD VSS=VSS
Xbank_a_reg_3__2__4_ dfcrq2 $PINS D=n573 CP=ZCTSNET_70 CDN=HFSNET_54
+ Q=bank_a[116] VDD=VDD VSS=VSS
Xbank_a_reg_3__0__3_ dfcrq2 $PINS D=n571 CP=ZCTSNET_70 CDN=HFSNET_45
+ Q=bank_a[99] VDD=VDD VSS=VSS
Xbank_a_reg_3__1__3_ dfcrq2 $PINS D=n570 CP=ZCTSNET_9 CDN=HFSNET_43
+ Q=bank_a[107] VDD=VDD VSS=VSS
Xbank_a_reg_3__2__3_ dfcrq2 $PINS D=n569 CP=ZCTSNET_65 CDN=HFSNET_43
+ Q=bank_a[115] VDD=VDD VSS=VSS
Xbank_a_reg_3__0__2_ dfcrq2 $PINS D=n567 CP=ZCTSNET_70 CDN=HFSNET_54
+ Q=bank_a[98] VDD=VDD VSS=VSS
Xbank_a_reg_3__1__2_ dfcrq2 $PINS D=n566 CP=ZCTSNET_70 CDN=HFSNET_54
+ Q=bank_a[106] VDD=VDD VSS=VSS
Xbank_a_reg_3__2__2_ dfcrq2 $PINS D=n565 CP=ZCTSNET_65 CDN=HFSNET_45
+ Q=bank_a[114] VDD=VDD VSS=VSS
Xbank_a_reg_3__0__1_ dfcrq2 $PINS D=n563 CP=ZCTSNET_9 CDN=HFSNET_43
+ Q=bank_a[97] VDD=VDD VSS=VSS
Xbank_a_reg_3__1__1_ dfcrq2 $PINS D=n562 CP=ZCTSNET_9 CDN=HFSNET_43
+ Q=bank_a[105] VDD=VDD VSS=VSS
Xbank_a_reg_3__2__1_ dfcrq2 $PINS D=n561 CP=ZCTSNET_9 CDN=HFSNET_43
+ Q=bank_a[113] VDD=VDD VSS=VSS
Xbank_a_reg_3__0__0_ dfcrq2 $PINS D=n559 CP=ZCTSNET_9 CDN=HFSNET_43
+ Q=bank_a[96] VDD=VDD VSS=VSS
Xbank_a_reg_3__1__0_ dfcrq2 $PINS D=n558 CP=ZCTSNET_65 CDN=HFSNET_43
+ Q=bank_a[104] VDD=VDD VSS=VSS
Xbank_a_reg_3__2__0_ dfcrq2 $PINS D=n557 CP=ZCTSNET_65 CDN=rst_n Q=bank_a[112]
+ VDD=VDD VSS=VSS
Xbank_a_reg_2__0__7_ dfcrq2 $PINS D=n555 CP=ZCTSNET_4 CDN=rst_n Q=bank_a[71]
+ VDD=VDD VSS=VSS
Xbank_a_reg_2__1__7_ dfcrq2 $PINS D=n554 CP=ZCTSNET_65 CDN=rst_n Q=bank_a[79]
+ VDD=VDD VSS=VSS
Xbank_a_reg_2__2__7_ dfcrq2 $PINS D=n553 CP=ZCTSNET_65 CDN=rst_n Q=bank_a[87]
+ VDD=VDD VSS=VSS
Xbank_a_reg_2__0__6_ dfcrq2 $PINS D=n551 CP=ZCTSNET_65 CDN=rst_n Q=bank_a[70]
+ VDD=VDD VSS=VSS
Xbank_a_reg_2__1__6_ dfcrq2 $PINS D=n550 CP=ZCTSNET_65 CDN=rst_n Q=bank_a[78]
+ VDD=VDD VSS=VSS
Xbank_a_reg_2__2__6_ dfcrq2 $PINS D=n549 CP=ZCTSNET_65 CDN=rst_n Q=bank_a[86]
+ VDD=VDD VSS=VSS
Xbank_a_reg_2__0__5_ dfcrq2 $PINS D=n547 CP=ZCTSNET_66 CDN=rst_n Q=bank_a[69]
+ VDD=VDD VSS=VSS
Xbank_a_reg_2__1__5_ dfcrq2 $PINS D=n546 CP=ZCTSNET_65 CDN=HFSNET_42
+ Q=bank_a[77] VDD=VDD VSS=VSS
Xbank_a_reg_2__2__5_ dfcrq2 $PINS D=n545 CP=ZCTSNET_65 CDN=HFSNET_42
+ Q=bank_a[85] VDD=VDD VSS=VSS
Xbank_a_reg_2__0__4_ dfcrq2 $PINS D=n543 CP=ZCTSNET_66 CDN=rst_n Q=bank_a[68]
+ VDD=VDD VSS=VSS
Xbank_a_reg_2__1__4_ dfcrq2 $PINS D=n542 CP=ZCTSNET_66 CDN=HFSNET_46
+ Q=bank_a[76] VDD=VDD VSS=VSS
Xbank_a_reg_2__2__4_ dfcrq2 $PINS D=n541 CP=ZCTSNET_65 CDN=HFSNET_46
+ Q=bank_a[84] VDD=VDD VSS=VSS
Xbank_a_reg_2__0__3_ dfcrq2 $PINS D=n539 CP=ZCTSNET_66 CDN=HFSNET_46
+ Q=bank_a[67] VDD=VDD VSS=VSS
Xbank_a_reg_2__1__3_ dfcrq2 $PINS D=n538 CP=ZCTSNET_65 CDN=HFSNET_46
+ Q=bank_a[75] VDD=VDD VSS=VSS
Xbank_a_reg_2__2__3_ dfcrq2 $PINS D=n537 CP=ZCTSNET_65 CDN=rst_n Q=bank_a[83]
+ VDD=VDD VSS=VSS
Xbank_a_reg_2__0__2_ dfcrq2 $PINS D=n535 CP=ZCTSNET_66 CDN=HFSNET_46
+ Q=bank_a[66] VDD=VDD VSS=VSS
Xbank_a_reg_2__1__2_ dfcrq2 $PINS D=n534 CP=ZCTSNET_66 CDN=HFSNET_46
+ Q=bank_a[74] VDD=VDD VSS=VSS
Xbank_a_reg_2__2__2_ dfcrq2 $PINS D=n533 CP=ZCTSNET_66 CDN=HFSNET_46
+ Q=bank_a[82] VDD=VDD VSS=VSS
Xbank_a_reg_2__0__1_ dfcrq2 $PINS D=n531 CP=ZCTSNET_66 CDN=HFSNET_46
+ Q=bank_a[65] VDD=VDD VSS=VSS
Xbank_a_reg_2__1__1_ dfcrq2 $PINS D=n530 CP=ZCTSNET_66 CDN=HFSNET_46
+ Q=bank_a[73] VDD=VDD VSS=VSS
Xbank_a_reg_2__2__1_ dfcrq2 $PINS D=n529 CP=ZCTSNET_66 CDN=HFSNET_46
+ Q=bank_a[81] VDD=VDD VSS=VSS
Xbank_a_reg_2__0__0_ dfcrq2 $PINS D=n527 CP=ZCTSNET_66 CDN=HFSNET_46
+ Q=bank_a[64] VDD=VDD VSS=VSS
Xbank_a_reg_2__1__0_ dfcrq2 $PINS D=n526 CP=ZCTSNET_68 CDN=HFSNET_55
+ Q=bank_a[72] VDD=VDD VSS=VSS
Xbank_a_reg_2__2__0_ dfcrq2 $PINS D=n525 CP=ZCTSNET_68 CDN=HFSNET_55
+ Q=bank_a[80] VDD=VDD VSS=VSS
Xbank_a_reg_1__0__7_ dfcrq2 $PINS D=n523 CP=ZCTSNET_4 CDN=HFSNET_45
+ Q=bank_a[39] VDD=VDD VSS=VSS
Xbank_a_reg_1__1__7_ dfcrq2 $PINS D=n522 CP=ZCTSNET_4 CDN=rst_n Q=bank_a[47]
+ VDD=VDD VSS=VSS
Xbank_a_reg_1__2__7_ dfcrq2 $PINS D=n521 CP=ZCTSNET_4 CDN=rst_n Q=bank_a[55]
+ VDD=VDD VSS=VSS
Xbank_a_reg_1__0__6_ dfcrq2 $PINS D=n519 CP=ZCTSNET_61 CDN=HFSNET_50
+ Q=bank_a[38] VDD=VDD VSS=VSS
Xbank_a_reg_1__1__6_ dfcrq2 $PINS D=n518 CP=ZCTSNET_66 CDN=HFSNET_46
+ Q=bank_a[46] VDD=VDD VSS=VSS
Xbank_a_reg_1__2__6_ dfcrq2 $PINS D=n517 CP=ZCTSNET_63 CDN=HFSNET_46
+ Q=bank_a[54] VDD=VDD VSS=VSS
Xbank_a_reg_1__0__5_ dfcrq2 $PINS D=n515 CP=ZCTSNET_3 CDN=HFSNET_51
+ Q=bank_a[37] VDD=VDD VSS=VSS
Xbank_a_reg_1__1__5_ dfcrq2 $PINS D=n514 CP=ZCTSNET_63 CDN=HFSNET_44
+ Q=bank_a[45] VDD=VDD VSS=VSS
Xbank_a_reg_1__2__5_ dfcrq2 $PINS D=n513 CP=ZCTSNET_3 CDN=HFSNET_51
+ Q=bank_a[53] VDD=VDD VSS=VSS
Xbank_a_reg_1__0__4_ dfcrq2 $PINS D=n511 CP=ZCTSNET_3 CDN=HFSNET_46
+ Q=bank_a[36] VDD=VDD VSS=VSS
Xbank_a_reg_1__1__4_ dfcrq2 $PINS D=n510 CP=ZCTSNET_68 CDN=HFSNET_46
+ Q=bank_a[44] VDD=VDD VSS=VSS
Xbank_a_reg_1__2__4_ dfcrq2 $PINS D=n509 CP=ZCTSNET_68 CDN=HFSNET_44
+ Q=bank_a[52] VDD=VDD VSS=VSS
Xbank_a_reg_1__0__3_ dfcrq2 $PINS D=n507 CP=ZCTSNET_68 CDN=HFSNET_51
+ Q=bank_a[35] VDD=VDD VSS=VSS
Xbank_a_reg_1__1__3_ dfcrq2 $PINS D=n506 CP=ZCTSNET_68 CDN=HFSNET_51
+ Q=bank_a[43] VDD=VDD VSS=VSS
Xbank_a_reg_1__2__3_ dfcrq2 $PINS D=n505 CP=ZCTSNET_68 CDN=HFSNET_51
+ Q=bank_a[51] VDD=VDD VSS=VSS
Xbank_a_reg_1__0__2_ dfcrq2 $PINS D=n503 CP=ZCTSNET_68 CDN=HFSNET_51
+ Q=bank_a[34] VDD=VDD VSS=VSS
Xbank_a_reg_1__1__2_ dfcrq2 $PINS D=n502 CP=ZCTSNET_68 CDN=HFSNET_51
+ Q=bank_a[42] VDD=VDD VSS=VSS
Xbank_a_reg_1__2__2_ dfcrq2 $PINS D=n501 CP=ZCTSNET_68 CDN=HFSNET_51
+ Q=bank_a[50] VDD=VDD VSS=VSS
Xbank_a_reg_1__0__1_ dfcrq2 $PINS D=n499 CP=ZCTSNET_61 CDN=HFSNET_49
+ Q=bank_a[33] VDD=VDD VSS=VSS
Xbank_a_reg_1__1__1_ dfcrq2 $PINS D=n498 CP=ZCTSNET_61 CDN=HFSNET_49
+ Q=bank_a[41] VDD=VDD VSS=VSS
Xbank_a_reg_1__2__1_ dfcrq2 $PINS D=n497 CP=ZCTSNET_68 CDN=HFSNET_51
+ Q=bank_a[49] VDD=VDD VSS=VSS
Xbank_a_reg_1__0__0_ dfcrq2 $PINS D=n495 CP=ZCTSNET_61 CDN=HFSNET_49
+ Q=bank_a[32] VDD=VDD VSS=VSS
Xbank_a_reg_1__1__0_ dfcrq2 $PINS D=n494 CP=ZCTSNET_68 CDN=HFSNET_51
+ Q=bank_a[40] VDD=VDD VSS=VSS
Xbank_a_reg_1__2__0_ dfcrq2 $PINS D=n493 CP=ZCTSNET_68 CDN=HFSNET_51
+ Q=bank_a[48] VDD=VDD VSS=VSS
Xn_lat_reg_0_ dfcrq2 $PINS D=n621 CP=ZCTSNET_64 CDN=HFSNET_55 Q=n_lat[0]
+ VDD=VDD VSS=VSS
Xn_lat_reg_1_ dfcrq2 $PINS D=n622 CP=ZCTSNET_64 CDN=HFSNET_55 Q=n_lat[1]
+ VDD=VDD VSS=VSS
Xn_lat_reg_2_ dfcrq2 $PINS D=n623 CP=ZCTSNET_64 CDN=HFSNET_55 Q=n_lat[2]
+ VDD=VDD VSS=VSS
Xk_lat_reg_2_ dfcrq2 $PINS D=n620 CP=ZCTSNET_64 CDN=HFSNET_55 Q=k_lat[2]
+ VDD=VDD VSS=VSS
Xactive_sel_reg dfcrq2 $PINS D=HFSNET_36 CP=ZCTSNET_62 CDN=HFSNET_55
+ Q=active_sel VDD=VDD VSS=VSS
Xactive_load_reg dfcrq2 $PINS D=n629 CP=ZCTSNET_70 CDN=HFSNET_55 Q=active_load
+ VDD=VDD VSS=VSS
Xk_lat_reg_1_ dfcrq2 $PINS D=n619 CP=ZCTSNET_64 CDN=HFSNET_55 Q=k_lat[1]
+ VDD=VDD VSS=VSS
Xk_lat_reg_0_ dfcrq2 $PINS D=n618 CP=ZCTSNET_64 CDN=HFSNET_52 Q=k_lat[0]
+ VDD=VDD VSS=VSS
XHFSBUF_1530_478 buffd1 $PINS I=HFSNET_28 Z=HFSNET_24 VDD=VDD VSS=VSS
XHFSINV_1131_680 inv0d2 $PINS I=HFSNET_56 ZN=HFSNET_45 VDD=VDD VSS=VSS
XHFSBUF_3803_470 buffd1 $PINS I=HFSNET_19 Z=HFSNET_16 VDD=VDD VSS=VSS
XHFSBUF_8533_471 buffd1 $PINS I=HFSNET_19 Z=HFSNET_17 VDD=VDD VSS=VSS
XHFSBUF_20245_472 buffd1 $PINS I=HFSNET_19 Z=HFSNET_18 VDD=VDD VSS=VSS
XU142 inv0d0 $PINS I=n352 ZN=n650 VDD=VDD VSS=VSS
XHFSBUF_5986_479 buffd1 $PINS I=HFSNET_28 Z=HFSNET_25 VDD=VDD VSS=VSS
XHFSBUF_14753_480 buffd1 $PINS I=HFSNET_28 Z=HFSNET_26 VDD=VDD VSS=VSS
XHFSBUF_9388_481 buffd1 $PINS I=HFSNET_28 Z=HFSNET_27 VDD=VDD VSS=VSS
XHFSINV_22296_482 inv0d1 $PINS I=copt_net_237 ZN=HFSNET_28 VDD=VDD VSS=VSS
XHFSBUF_5948_483 buffd1 $PINS I=copt_net_237 Z=HFSNET_29 VDD=VDD VSS=VSS
XHFSBUF_14727_484 buffd1 $PINS I=copt_net_237 Z=HFSNET_30 VDD=VDD VSS=VSS
XHFSBUF_9191_485 buffd1 $PINS I=copt_net_237 Z=HFSNET_31 VDD=VDD VSS=VSS
XctmTdsLR_1_1274 oaim21d1 $PINS B1=n94 B2=copt_net_2005 A=copt_net_1054
+ ZN=tmp_net110 VDD=VDD VSS=VSS
XHFSBUF_15306_522 buffd1 $PINS I=HFSNET_40 Z=HFSNET_33 VDD=VDD VSS=VSS
XHFSINV_3049_690 inv0d2 $PINS I=HFSNET_56 ZN=HFSNET_50 VDD=VDD VSS=VSS
XU164 nr02d1 $PINS A1=n651 A2=array_en ZN=n352 VDD=VDD VSS=VSS
XHFSBUF_19554_523 buffd1 $PINS I=HFSNET_40 Z=HFSNET_34 VDD=VDD VSS=VSS
XHFSBUF_20457_524 buffd1 $PINS I=HFSNET_40 Z=HFSNET_35 VDD=VDD VSS=VSS
XHFSINV_4278_525 inv0d1 $PINS I=HFSNET_40 ZN=HFSNET_36 VDD=VDD VSS=VSS
XHFSINV_15143_526 inv0d1 $PINS I=HFSNET_40 ZN=HFSNET_37 VDD=VDD VSS=VSS
XHFSINV_16106_527 inv0d1 $PINS I=HFSNET_40 ZN=HFSNET_38 VDD=VDD VSS=VSS
XU176 nd02d1 $PINS A1=n317 A2=HFSNET_24 ZN=n308 VDD=VDD VSS=VSS
XHFSINV_11090_528 inv0d2 $PINS I=HFSNET_40 ZN=HFSNET_39 VDD=VDD VSS=VSS
Xcopt_h_inst_3067 buffd1 $PINS I=n287 Z=copt_net_237 VDD=VDD VSS=VSS
XHFSINV_1401_693 inv0d2 $PINS I=HFSNET_56 ZN=HFSNET_53 VDD=VDD VSS=VSS
XHFSINV_20862_473 inv0d2 $PINS I=n329 ZN=HFSNET_19 VDD=VDD VSS=VSS
XU186 nd02d1 $PINS A1=HFSNET_18 A2=n317 ZN=n336 VDD=VDD VSS=VSS
XctmTdsLR_2_1275 aon211d1 $PINS C1=n350 C2=copt_net_2005 B=copt_net_1808
+ A=tmp_net110 ZN=tmp_net111 VDD=VDD VSS=VSS
XHFSBUF_12912_475 buffd1 $PINS I=n329 Z=HFSNET_21 VDD=VDD VSS=VSS
XHFSBUF_8857_476 buffd1 $PINS I=n329 Z=HFSNET_22 VDD=VDD VSS=VSS
XHFSBUF_3870_477 buffd1 $PINS I=n329 Z=HFSNET_23 VDD=VDD VSS=VSS
XctmTdsLR_3_1276 nd03d0 $PINS A1=n651 A2=tmp_net111 A3=copt_net_1192 ZN=n344
+ VDD=VDD VSS=VSS
Xcopt_h_inst_3149 dl02d1 $PINS I=n312 Z=copt_net_319 VDD=VDD VSS=VSS
Xcopt_h_inst_3170 dl02d1 $PINS I=n321 Z=copt_net_340 VDD=VDD VSS=VSS
Xcopt_h_inst_3185 dl02d1 $PINS I=n260 Z=copt_net_355 VDD=VDD VSS=VSS
Xcopt_h_inst_3316 dl02d1 $PINS I=n131 Z=copt_net_486 VDD=VDD VSS=VSS
Xcopt_h_inst_3343 dl02d1 $PINS I=n326 Z=copt_net_513 VDD=VDD VSS=VSS
Xcopt_h_inst_3473 dl02d1 $PINS I=n337 Z=copt_net_643 VDD=VDD VSS=VSS
Xcopt_h_inst_3540 dl02d1 $PINS I=n303 Z=copt_net_710 VDD=VDD VSS=VSS
Xcopt_h_inst_3558 dl02d1 $PINS I=n255 Z=copt_net_728 VDD=VDD VSS=VSS
Xcopt_h_inst_3564 dl02d1 $PINS I=n293 Z=copt_net_733 VDD=VDD VSS=VSS
Xcopt_h_inst_3589 dl02d1 $PINS I=n310 Z=copt_net_758 VDD=VDD VSS=VSS
Xcopt_h_inst_3685 dl02d1 $PINS I=n128 Z=copt_net_853 VDD=VDD VSS=VSS
Xcopt_h_inst_3710 dl01d1 $PINS I=n353 Z=copt_net_878 VDD=VDD VSS=VSS
Xcopt_h_inst_3778 dl02d1 $PINS I=n117 Z=copt_net_946 VDD=VDD VSS=VSS
Xcopt_h_inst_3826 dl02d1 $PINS I=n275 Z=copt_net_994 VDD=VDD VSS=VSS
Xcopt_h_inst_3838 dl02d1 $PINS I=n168 Z=copt_net_1006 VDD=VDD VSS=VSS
Xcopt_h_inst_3841 dl02d1 $PINS I=n111 Z=copt_net_1009 VDD=VDD VSS=VSS
Xcopt_h_inst_3856 dl02d1 $PINS I=n188 Z=copt_net_1024 VDD=VDD VSS=VSS
Xcopt_h_inst_3872 dl01d1 $PINS I=n270 Z=copt_net_1040 VDD=VDD VSS=VSS
Xcopt_h_inst_3886 dl02d1 $PINS I=n625 Z=copt_net_1054 VDD=VDD VSS=VSS
Xcopt_h_inst_3905 dl01d1 $PINS I=n315 Z=copt_net_1073 VDD=VDD VSS=VSS
Xcopt_h_inst_3906 dl01d1 $PINS I=n315 Z=copt_net_1074 VDD=VDD VSS=VSS
Xcopt_h_inst_3913 dl01d1 $PINS I=n151 Z=copt_net_1081 VDD=VDD VSS=VSS
Xcopt_h_inst_3914 dl01d1 $PINS I=n151 Z=copt_net_1082 VDD=VDD VSS=VSS
Xcopt_h_inst_3922 dl02d1 $PINS I=n222 Z=copt_net_1090 VDD=VDD VSS=VSS
Xcopt_h_inst_3929 dl02d1 $PINS I=n647 Z=copt_net_1097 VDD=VDD VSS=VSS
Xcopt_gre_h_inst_5859 dl01d1 $PINS I=n115 Z=copt_gre_net_3203 VDD=VDD VSS=VSS
Xcopt_h_inst_3943 dl02d1 $PINS I=n135 Z=copt_net_1111 VDD=VDD VSS=VSS
Xcopt_h_inst_3944 dl01d1 $PINS I=n347 Z=copt_net_1112 VDD=VDD VSS=VSS
Xcopt_h_inst_3948 dl02d1 $PINS I=n271 Z=copt_net_1116 VDD=VDD VSS=VSS
Xcopt_h_inst_3950 dl02d1 $PINS I=n133 Z=copt_net_1118 VDD=VDD VSS=VSS
Xcopt_h_inst_3960 dl01d1 $PINS I=n302 Z=copt_net_1128 VDD=VDD VSS=VSS
Xcopt_h_inst_3969 dl02d1 $PINS I=n305 Z=copt_net_1137 VDD=VDD VSS=VSS
Xcopt_h_inst_3975 dl02d1 $PINS I=n155 Z=copt_net_1143 VDD=VDD VSS=VSS
Xcopt_h_inst_3990 dl02d1 $PINS I=n316 Z=copt_net_1158 VDD=VDD VSS=VSS
Xcopt_h_inst_3994 dl02d1 $PINS I=n159 Z=copt_net_1162 VDD=VDD VSS=VSS
Xcopt_h_inst_3995 dl01d1 $PINS I=n109 Z=copt_net_1163 VDD=VDD VSS=VSS
XU270 nd02d1 $PINS A1=n92 A2=HFSNET_27 ZN=n288 VDD=VDD VSS=VSS
Xcopt_h_inst_4006 dl02d1 $PINS I=n139 Z=copt_net_1174 VDD=VDD VSS=VSS
Xcopt_h_inst_4010 dl02d1 $PINS I=n219 Z=copt_net_1178 VDD=VDD VSS=VSS
XU276 inv0d0 $PINS I=load_start ZN=n651 VDD=VDD VSS=VSS
XU278 nd02d1 $PINS A1=HFSNET_18 A2=n92 ZN=n330 VDD=VDD VSS=VSS
Xcopt_h_inst_4020 dl01d1 $PINS I=n354 Z=copt_net_1188 VDD=VDD VSS=VSS
Xcopt_h_inst_4021 dl01d1 $PINS I=n354 Z=copt_net_1189 VDD=VDD VSS=VSS
Xcopt_h_inst_4023 dl01d1 $PINS I=n263 Z=copt_net_1191 VDD=VDD VSS=VSS
Xcopt_h_inst_4024 dl02d1 $PINS I=n97 Z=copt_net_1192 VDD=VDD VSS=VSS
Xcopt_h_inst_4038 dl01d1 $PINS I=n634 Z=copt_net_1206 VDD=VDD VSS=VSS
Xcopt_h_inst_4049 dl02d1 $PINS I=n225 Z=copt_net_1217 VDD=VDD VSS=VSS
Xcopt_h_inst_4051 dl02d1 $PINS I=n643 Z=copt_net_1219 VDD=VDD VSS=VSS
Xcopt_h_inst_4057 dl02d1 $PINS I=n314 Z=copt_net_1225 VDD=VDD VSS=VSS
Xcopt_h_inst_4060 dl01d1 $PINS I=n632 Z=copt_net_1228 VDD=VDD VSS=VSS
XU300 nd02d0 $PINS A1=HFSNET_24 A2=n327 ZN=n318 VDD=VDD VSS=VSS
Xcopt_h_inst_4061 dl02d1 $PINS I=n632 Z=copt_net_1229 VDD=VDD VSS=VSS
XU304 nd02d1 $PINS A1=n91 A2=HFSNET_27 ZN=n298 VDD=VDD VSS=VSS
Xcopt_h_inst_4062 dl02d1 $PINS I=n108 Z=copt_net_1230 VDD=VDD VSS=VSS
XU308 nd02d1 $PINS A1=HFSNET_18 A2=n91 ZN=n331 VDD=VDD VSS=VSS
XU310 inv0d0 $PINS I=n335 ZN=n92 VDD=VDD VSS=VSS
XU312 inv0d0 $PINS I=n340 ZN=n93 VDD=VDD VSS=VSS
XU314 nd02d1 $PINS A1=n651 A2=n90 ZN=load_busy_gOb4 VDD=VDD VSS=VSS
XU316 nd02d0 $PINS A1=HFSNET_16 A2=n327 ZN=n338 VDD=VDD VSS=VSS
XU318 nd02d1 $PINS A1=n651 A2=n96 ZN=n334 VDD=VDD VSS=VSS
XU320 nd02d0 $PINS A1=n355 A2=n650 ZN=n360 VDD=VDD VSS=VSS
XU322 nd02d1 $PINS A1=load_start A2=load_n[2] ZN=n333 VDD=VDD VSS=VSS
Xcopt_h_inst_4063 dl01d1 $PINS I=n127 Z=copt_net_1231 VDD=VDD VSS=VSS
Xcopt_h_inst_4064 dl01d1 $PINS I=n127 Z=copt_net_1232 VDD=VDD VSS=VSS
Xcopt_h_inst_4069 dl01d1 $PINS I=n203 Z=copt_net_1237 VDD=VDD VSS=VSS
Xcopt_h_inst_4070 dl01d1 $PINS I=n630 Z=copt_net_1238 VDD=VDD VSS=VSS
Xcopt_h_inst_4073 dl01d1 $PINS I=n194 Z=copt_net_1241 VDD=VDD VSS=VSS
Xcopt_h_inst_4077 dl02d1 $PINS I=n98 Z=copt_net_1245 VDD=VDD VSS=VSS
Xcopt_h_inst_4089 dl02d1 $PINS I=n247 Z=copt_net_1257 VDD=VDD VSS=VSS
XU341 inv0d0 $PINS I=n332 ZN=n91 VDD=VDD VSS=VSS
XU343 nd03d1 $PINS A1=n651 A2=n94 A3=n356 ZN=n358 VDD=VDD VSS=VSS
XU345 nd03d1 $PINS A1=HFSNET_41 A2=load_busy_gOb4 A3=copt_net_2726 ZN=n329
+ VDD=VDD VSS=VSS
XHFSINV_117_297 inv0d1 $PINS I=load_row[1] ZN=HFSNET_15 VDD=VDD VSS=VSS
Xcopt_h_inst_4093 dl01d1 $PINS I=n171 Z=copt_net_1261 VDD=VDD VSS=VSS
Xcopt_h_inst_4095 dl01d1 $PINS I=n289 Z=copt_net_1263 VDD=VDD VSS=VSS
XU353 inv0d0 $PINS I=load_row[12] ZN=n664 VDD=VDD VSS=VSS
Xcopt_h_inst_4101 dl01d1 $PINS I=n179 Z=copt_net_1269 VDD=VDD VSS=VSS
XU357 inv0d0 $PINS I=load_row[14] ZN=n666 VDD=VDD VSS=VSS
XU359 inv0d0 $PINS I=load_row[15] ZN=n667 VDD=VDD VSS=VSS
XU361 inv0d0 $PINS I=load_row[16] ZN=n668 VDD=VDD VSS=VSS
XU363 inv0d0 $PINS I=load_row[17] ZN=n669 VDD=VDD VSS=VSS
XU365 inv0d0 $PINS I=load_row[18] ZN=n670 VDD=VDD VSS=VSS
XU367 inv0d0 $PINS I=load_row[19] ZN=n671 VDD=VDD VSS=VSS
XU369 inv0d0 $PINS I=load_row[20] ZN=n672 VDD=VDD VSS=VSS
XU371 inv0d0 $PINS I=load_row[21] ZN=n673 VDD=VDD VSS=VSS
XU373 inv0d0 $PINS I=load_row[22] ZN=n674 VDD=VDD VSS=VSS
XU375 inv0d0 $PINS I=load_row[23] ZN=n675 VDD=VDD VSS=VSS
XU377 inv0d0 $PINS I=load_row[24] ZN=n676 VDD=VDD VSS=VSS
XU379 inv0d0 $PINS I=load_row[25] ZN=n677 VDD=VDD VSS=VSS
XU381 inv0d0 $PINS I=load_row[26] ZN=n678 VDD=VDD VSS=VSS
Xcopt_h_inst_4106 dl01d1 $PINS I=n187 Z=copt_net_1274 VDD=VDD VSS=VSS
XU385 inv0d0 $PINS I=load_row[0] ZN=n652 VDD=VDD VSS=VSS
XU387 inv0d0 $PINS I=load_row[2] ZN=n654 VDD=VDD VSS=VSS
XU389 inv0d0 $PINS I=load_row[3] ZN=n655 VDD=VDD VSS=VSS
XHFSINV_113_290 inv0d1 $PINS I=load_row[4] ZN=HFSNET_13 VDD=VDD VSS=VSS
XU391 inv0d0 $PINS I=load_row[5] ZN=n657 VDD=VDD VSS=VSS
XU394 inv0d0 $PINS I=load_row[6] ZN=n658 VDD=VDD VSS=VSS
XU396 inv0d0 $PINS I=load_row[7] ZN=n659 VDD=VDD VSS=VSS
XU400 inv0d0 $PINS I=load_row[27] ZN=n679 VDD=VDD VSS=VSS
XU402 inv0d0 $PINS I=load_row[28] ZN=n680 VDD=VDD VSS=VSS
XU404 inv0d0 $PINS I=load_row[29] ZN=n681 VDD=VDD VSS=VSS
XU406 inv0d0 $PINS I=load_row[30] ZN=n682 VDD=VDD VSS=VSS
XU407 inv0d0 $PINS I=load_row[31] ZN=n683 VDD=VDD VSS=VSS
XU409 inv0d0 $PINS I=copt_net_1938 ZN=n94 VDD=VDD VSS=VSS
XU411 nr02d0 $PINS A1=copt_net_1054 A2=copt_net_1938 ZN=n350 VDD=VDD VSS=VSS
XU413 nd03d0 $PINS A1=n350 A2=HFSNET_41 A3=copt_net_2651 ZN=n355 VDD=VDD
+ VSS=VSS
Xcopt_h_inst_4117 dl01d1 $PINS I=n306 Z=copt_net_1285 VDD=VDD VSS=VSS
XU416 inv0d0 $PINS I=copt_net_2651 ZN=n90 VDD=VDD VSS=VSS
XU418 inv0d0 $PINS I=k_lat[2] ZN=n97 VDD=VDD VSS=VSS
Xcopt_h_inst_4120 dl02d1 $PINS I=n195 Z=copt_net_1288 VDD=VDD VSS=VSS
XU422 inv0d0 $PINS I=n_lat[2] ZN=n96 VDD=VDD VSS=VSS
XU424 inv0d0 $PINS I=bank_a[48] ZN=n221 VDD=VDD VSS=VSS
XU425 inv0d0 $PINS I=bank_a[40] ZN=n220 VDD=VDD VSS=VSS
XU427 inv0d0 $PINS I=bank_a[32] ZN=n219 VDD=VDD VSS=VSS
XU429 inv0d0 $PINS I=copt_net_2522 ZN=n217 VDD=VDD VSS=VSS
XU431 inv0d0 $PINS I=bank_a[41] ZN=n216 VDD=VDD VSS=VSS
XU433 inv0d0 $PINS I=bank_a[33] ZN=n215 VDD=VDD VSS=VSS
XU434 inv0d0 $PINS I=bank_a[50] ZN=n213 VDD=VDD VSS=VSS
XU436 inv0d0 $PINS I=bank_a[42] ZN=n212 VDD=VDD VSS=VSS
XU438 inv0d0 $PINS I=bank_a[34] ZN=n211 VDD=VDD VSS=VSS
XU440 inv0d0 $PINS I=bank_a[51] ZN=n209 VDD=VDD VSS=VSS
XU442 inv0d0 $PINS I=bank_a[43] ZN=n208 VDD=VDD VSS=VSS
XU443 inv0d0 $PINS I=copt_net_2499 ZN=n207 VDD=VDD VSS=VSS
XU445 inv0d0 $PINS I=bank_a[52] ZN=n205 VDD=VDD VSS=VSS
XU447 inv0d0 $PINS I=copt_net_2492 ZN=n204 VDD=VDD VSS=VSS
XU449 inv0d0 $PINS I=copt_net_2721 ZN=n203 VDD=VDD VSS=VSS
XU451 inv0d0 $PINS I=bank_a[53] ZN=n201 VDD=VDD VSS=VSS
XU452 inv0d0 $PINS I=copt_net_2624 ZN=n200 VDD=VDD VSS=VSS
XU454 inv0d0 $PINS I=bank_a[37] ZN=n199 VDD=VDD VSS=VSS
XU456 inv0d0 $PINS I=bank_a[54] ZN=n197 VDD=VDD VSS=VSS
XU458 inv0d0 $PINS I=bank_a[46] ZN=n196 VDD=VDD VSS=VSS
XU460 inv0d0 $PINS I=bank_a[38] ZN=n195 VDD=VDD VSS=VSS
XU461 inv0d0 $PINS I=bank_a[55] ZN=n193 VDD=VDD VSS=VSS
XU463 inv0d0 $PINS I=bank_a[47] ZN=n192 VDD=VDD VSS=VSS
XU465 inv0d0 $PINS I=bank_a[39] ZN=n191 VDD=VDD VSS=VSS
XU467 inv0d0 $PINS I=bank_a[80] ZN=n189 VDD=VDD VSS=VSS
XU469 inv0d0 $PINS I=bank_a[72] ZN=n188 VDD=VDD VSS=VSS
XU470 inv0d0 $PINS I=bank_a[64] ZN=n187 VDD=VDD VSS=VSS
XU471 inv0d0 $PINS I=copt_net_2704 ZN=n185 VDD=VDD VSS=VSS
XU473 inv0d0 $PINS I=bank_a[73] ZN=n184 VDD=VDD VSS=VSS
XU475 inv0d0 $PINS I=bank_a[65] ZN=n183 VDD=VDD VSS=VSS
XU477 inv0d0 $PINS I=bank_a[82] ZN=n181 VDD=VDD VSS=VSS
XU479 inv0d0 $PINS I=bank_a[74] ZN=n180 VDD=VDD VSS=VSS
XU480 inv0d0 $PINS I=bank_a[66] ZN=n179 VDD=VDD VSS=VSS
XU482 inv0d0 $PINS I=bank_a[83] ZN=n177 VDD=VDD VSS=VSS
XU484 inv0d0 $PINS I=bank_a[75] ZN=n176 VDD=VDD VSS=VSS
XU486 inv0d0 $PINS I=bank_a[67] ZN=n175 VDD=VDD VSS=VSS
XU488 inv0d0 $PINS I=bank_a[84] ZN=n173 VDD=VDD VSS=VSS
XU489 inv0d0 $PINS I=copt_net_2386 ZN=n172 VDD=VDD VSS=VSS
XU491 inv0d0 $PINS I=bank_a[68] ZN=n171 VDD=VDD VSS=VSS
XU493 inv0d0 $PINS I=bank_a[85] ZN=n169 VDD=VDD VSS=VSS
XU495 inv0d0 $PINS I=bank_a[77] ZN=n168 VDD=VDD VSS=VSS
XU497 inv0d0 $PINS I=bank_a[69] ZN=n167 VDD=VDD VSS=VSS
XU498 inv0d0 $PINS I=copt_net_2283 ZN=n165 VDD=VDD VSS=VSS
XU500 inv0d0 $PINS I=bank_a[78] ZN=n164 VDD=VDD VSS=VSS
XU502 inv0d0 $PINS I=bank_a[70] ZN=n163 VDD=VDD VSS=VSS
XU504 inv0d0 $PINS I=bank_a[87] ZN=n161 VDD=VDD VSS=VSS
XU506 inv0d0 $PINS I=copt_net_2490 ZN=n160 VDD=VDD VSS=VSS
XU507 inv0d0 $PINS I=bank_a[71] ZN=n159 VDD=VDD VSS=VSS
XU509 inv0d0 $PINS I=copt_net_2706 ZN=n157 VDD=VDD VSS=VSS
XU511 inv0d0 $PINS I=bank_a[104] ZN=n156 VDD=VDD VSS=VSS
XU513 inv0d0 $PINS I=bank_a[96] ZN=n155 VDD=VDD VSS=VSS
XU515 inv0d0 $PINS I=bank_a[113] ZN=n153 VDD=VDD VSS=VSS
XU516 inv0d0 $PINS I=bank_a[105] ZN=n152 VDD=VDD VSS=VSS
XU518 inv0d0 $PINS I=bank_a[97] ZN=n151 VDD=VDD VSS=VSS
XU520 inv0d0 $PINS I=bank_a[114] ZN=n149 VDD=VDD VSS=VSS
XU522 inv0d0 $PINS I=bank_a[106] ZN=n148 VDD=VDD VSS=VSS
XU524 inv0d0 $PINS I=bank_a[98] ZN=n147 VDD=VDD VSS=VSS
XU525 inv0d0 $PINS I=bank_a[115] ZN=n145 VDD=VDD VSS=VSS
XU527 inv0d0 $PINS I=bank_a[107] ZN=n144 VDD=VDD VSS=VSS
XU529 inv0d0 $PINS I=copt_net_2543 ZN=n143 VDD=VDD VSS=VSS
XU531 inv0d0 $PINS I=bank_a[116] ZN=n141 VDD=VDD VSS=VSS
XU533 inv0d0 $PINS I=bank_a[108] ZN=n140 VDD=VDD VSS=VSS
XU534 inv0d0 $PINS I=bank_a[100] ZN=n139 VDD=VDD VSS=VSS
XU536 inv0d0 $PINS I=bank_a[117] ZN=n137 VDD=VDD VSS=VSS
XU538 inv0d0 $PINS I=bank_a[109] ZN=n136 VDD=VDD VSS=VSS
XU540 inv0d0 $PINS I=bank_a[101] ZN=n135 VDD=VDD VSS=VSS
XU542 inv0d0 $PINS I=bank_a[118] ZN=n133 VDD=VDD VSS=VSS
XU543 inv0d0 $PINS I=bank_a[110] ZN=n132 VDD=VDD VSS=VSS
XU545 inv0d0 $PINS I=bank_a[102] ZN=n131 VDD=VDD VSS=VSS
XU546 inv0d0 $PINS I=bank_a[119] ZN=n129 VDD=VDD VSS=VSS
XU547 inv0d0 $PINS I=bank_a[111] ZN=n128 VDD=VDD VSS=VSS
XU549 inv0d0 $PINS I=bank_a[103] ZN=n127 VDD=VDD VSS=VSS
XU551 inv0d0 $PINS I=bank_a[16] ZN=n125 VDD=VDD VSS=VSS
XU553 inv0d0 $PINS I=bank_a[8] ZN=n124 VDD=VDD VSS=VSS
XU555 inv0d0 $PINS I=bank_a[0] ZN=n123 VDD=VDD VSS=VSS
XU556 inv0d0 $PINS I=bank_a[18] ZN=n121 VDD=VDD VSS=VSS
XU558 inv0d0 $PINS I=bank_a[10] ZN=n120 VDD=VDD VSS=VSS
XU560 inv0d0 $PINS I=bank_a[2] ZN=n119 VDD=VDD VSS=VSS
XU562 inv0d0 $PINS I=bank_a[19] ZN=n117 VDD=VDD VSS=VSS
XU564 inv0d0 $PINS I=bank_a[11] ZN=n116 VDD=VDD VSS=VSS
XU565 inv0d0 $PINS I=bank_a[3] ZN=n115 VDD=VDD VSS=VSS
XU567 inv0d0 $PINS I=bank_a[20] ZN=n113 VDD=VDD VSS=VSS
XU569 inv0d0 $PINS I=bank_a[12] ZN=n112 VDD=VDD VSS=VSS
XU571 inv0d0 $PINS I=bank_a[4] ZN=n111 VDD=VDD VSS=VSS
XU573 inv0d0 $PINS I=bank_a[21] ZN=n110 VDD=VDD VSS=VSS
XU574 inv0d0 $PINS I=bank_a[13] ZN=n109 VDD=VDD VSS=VSS
XU576 inv0d0 $PINS I=bank_a[5] ZN=n108 VDD=VDD VSS=VSS
XU578 inv0d0 $PINS I=copt_net_2462 ZN=n107 VDD=VDD VSS=VSS
XU580 inv0d0 $PINS I=bank_a[14] ZN=n106 VDD=VDD VSS=VSS
XU582 inv0d0 $PINS I=bank_a[6] ZN=n105 VDD=VDD VSS=VSS
XU583 inv0d0 $PINS I=bank_a[23] ZN=n104 VDD=VDD VSS=VSS
XU585 inv0d0 $PINS I=bank_a[15] ZN=n103 VDD=VDD VSS=VSS
XU587 inv0d0 $PINS I=bank_a[7] ZN=n102 VDD=VDD VSS=VSS
XU589 inv0d0 $PINS I=copt_net_2453 ZN=n100 VDD=VDD VSS=VSS
XU591 inv0d0 $PINS I=bank_a[9] ZN=n99 VDD=VDD VSS=VSS
XU592 inv0d0 $PINS I=bank_a[1] ZN=n98 VDD=VDD VSS=VSS
XU594 inv0d0 $PINS I=bank_a[24] ZN=n126 VDD=VDD VSS=VSS
XU596 inv0d0 $PINS I=bank_a[25] ZN=n101 VDD=VDD VSS=VSS
XU598 inv0d0 $PINS I=bank_a[26] ZN=n122 VDD=VDD VSS=VSS
XU600 inv0d0 $PINS I=bank_a[27] ZN=n118 VDD=VDD VSS=VSS
XU601 inv0d0 $PINS I=bank_a[28] ZN=n114 VDD=VDD VSS=VSS
XU603 inv0d0 $PINS I=bank_a[29] ZN=n225 VDD=VDD VSS=VSS
XU605 inv0d0 $PINS I=bank_a[30] ZN=n224 VDD=VDD VSS=VSS
XU607 inv0d0 $PINS I=bank_a[31] ZN=n223 VDD=VDD VSS=VSS
XU609 inv0d0 $PINS I=bank_a[56] ZN=n222 VDD=VDD VSS=VSS
XU610 inv0d0 $PINS I=bank_a[57] ZN=n218 VDD=VDD VSS=VSS
XU612 inv0d0 $PINS I=bank_a[58] ZN=n214 VDD=VDD VSS=VSS
XU614 inv0d0 $PINS I=bank_a[59] ZN=n210 VDD=VDD VSS=VSS
XU616 inv0d0 $PINS I=bank_a[60] ZN=n206 VDD=VDD VSS=VSS
XU618 inv0d0 $PINS I=bank_a[61] ZN=n202 VDD=VDD VSS=VSS
XU620 inv0d0 $PINS I=bank_a[62] ZN=n198 VDD=VDD VSS=VSS
XU621 inv0d0 $PINS I=bank_a[63] ZN=n194 VDD=VDD VSS=VSS
XU623 inv0d0 $PINS I=bank_a[88] ZN=n190 VDD=VDD VSS=VSS
XU625 inv0d0 $PINS I=bank_a[89] ZN=n186 VDD=VDD VSS=VSS
XU627 inv0d0 $PINS I=bank_a[90] ZN=n182 VDD=VDD VSS=VSS
XU629 inv0d0 $PINS I=copt_net_2430 ZN=n178 VDD=VDD VSS=VSS
XU630 inv0d0 $PINS I=bank_a[92] ZN=n174 VDD=VDD VSS=VSS
XU632 inv0d0 $PINS I=bank_a[93] ZN=n170 VDD=VDD VSS=VSS
XU634 inv0d0 $PINS I=bank_a[94] ZN=n166 VDD=VDD VSS=VSS
XU636 inv0d0 $PINS I=bank_a[95] ZN=n162 VDD=VDD VSS=VSS
XU638 inv0d0 $PINS I=bank_a[120] ZN=n158 VDD=VDD VSS=VSS
XU639 inv0d0 $PINS I=bank_a[121] ZN=n154 VDD=VDD VSS=VSS
XU641 inv0d0 $PINS I=bank_a[122] ZN=n150 VDD=VDD VSS=VSS
XU643 inv0d0 $PINS I=bank_a[123] ZN=n146 VDD=VDD VSS=VSS
XU645 inv0d0 $PINS I=bank_a[124] ZN=n142 VDD=VDD VSS=VSS
XU647 inv0d0 $PINS I=bank_a[125] ZN=n138 VDD=VDD VSS=VSS
XU648 inv0d0 $PINS I=bank_a[126] ZN=n134 VDD=VDD VSS=VSS
XU650 inv0d0 $PINS I=bank_a[127] ZN=n130 VDD=VDD VSS=VSS
XU652 inv0d0 $PINS I=bank_b[48] ZN=n645 VDD=VDD VSS=VSS
XU654 inv0d0 $PINS I=bank_b[40] ZN=n644 VDD=VDD VSS=VSS
XU656 inv0d0 $PINS I=bank_b[32] ZN=n643 VDD=VDD VSS=VSS
XU657 inv0d0 $PINS I=copt_net_2377 ZN=n641 VDD=VDD VSS=VSS
XU659 inv0d0 $PINS I=bank_b[41] ZN=n640 VDD=VDD VSS=VSS
XU661 inv0d0 $PINS I=bank_b[33] ZN=n639 VDD=VDD VSS=VSS
XU663 inv0d0 $PINS I=bank_b[50] ZN=n637 VDD=VDD VSS=VSS
XU664 inv0d0 $PINS I=bank_b[42] ZN=n636 VDD=VDD VSS=VSS
XU666 inv0d0 $PINS I=bank_b[34] ZN=n635 VDD=VDD VSS=VSS
XU668 inv0d0 $PINS I=bank_b[51] ZN=n633 VDD=VDD VSS=VSS
XU670 inv0d0 $PINS I=bank_b[43] ZN=n632 VDD=VDD VSS=VSS
XU671 inv0d0 $PINS I=copt_net_2628 ZN=n631 VDD=VDD VSS=VSS
XU673 inv0d0 $PINS I=bank_b[52] ZN=n617 VDD=VDD VSS=VSS
XU675 inv0d0 $PINS I=bank_b[44] ZN=n359 VDD=VDD VSS=VSS
XU677 inv0d0 $PINS I=bank_b[36] ZN=n354 VDD=VDD VSS=VSS
XU678 inv0d0 $PINS I=copt_net_2660 ZN=n351 VDD=VDD VSS=VSS
XU680 inv0d0 $PINS I=bank_b[45] ZN=n349 VDD=VDD VSS=VSS
XU682 inv0d0 $PINS I=bank_b[37] ZN=n348 VDD=VDD VSS=VSS
XU684 inv0d0 $PINS I=copt_net_2534 ZN=n343 VDD=VDD VSS=VSS
XU686 inv0d0 $PINS I=bank_b[46] ZN=n342 VDD=VDD VSS=VSS
XU689 inv0d0 $PINS I=bank_b[38] ZN=n341 VDD=VDD VSS=VSS
XU690 inv0d0 $PINS I=bank_b[55] ZN=n328 VDD=VDD VSS=VSS
XU691 inv0d0 $PINS I=bank_b[47] ZN=n326 VDD=VDD VSS=VSS
XU695 inv0d0 $PINS I=copt_net_2432 ZN=n325 VDD=VDD VSS=VSS
XU698 inv0d0 $PINS I=bank_b[80] ZN=n323 VDD=VDD VSS=VSS
XU699 inv0d0 $PINS I=bank_b[72] ZN=n322 VDD=VDD VSS=VSS
XU700 inv0d0 $PINS I=bank_b[64] ZN=n321 VDD=VDD VSS=VSS
XU701 inv0d0 $PINS I=bank_b[81] ZN=n319 VDD=VDD VSS=VSS
XU702 inv0d0 $PINS I=bank_b[73] ZN=n316 VDD=VDD VSS=VSS
XU703 inv0d0 $PINS I=bank_b[65] ZN=n315 VDD=VDD VSS=VSS
XU704 inv0d0 $PINS I=bank_b[82] ZN=n313 VDD=VDD VSS=VSS
XU708 inv0d0 $PINS I=bank_b[74] ZN=n312 VDD=VDD VSS=VSS
XU712 inv0d0 $PINS I=copt_net_2686 ZN=n311 VDD=VDD VSS=VSS
XU713 inv0d0 $PINS I=bank_b[83] ZN=n309 VDD=VDD VSS=VSS
XU718 inv0d0 $PINS I=bank_b[75] ZN=n307 VDD=VDD VSS=VSS
XU719 inv0d0 $PINS I=bank_b[67] ZN=n306 VDD=VDD VSS=VSS
XU722 inv0d0 $PINS I=bank_b[84] ZN=n304 VDD=VDD VSS=VSS
XU723 inv0d0 $PINS I=bank_b[76] ZN=n303 VDD=VDD VSS=VSS
XU724 inv0d0 $PINS I=bank_b[68] ZN=n302 VDD=VDD VSS=VSS
XU725 inv0d0 $PINS I=bank_b[85] ZN=n300 VDD=VDD VSS=VSS
XU726 inv0d0 $PINS I=copt_net_2649 ZN=n299 VDD=VDD VSS=VSS
XU727 inv0d0 $PINS I=bank_b[69] ZN=n297 VDD=VDD VSS=VSS
XU728 inv0d0 $PINS I=bank_b[86] ZN=n295 VDD=VDD VSS=VSS
XU729 inv0d0 $PINS I=bank_b[78] ZN=n294 VDD=VDD VSS=VSS
XU730 inv0d0 $PINS I=bank_b[70] ZN=n293 VDD=VDD VSS=VSS
XU731 inv0d0 $PINS I=bank_b[87] ZN=n291 VDD=VDD VSS=VSS
XU732 inv0d0 $PINS I=copt_net_2530 ZN=n290 VDD=VDD VSS=VSS
XU733 inv0d0 $PINS I=bank_b[71] ZN=n289 VDD=VDD VSS=VSS
XU734 inv0d0 $PINS I=bank_b[112] ZN=n285 VDD=VDD VSS=VSS
XU735 inv0d0 $PINS I=bank_b[104] ZN=n284 VDD=VDD VSS=VSS
XU736 inv0d0 $PINS I=bank_b[96] ZN=n283 VDD=VDD VSS=VSS
XU737 inv0d0 $PINS I=copt_net_2714 ZN=n281 VDD=VDD VSS=VSS
XU738 inv0d0 $PINS I=copt_net_2501 ZN=n280 VDD=VDD VSS=VSS
XU739 inv0d0 $PINS I=copt_net_2708 ZN=n279 VDD=VDD VSS=VSS
XU740 inv0d0 $PINS I=copt_net_2451 ZN=n277 VDD=VDD VSS=VSS
XU741 inv0d0 $PINS I=copt_net_2771 ZN=n276 VDD=VDD VSS=VSS
XU742 inv0d0 $PINS I=bank_b[98] ZN=n275 VDD=VDD VSS=VSS
XU743 inv0d0 $PINS I=bank_b[115] ZN=n273 VDD=VDD VSS=VSS
XU744 inv0d0 $PINS I=bank_b[107] ZN=n272 VDD=VDD VSS=VSS
XU745 inv0d0 $PINS I=bank_b[99] ZN=n271 VDD=VDD VSS=VSS
XU746 inv0d0 $PINS I=bank_b[116] ZN=n269 VDD=VDD VSS=VSS
XU747 inv0d0 $PINS I=bank_b[108] ZN=n268 VDD=VDD VSS=VSS
XU748 inv0d0 $PINS I=bank_b[100] ZN=n267 VDD=VDD VSS=VSS
XU749 inv0d0 $PINS I=bank_b[117] ZN=n265 VDD=VDD VSS=VSS
XU750 inv0d0 $PINS I=bank_b[109] ZN=n264 VDD=VDD VSS=VSS
XU751 inv0d0 $PINS I=bank_b[101] ZN=n263 VDD=VDD VSS=VSS
XU752 inv0d0 $PINS I=bank_b[118] ZN=n261 VDD=VDD VSS=VSS
XU753 inv0d0 $PINS I=bank_b[110] ZN=n260 VDD=VDD VSS=VSS
XU754 inv0d0 $PINS I=bank_b[102] ZN=n259 VDD=VDD VSS=VSS
XU755 inv0d0 $PINS I=bank_b[119] ZN=n257 VDD=VDD VSS=VSS
XU756 inv0d0 $PINS I=bank_b[111] ZN=n256 VDD=VDD VSS=VSS
XU757 inv0d0 $PINS I=bank_b[103] ZN=n255 VDD=VDD VSS=VSS
XU758 inv0d0 $PINS I=copt_net_2500 ZN=n253 VDD=VDD VSS=VSS
XU759 inv0d0 $PINS I=bank_b[8] ZN=n252 VDD=VDD VSS=VSS
XU760 inv0d0 $PINS I=bank_b[0] ZN=n251 VDD=VDD VSS=VSS
XU761 inv0d0 $PINS I=bank_b[18] ZN=n249 VDD=VDD VSS=VSS
XU762 inv0d0 $PINS I=copt_net_2532 ZN=n248 VDD=VDD VSS=VSS
XU763 inv0d0 $PINS I=bank_b[2] ZN=n247 VDD=VDD VSS=VSS
XU764 inv0d0 $PINS I=copt_net_2320 ZN=n245 VDD=VDD VSS=VSS
XU765 inv0d0 $PINS I=bank_b[11] ZN=n244 VDD=VDD VSS=VSS
XU766 inv0d0 $PINS I=bank_b[3] ZN=n243 VDD=VDD VSS=VSS
XU767 inv0d0 $PINS I=bank_b[20] ZN=n241 VDD=VDD VSS=VSS
XU768 inv0d0 $PINS I=bank_b[12] ZN=n240 VDD=VDD VSS=VSS
XU769 inv0d0 $PINS I=bank_b[4] ZN=n239 VDD=VDD VSS=VSS
XU770 inv0d0 $PINS I=bank_b[21] ZN=n238 VDD=VDD VSS=VSS
XU771 inv0d0 $PINS I=bank_b[13] ZN=n237 VDD=VDD VSS=VSS
XU772 inv0d0 $PINS I=copt_net_2699 ZN=n236 VDD=VDD VSS=VSS
XU773 inv0d0 $PINS I=bank_b[22] ZN=n235 VDD=VDD VSS=VSS
XU774 inv0d0 $PINS I=bank_b[14] ZN=n234 VDD=VDD VSS=VSS
XU775 inv0d0 $PINS I=bank_b[6] ZN=n233 VDD=VDD VSS=VSS
XU776 inv0d0 $PINS I=copt_net_2638 ZN=n232 VDD=VDD VSS=VSS
XU777 inv0d0 $PINS I=bank_b[15] ZN=n231 VDD=VDD VSS=VSS
XU778 inv0d0 $PINS I=bank_b[7] ZN=n230 VDD=VDD VSS=VSS
XU779 inv0d0 $PINS I=bank_b[17] ZN=n228 VDD=VDD VSS=VSS
XU780 inv0d0 $PINS I=bank_b[9] ZN=n227 VDD=VDD VSS=VSS
XU782 inv0d0 $PINS I=bank_b[24] ZN=n254 VDD=VDD VSS=VSS
XU783 inv0d0 $PINS I=bank_b[25] ZN=n229 VDD=VDD VSS=VSS
XU784 inv0d0 $PINS I=bank_b[26] ZN=n250 VDD=VDD VSS=VSS
XU785 inv0d0 $PINS I=bank_b[27] ZN=n246 VDD=VDD VSS=VSS
XU786 inv0d0 $PINS I=bank_b[28] ZN=n242 VDD=VDD VSS=VSS
XU787 inv0d0 $PINS I=copt_net_2612 ZN=n649 VDD=VDD VSS=VSS
XU788 inv0d0 $PINS I=bank_b[30] ZN=n648 VDD=VDD VSS=VSS
XU789 inv0d0 $PINS I=bank_b[31] ZN=n647 VDD=VDD VSS=VSS
XU790 inv0d0 $PINS I=bank_b[56] ZN=n646 VDD=VDD VSS=VSS
XU791 inv0d0 $PINS I=bank_b[57] ZN=n642 VDD=VDD VSS=VSS
XU792 inv0d0 $PINS I=bank_b[58] ZN=n638 VDD=VDD VSS=VSS
XU793 inv0d0 $PINS I=bank_b[59] ZN=n634 VDD=VDD VSS=VSS
XU794 inv0d0 $PINS I=bank_b[60] ZN=n630 VDD=VDD VSS=VSS
XU795 inv0d0 $PINS I=bank_b[61] ZN=n353 VDD=VDD VSS=VSS
XU796 inv0d0 $PINS I=bank_b[62] ZN=n347 VDD=VDD VSS=VSS
XU797 inv0d0 $PINS I=bank_b[63] ZN=n337 VDD=VDD VSS=VSS
XU798 inv0d0 $PINS I=bank_b[88] ZN=n324 VDD=VDD VSS=VSS
XU799 inv0d0 $PINS I=bank_b[89] ZN=n320 VDD=VDD VSS=VSS
XU800 inv0d0 $PINS I=bank_b[90] ZN=n314 VDD=VDD VSS=VSS
XU801 inv0d0 $PINS I=bank_b[91] ZN=n310 VDD=VDD VSS=VSS
XU802 inv0d0 $PINS I=bank_b[92] ZN=n305 VDD=VDD VSS=VSS
XU803 inv0d0 $PINS I=bank_b[93] ZN=n301 VDD=VDD VSS=VSS
XU804 inv0d0 $PINS I=bank_b[94] ZN=n296 VDD=VDD VSS=VSS
XU805 inv0d0 $PINS I=bank_b[95] ZN=n292 VDD=VDD VSS=VSS
XU806 inv0d0 $PINS I=bank_b[120] ZN=n286 VDD=VDD VSS=VSS
XU807 inv0d0 $PINS I=bank_b[121] ZN=n282 VDD=VDD VSS=VSS
XU808 inv0d0 $PINS I=bank_b[122] ZN=n278 VDD=VDD VSS=VSS
XU809 inv0d0 $PINS I=bank_b[123] ZN=n274 VDD=VDD VSS=VSS
XU810 inv0d0 $PINS I=bank_b[124] ZN=n270 VDD=VDD VSS=VSS
XU811 inv0d0 $PINS I=bank_b[125] ZN=n266 VDD=VDD VSS=VSS
XU812 inv0d0 $PINS I=bank_b[126] ZN=n262 VDD=VDD VSS=VSS
XU813 inv0d0 $PINS I=bank_b[127] ZN=n258 VDD=VDD VSS=VSS
Xcopt_h_inst_4122 dl02d1 $PINS I=n251 Z=copt_net_1290 VDD=VDD VSS=VSS
Xcopt_h_inst_4123 dl02d1 $PINS I=n264 Z=copt_net_1291 VDD=VDD VSS=VSS
Xcopt_h_inst_4125 dl01d1 $PINS I=n348 Z=copt_net_1293 VDD=VDD VSS=VSS
Xcopt_h_inst_4128 dl01d1 $PINS I=n311 Z=copt_net_1296 VDD=VDD VSS=VSS
Xcopt_h_inst_4131 dl02d1 $PINS I=n349 Z=copt_net_1299 VDD=VDD VSS=VSS
Xcopt_h_inst_4133 dl02d1 $PINS I=n126 Z=copt_net_1301 VDD=VDD VSS=VSS
Xcopt_h_inst_4134 dl01d1 $PINS I=n147 Z=copt_net_1302 VDD=VDD VSS=VSS
Xcopt_h_inst_4138 dl02d1 $PINS I=n235 Z=copt_net_1306 VDD=VDD VSS=VSS
Xcopt_h_inst_4139 dl01d1 $PINS I=n235 Z=copt_net_1307 VDD=VDD VSS=VSS
Xcopt_h_inst_4140 dl02d1 $PINS I=n262 Z=copt_net_1308 VDD=VDD VSS=VSS
Xcopt_h_inst_4143 dl01d1 $PINS I=n167 Z=copt_net_1311 VDD=VDD VSS=VSS
Xcopt_h_inst_4148 dl02d1 $PINS I=n209 Z=copt_net_1316 VDD=VDD VSS=VSS
Xcopt_h_inst_4159 dl02d1 $PINS I=n176 Z=copt_net_1327 VDD=VDD VSS=VSS
Xcopt_h_inst_4160 dl01d1 $PINS I=n228 Z=copt_net_1328 VDD=VDD VSS=VSS
Xcopt_h_inst_4161 dl01d1 $PINS I=n228 Z=copt_net_1329 VDD=VDD VSS=VSS
Xcopt_h_inst_4163 dl02d1 $PINS I=n233 Z=copt_net_1331 VDD=VDD VSS=VSS
Xcopt_h_inst_4169 dl01d1 $PINS I=n163 Z=copt_net_1337 VDD=VDD VSS=VSS
Xcopt_h_inst_4170 dl02d1 $PINS I=n110 Z=copt_net_1338 VDD=VDD VSS=VSS
Xcopt_h_inst_4180 dl01d1 $PINS I=n183 Z=copt_net_1348 VDD=VDD VSS=VSS
Xcopt_h_inst_4197 dl02d1 $PINS I=n229 Z=copt_net_1365 VDD=VDD VSS=VSS
Xcopt_h_inst_4207 dl01d1 $PINS I=n175 Z=copt_net_1375 VDD=VDD VSS=VSS
Xcopt_h_inst_4208 dl01d1 $PINS I=n297 Z=copt_net_1376 VDD=VDD VSS=VSS
Xcopt_h_inst_4234 dl01d1 $PINS I=n106 Z=copt_net_1402 VDD=VDD VSS=VSS
Xcopt_h_inst_4235 dl01d1 $PINS I=n106 Z=copt_net_1403 VDD=VDD VSS=VSS
Xcopt_h_inst_4239 dl02d1 $PINS I=n211 Z=copt_net_1407 VDD=VDD VSS=VSS
Xcopt_h_inst_4240 dl01d1 $PINS I=n173 Z=copt_net_1408 VDD=VDD VSS=VSS
Xcopt_h_inst_4241 dl01d1 $PINS I=n173 Z=copt_net_1409 VDD=VDD VSS=VSS
Xcopt_h_inst_4261 dl02d1 $PINS I=n295 Z=copt_net_1429 VDD=VDD VSS=VSS
Xcopt_h_inst_4264 dl02d1 $PINS I=n296 Z=copt_net_1432 VDD=VDD VSS=VSS
Xcopt_h_inst_4269 dl01d1 $PINS I=n259 Z=copt_net_1437 VDD=VDD VSS=VSS
Xcopt_h_inst_4272 dl01d1 $PINS I=n283 Z=copt_net_1440 VDD=VDD VSS=VSS
Xcopt_h_inst_4273 dl01d1 $PINS I=n341 Z=copt_net_1441 VDD=VDD VSS=VSS
Xcopt_h_inst_4286 dl01d1 $PINS I=n123 Z=copt_net_1454 VDD=VDD VSS=VSS
Xcopt_h_inst_4287 dl01d1 $PINS I=n123 Z=copt_net_1455 VDD=VDD VSS=VSS
Xcopt_h_inst_4307 dl01d1 $PINS I=n342 Z=copt_net_1475 VDD=VDD VSS=VSS
Xcopt_h_inst_4308 dl01d1 $PINS I=n342 Z=copt_net_1476 VDD=VDD VSS=VSS
Xcopt_h_inst_4315 dl01d1 $PINS I=n121 Z=copt_net_1483 VDD=VDD VSS=VSS
Xcopt_h_inst_4319 dl02d1 $PINS I=load_done_gOb5 Z=copt_net_1487 VDD=VDD VSS=VSS
Xcopt_h_inst_4328 dl01d1 $PINS I=n242 Z=copt_net_1496 VDD=VDD VSS=VSS
Xcopt_h_inst_4338 dl02d1 $PINS I=n177 Z=copt_net_1506 VDD=VDD VSS=VSS
Xcopt_h_inst_4340 dl02d1 $PINS I=n144 Z=copt_net_1508 VDD=VDD VSS=VSS
Xcopt_h_inst_4347 dl01d1 $PINS I=n244 Z=copt_net_1515 VDD=VDD VSS=VSS
Xcopt_h_inst_4371 dl01d1 $PINS I=n161 Z=copt_net_1539 VDD=VDD VSS=VSS
Xcopt_h_inst_4372 dl01d1 $PINS I=n267 Z=copt_net_1540 VDD=VDD VSS=VSS
Xcopt_h_inst_4381 dl02d1 $PINS I=n114 Z=copt_net_1549 VDD=VDD VSS=VSS
Xcopt_h_inst_4385 dl02d1 $PINS I=n208 Z=copt_net_1553 VDD=VDD VSS=VSS
Xcopt_h_inst_4396 dl02d1 $PINS I=n216 Z=copt_net_1564 VDD=VDD VSS=VSS
Xcopt_h_inst_4407 dl02d1 $PINS I=n307 Z=copt_net_1575 VDD=VDD VSS=VSS
Xcopt_h_inst_4412 dl01d1 $PINS I=n202 Z=copt_net_1580 VDD=VDD VSS=VSS
Xcopt_h_inst_4414 dl01d1 $PINS I=n102 Z=copt_net_1582 VDD=VDD VSS=VSS
Xcopt_h_inst_4433 dl01d1 $PINS I=n215 Z=copt_net_1601 VDD=VDD VSS=VSS
Xcopt_h_inst_4434 dl01d1 $PINS I=n215 Z=copt_net_1602 VDD=VDD VSS=VSS
Xcopt_h_inst_4466 dl01d1 $PINS I=n197 Z=copt_net_1634 VDD=VDD VSS=VSS
Xcopt_h_inst_4467 dl01d1 $PINS I=n197 Z=copt_net_1635 VDD=VDD VSS=VSS
Xcopt_h_inst_4470 dl01d1 $PINS I=n234 Z=copt_net_1638 VDD=VDD VSS=VSS
Xcopt_h_inst_4473 dl02d1 $PINS I=n250 Z=copt_net_1641 VDD=VDD VSS=VSS
Xcopt_h_inst_4474 dl01d1 $PINS I=n250 Z=copt_net_1642 VDD=VDD VSS=VSS
Xcopt_h_inst_4483 dl01d1 $PINS I=n103 Z=copt_net_1651 VDD=VDD VSS=VSS
Xcopt_h_inst_4490 dl01d1 $PINS I=n243 Z=copt_net_1658 VDD=VDD VSS=VSS
Xcopt_h_inst_4497 dl02d1 $PINS I=n148 Z=copt_net_1665 VDD=VDD VSS=VSS
Xcopt_h_inst_4507 dl01d1 $PINS I=n279 Z=copt_net_1675 VDD=VDD VSS=VSS
Xcopt_h_inst_4509 dl02d1 $PINS I=n645 Z=copt_net_1677 VDD=VDD VSS=VSS
Xcopt_h_inst_4514 dl02d1 $PINS I=n218 Z=copt_net_1682 VDD=VDD VSS=VSS
Xcopt_h_inst_4530 dl01d1 $PINS I=n164 Z=copt_net_1698 VDD=VDD VSS=VSS
Xcopt_h_inst_4555 dl01d1 $PINS I=n359 Z=copt_net_1723 VDD=VDD VSS=VSS
Xcopt_h_inst_4556 dl01d1 $PINS I=n359 Z=copt_net_1724 VDD=VDD VSS=VSS
Xcopt_h_inst_4603 dl01d1 $PINS I=n96 Z=copt_net_1771 VDD=VDD VSS=VSS
Xcopt_h_inst_4621 dl01d1 $PINS I=n224 Z=copt_net_1789 VDD=VDD VSS=VSS
Xcopt_h_inst_4640 dl02d1 $PINS I=k_lat[1] Z=copt_net_1808 VDD=VDD VSS=VSS
Xcopt_h_inst_4653 dl02d1 $PINS I=n205 Z=copt_net_1821 VDD=VDD VSS=VSS
Xcopt_h_inst_4666 dl02d1 $PINS I=n_lat[1] Z=copt_net_1834 VDD=VDD VSS=VSS
Xcopt_h_inst_4667 dl01d1 $PINS I=n152 Z=copt_net_1835 VDD=VDD VSS=VSS
Xcopt_h_inst_4668 dl02d1 $PINS I=n152 Z=copt_net_1836 VDD=VDD VSS=VSS
Xcopt_h_inst_4681 dl02d1 $PINS I=n_lat[0] Z=copt_net_1849 VDD=VDD VSS=VSS
Xcopt_h_inst_4683 dl02d1 $PINS I=n138 Z=copt_net_1851 VDD=VDD VSS=VSS
Xcopt_h_inst_4692 dl02d1 $PINS I=n320 Z=copt_net_1860 VDD=VDD VSS=VSS
Xcopt_h_inst_4693 buffd1 $PINS I=n320 Z=copt_net_1861 VDD=VDD VSS=VSS
Xcopt_h_inst_4696 dl02d1 $PINS I=n116 Z=copt_net_1864 VDD=VDD VSS=VSS
Xcopt_h_inst_4697 dl01d1 $PINS I=n639 Z=copt_net_1865 VDD=VDD VSS=VSS
Xcopt_h_inst_4703 dl01d1 $PINS I=n212 Z=copt_net_1871 VDD=VDD VSS=VSS
Xcopt_h_inst_4704 dl02d1 $PINS I=n199 Z=copt_net_1872 VDD=VDD VSS=VSS
Xcopt_h_inst_4714 dl02d1 $PINS I=n246 Z=copt_net_1882 VDD=VDD VSS=VSS
Xcopt_h_inst_4721 dl01d1 $PINS I=n185 Z=copt_net_1889 VDD=VDD VSS=VSS
Xcopt_h_inst_4730 dl02d1 $PINS I=n113 Z=copt_net_1898 VDD=VDD VSS=VSS
Xcopt_h_inst_4734 dl01d1 $PINS I=n125 Z=copt_net_1902 VDD=VDD VSS=VSS
Xcopt_h_inst_4743 dl01d1 $PINS I=n124 Z=copt_net_1911 VDD=VDD VSS=VSS
Xcopt_h_inst_4749 dl01d1 $PINS I=n182 Z=copt_net_1917 VDD=VDD VSS=VSS
Xcopt_h_inst_4756 dl01d1 $PINS I=n104 Z=copt_net_1924 VDD=VDD VSS=VSS
Xcopt_h_inst_4768 dl02d1 $PINS I=n254 Z=copt_net_1936 VDD=VDD VSS=VSS
Xcopt_h_inst_4770 dl02d1 $PINS I=n626 Z=copt_net_1938 VDD=VDD VSS=VSS
Xcopt_h_inst_4771 dl02d1 $PINS I=n324 Z=copt_net_1939 VDD=VDD VSS=VSS
Xcopt_h_inst_4773 dl01d1 $PINS I=n146 Z=copt_net_1941 VDD=VDD VSS=VSS
Xcopt_h_inst_4779 dl02d1 $PINS I=n140 Z=copt_net_1947 VDD=VDD VSS=VSS
Xcopt_h_inst_4809 dl02d1 $PINS I=n162 Z=copt_net_1976 VDD=VDD VSS=VSS
Xcopt_h_inst_4810 dl01d1 $PINS I=n162 Z=copt_net_1977 VDD=VDD VSS=VSS
Xcopt_h_inst_4812 dl01d1 $PINS I=n150 Z=copt_net_1979 VDD=VDD VSS=VSS
Xcopt_h_inst_4815 dl02d1 $PINS I=n214 Z=copt_net_1982 VDD=VDD VSS=VSS
Xcopt_h_inst_4818 dl02d1 $PINS I=n319 Z=copt_net_1985 VDD=VDD VSS=VSS
Xcopt_h_inst_4825 dl02d1 $PINS I=n223 Z=copt_net_1992 VDD=VDD VSS=VSS
Xcopt_h_inst_4827 dl01d1 $PINS I=n192 Z=copt_net_1994 VDD=VDD VSS=VSS
Xcopt_h_inst_4838 dl01d1 $PINS I=k_lat[0] Z=copt_net_2005 VDD=VDD VSS=VSS
Xcopt_h_inst_4840 dl02d1 $PINS I=n285 Z=copt_net_2007 VDD=VDD VSS=VSS
Xcopt_h_inst_4844 dl01d1 $PINS I=n189 Z=copt_net_2011 VDD=VDD VSS=VSS
Xcopt_h_inst_4845 dl02d1 $PINS I=n137 Z=copt_net_2012 VDD=VDD VSS=VSS
Xcopt_h_inst_4847 dl02d1 $PINS I=n637 Z=copt_net_2014 VDD=VDD VSS=VSS
Xcopt_h_inst_4854 dl02d1 $PINS I=n190 Z=copt_net_2021 VDD=VDD VSS=VSS
Xcopt_h_inst_4857 dl01d1 $PINS I=n174 Z=copt_net_2024 VDD=VDD VSS=VSS
Xcopt_h_inst_4863 dl02d1 $PINS I=n154 Z=copt_net_2030 VDD=VDD VSS=VSS
Xcopt_h_inst_4867 dl01d1 $PINS I=n638 Z=copt_net_2034 VDD=VDD VSS=VSS
Xcopt_h_inst_4868 dl02d1 $PINS I=n180 Z=copt_net_2035 VDD=VDD VSS=VSS
Xcopt_h_inst_4898 dl01d1 $PINS I=n282 Z=copt_net_2065 VDD=VDD VSS=VSS
Xcopt_h_inst_4899 dl02d1 $PINS I=n134 Z=copt_net_2066 VDD=VDD VSS=VSS
Xcopt_h_inst_4900 dl01d1 $PINS I=n166 Z=copt_net_2067 VDD=VDD VSS=VSS
Xcopt_h_inst_4904 dl01d1 $PINS I=n642 Z=copt_net_2071 VDD=VDD VSS=VSS
Xcopt_h_inst_4907 dl01d1 $PINS I=n635 Z=copt_net_2074 VDD=VDD VSS=VSS
Xcopt_h_inst_4908 dl02d1 $PINS I=n644 Z=copt_net_2075 VDD=VDD VSS=VSS
Xcopt_h_inst_4912 dl02d1 $PINS I=n112 Z=copt_net_2079 VDD=VDD VSS=VSS
Xcopt_h_inst_4913 dl02d1 $PINS I=n101 Z=copt_net_2080 VDD=VDD VSS=VSS
Xcopt_h_inst_4925 dl01d1 $PINS I=n278 Z=copt_net_2092 VDD=VDD VSS=VSS
Xcopt_h_inst_4926 dl01d1 $PINS I=n186 Z=copt_net_2093 VDD=VDD VSS=VSS
Xcopt_h_inst_4933 dl02d1 $PINS I=n213 Z=copt_net_2100 VDD=VDD VSS=VSS
Xcopt_h_inst_4945 dl02d1 $PINS I=n122 Z=copt_net_2112 VDD=VDD VSS=VSS
Xcopt_h_inst_4949 dl02d1 $PINS I=n170 Z=copt_net_2116 VDD=VDD VSS=VSS
Xcopt_h_inst_4950 dl01d1 $PINS I=n130 Z=copt_net_2117 VDD=VDD VSS=VSS
Xcopt_h_inst_4957 dl01d1 $PINS I=n227 Z=copt_net_2124 VDD=VDD VSS=VSS
Xcopt_h_inst_4958 dl01d1 $PINS I=n120 Z=copt_net_2125 VDD=VDD VSS=VSS
Xcopt_h_inst_4979 dl02d1 $PINS I=n266 Z=copt_net_2146 VDD=VDD VSS=VSS
Xcopt_h_inst_4982 dl02d1 $PINS I=n153 Z=copt_net_2149 VDD=VDD VSS=VSS
Xcopt_h_inst_4983 dl01d1 $PINS I=n153 Z=copt_net_2150 VDD=VDD VSS=VSS
Xcopt_h_inst_4987 dl02d1 $PINS I=n273 Z=copt_net_2154 VDD=VDD VSS=VSS
Xcopt_h_inst_4988 dl02d1 $PINS I=n156 Z=copt_net_2155 VDD=VDD VSS=VSS
Xcopt_h_inst_4996 dl01d1 $PINS I=n249 Z=copt_net_2163 VDD=VDD VSS=VSS
Xcopt_h_inst_4997 dl01d1 $PINS I=n142 Z=copt_net_2164 VDD=VDD VSS=VSS
Xcopt_h_inst_4999 dl01d1 $PINS I=n258 Z=copt_net_2166 VDD=VDD VSS=VSS
Xcopt_h_inst_5002 dl01d1 $PINS I=n158 Z=copt_net_2169 VDD=VDD VSS=VSS
Xcopt_h_inst_5024 dl01d1 $PINS I=n191 Z=copt_net_2191 VDD=VDD VSS=VSS
Xcopt_h_inst_5026 dl01d1 $PINS I=n169 Z=copt_net_2193 VDD=VDD VSS=VSS
Xcopt_h_inst_5041 dl02d1 $PINS I=n220 Z=copt_net_2208 VDD=VDD VSS=VSS
Xcopt_h_inst_5042 dl01d1 $PINS I=n231 Z=copt_net_2209 VDD=VDD VSS=VSS
Xcopt_h_inst_5049 dl01d1 $PINS I=n636 Z=copt_net_2216 VDD=VDD VSS=VSS
Xcopt_h_inst_5057 dl01d1 $PINS I=n141 Z=copt_net_2224 VDD=VDD VSS=VSS
Xcopt_h_inst_5064 dl01d1 $PINS I=n281 Z=copt_net_2231 VDD=VDD VSS=VSS
Xcopt_h_inst_5070 dl02d1 $PINS I=n221 Z=copt_net_2237 VDD=VDD VSS=VSS
Xcopt_h_inst_5116 dl01d1 $PINS I=bank_a[86] Z=copt_net_2283 VDD=VDD VSS=VSS
Xcopt_h_inst_5143 dl02d1 $PINS I=n99 Z=copt_net_2310 VDD=VDD VSS=VSS
Xcopt_h_inst_5153 dl01d1 $PINS I=bank_b[19] Z=copt_net_2320 VDD=VDD VSS=VSS
Xcopt_h_inst_5167 dl01d1 $PINS I=n640 Z=copt_net_2334 VDD=VDD VSS=VSS
Xcopt_h_inst_5172 dl01d1 $PINS I=n181 Z=copt_net_2339 VDD=VDD VSS=VSS
Xcopt_h_inst_5179 dl01d1 $PINS I=n149 Z=copt_net_2346 VDD=VDD VSS=VSS
Xcopt_h_inst_5180 dl01d1 $PINS I=n145 Z=copt_net_2347 VDD=VDD VSS=VSS
Xcopt_h_inst_5183 dl01d1 $PINS I=n136 Z=copt_net_2350 VDD=VDD VSS=VSS
Xcopt_h_inst_5186 dl01d1 $PINS I=n184 Z=copt_net_2353 VDD=VDD VSS=VSS
Xcopt_h_inst_5188 dl01d1 $PINS I=n617 Z=copt_net_2355 VDD=VDD VSS=VSS
Xcopt_h_inst_5189 dl01d1 $PINS I=n617 Z=copt_net_2356 VDD=VDD VSS=VSS
Xcopt_h_inst_5210 dl01d1 $PINS I=bank_b[49] Z=copt_net_2377 VDD=VDD VSS=VSS
Xcopt_h_inst_5219 dl01d1 $PINS I=bank_a[76] Z=copt_net_2386 VDD=VDD VSS=VSS
Xcopt_h_inst_5237 dl01d1 $PINS I=n119 Z=copt_net_2404 VDD=VDD VSS=VSS
Xcopt_h_inst_5257 dl01d1 $PINS I=n304 Z=copt_net_2424 VDD=VDD VSS=VSS
Xcopt_h_inst_5263 dl01d1 $PINS I=bank_a[91] Z=copt_net_2430 VDD=VDD VSS=VSS
Xcopt_h_inst_5265 dl01d1 $PINS I=bank_b[39] Z=copt_net_2432 VDD=VDD VSS=VSS
Xcopt_h_inst_5277 dl01d1 $PINS I=n210 Z=copt_net_2444 VDD=VDD VSS=VSS
Xcopt_h_inst_5280 dl02d1 $PINS I=n300 Z=copt_net_2447 VDD=VDD VSS=VSS
Xcopt_h_inst_5281 dl02d1 $PINS I=n265 Z=copt_net_2448 VDD=VDD VSS=VSS
Xcopt_h_inst_5284 dl01d1 $PINS I=bank_b[114] Z=copt_net_2451 VDD=VDD VSS=VSS
Xcopt_h_inst_5286 dl02d1 $PINS I=bank_a[17] Z=copt_net_2453 VDD=VDD VSS=VSS
Xcopt_h_inst_5295 dl01d1 $PINS I=bank_a[22] Z=copt_net_2462 VDD=VDD VSS=VSS
Xcopt_h_inst_5296 dl01d1 $PINS I=n286 Z=copt_net_2463 VDD=VDD VSS=VSS
Xcopt_h_inst_5300 dl02d1 $PINS I=n272 Z=copt_net_2467 VDD=VDD VSS=VSS
Xcopt_h_inst_5312 dl01d1 $PINS I=n206 Z=copt_net_2479 VDD=VDD VSS=VSS
Xcopt_h_inst_5315 dl01d1 $PINS I=n294 Z=copt_net_2482 VDD=VDD VSS=VSS
Xcopt_h_inst_5323 dl01d1 $PINS I=bank_a[79] Z=copt_net_2490 VDD=VDD VSS=VSS
Xcopt_h_inst_5325 dl01d1 $PINS I=bank_a[44] Z=copt_net_2492 VDD=VDD VSS=VSS
Xcopt_h_inst_5332 dl01d1 $PINS I=bank_a[35] Z=copt_net_2499 VDD=VDD VSS=VSS
Xcopt_h_inst_5333 dl01d1 $PINS I=bank_b[16] Z=copt_net_2500 VDD=VDD VSS=VSS
Xcopt_h_inst_5334 dl01d1 $PINS I=bank_b[105] Z=copt_net_2501 VDD=VDD VSS=VSS
Xcopt_h_inst_5335 dl02d1 $PINS I=n239 Z=copt_net_2502 VDD=VDD VSS=VSS
Xcopt_h_inst_5337 dl01d1 $PINS I=n252 Z=copt_net_2504 VDD=VDD VSS=VSS
Xcopt_h_inst_5339 dl01d1 $PINS I=n196 Z=copt_net_2506 VDD=VDD VSS=VSS
Xcopt_h_inst_5343 dl01d1 $PINS I=n284 Z=copt_net_2510 VDD=VDD VSS=VSS
Xcopt_h_inst_5355 dl01d1 $PINS I=bank_a[49] Z=copt_net_2522 VDD=VDD VSS=VSS
Xcopt_h_inst_5363 dl01d1 $PINS I=bank_b[79] Z=copt_net_2530 VDD=VDD VSS=VSS
Xcopt_h_inst_5365 dl01d1 $PINS I=bank_b[10] Z=copt_net_2532 VDD=VDD VSS=VSS
Xcopt_h_inst_5367 dl01d1 $PINS I=bank_b[54] Z=copt_net_2534 VDD=VDD VSS=VSS
Xcopt_h_inst_5368 dl01d1 $PINS I=n241 Z=copt_net_2535 VDD=VDD VSS=VSS
Xcopt_h_inst_5369 dl02d1 $PINS I=n292 Z=copt_net_2536 VDD=VDD VSS=VSS
Xcopt_h_inst_5376 dl01d1 $PINS I=bank_a[99] Z=copt_net_2543 VDD=VDD VSS=VSS
Xcopt_h_inst_5377 dl02d1 $PINS I=n323 Z=copt_net_2544 VDD=VDD VSS=VSS
Xcopt_h_inst_5379 dl01d1 $PINS I=n198 Z=copt_net_2546 VDD=VDD VSS=VSS
Xcopt_h_inst_5381 dl01d1 $PINS I=n230 Z=copt_net_2548 VDD=VDD VSS=VSS
Xcopt_h_inst_5383 dl01d1 $PINS I=n201 Z=copt_net_2550 VDD=VDD VSS=VSS
Xcopt_h_inst_5384 dl01d1 $PINS I=n274 Z=copt_net_2551 VDD=VDD VSS=VSS
Xcopt_h_inst_5388 dl02d1 $PINS I=n313 Z=copt_net_2555 VDD=VDD VSS=VSS
Xcopt_h_inst_5394 dl01d1 $PINS I=n105 Z=copt_net_2561 VDD=VDD VSS=VSS
Xcopt_h_inst_5395 dl01d1 $PINS I=n322 Z=copt_net_2562 VDD=VDD VSS=VSS
Xcopt_h_inst_5406 dl01d1 $PINS I=n268 Z=copt_net_2573 VDD=VDD VSS=VSS
Xcopt_h_inst_5414 dl02d1 $PINS I=n118 Z=copt_net_2581 VDD=VDD VSS=VSS
Xcopt_h_inst_5426 dl01d1 $PINS I=n238 Z=copt_net_2593 VDD=VDD VSS=VSS
Xcopt_h_inst_5445 dl01d1 $PINS I=bank_b[29] Z=copt_net_2612 VDD=VDD VSS=VSS
Xcopt_h_inst_5452 dl01d1 $PINS I=n132 Z=copt_net_2619 VDD=VDD VSS=VSS
Xcopt_h_inst_5453 dl01d1 $PINS I=n193 Z=copt_net_2620 VDD=VDD VSS=VSS
Xcopt_h_inst_5457 dl01d1 $PINS I=bank_a[45] Z=copt_net_2624 VDD=VDD VSS=VSS
Xcopt_h_inst_5461 dl01d1 $PINS I=bank_b[35] Z=copt_net_2628 VDD=VDD VSS=VSS
Xcopt_h_inst_5463 dl02d1 $PINS I=n633 Z=copt_net_2630 VDD=VDD VSS=VSS
Xcopt_h_inst_5464 dl01d1 $PINS I=n309 Z=copt_net_2631 VDD=VDD VSS=VSS
Xcopt_h_inst_5465 dl01d1 $PINS I=n129 Z=copt_net_2632 VDD=VDD VSS=VSS
Xcopt_h_inst_5471 dl01d1 $PINS I=bank_b[23] Z=copt_net_2638 VDD=VDD VSS=VSS
Xcopt_h_inst_5482 dl01d1 $PINS I=bank_b[77] Z=copt_net_2649 VDD=VDD VSS=VSS
Xcopt_h_inst_5484 dl01d1 $PINS I=active_load Z=copt_net_2651 VDD=VDD VSS=VSS
Xcopt_h_inst_5493 dl01d1 $PINS I=bank_b[53] Z=copt_net_2660 VDD=VDD VSS=VSS
Xcopt_h_inst_5497 dl02d1 $PINS I=n301 Z=copt_net_2664 VDD=VDD VSS=VSS
Xcopt_h_inst_5507 dl01d1 $PINS I=n646 Z=copt_net_2674 VDD=VDD VSS=VSS
Xcopt_h_inst_5514 dl01d1 $PINS I=n291 Z=copt_net_2681 VDD=VDD VSS=VSS
Xcopt_h_inst_5517 dl02d1 $PINS I=n261 Z=copt_net_2684 VDD=VDD VSS=VSS
Xcopt_h_inst_5519 buffd1 $PINS I=bank_b[66] Z=copt_net_2686 VDD=VDD VSS=VSS
Xcopt_h_inst_5525 dl02d1 $PINS I=n256 Z=copt_net_2692 VDD=VDD VSS=VSS
Xcopt_h_inst_5532 dl01d1 $PINS I=bank_b[5] Z=copt_net_2699 VDD=VDD VSS=VSS
Xcopt_h_inst_5537 buffd1 $PINS I=bank_a[81] Z=copt_net_2704 VDD=VDD VSS=VSS
Xcopt_h_inst_5539 dl01d1 $PINS I=bank_a[112] Z=copt_net_2706 VDD=VDD VSS=VSS
Xcopt_h_inst_5541 buffd1 $PINS I=bank_b[97] Z=copt_net_2708 VDD=VDD VSS=VSS
Xcopt_h_inst_5542 dl01d1 $PINS I=n269 Z=copt_net_2709 VDD=VDD VSS=VSS
Xcopt_h_inst_5547 buffd1 $PINS I=bank_b[113] Z=copt_net_2714 VDD=VDD VSS=VSS
Xcopt_h_inst_5553 dl01d1 $PINS I=n328 Z=copt_net_2720 VDD=VDD VSS=VSS
Xcopt_h_inst_5554 buffd1 $PINS I=bank_a[36] Z=copt_net_2721 VDD=VDD VSS=VSS
Xcopt_h_inst_5559 buffd1 $PINS I=active_sel Z=copt_net_2726 VDD=VDD VSS=VSS
Xcopt_h_inst_5562 dl01d1 $PINS I=n257 Z=copt_net_2729 VDD=VDD VSS=VSS
Xcopt_h_inst_5592 dl02d1 $PINS I=n237 Z=copt_net_2759 VDD=VDD VSS=VSS
Xcopt_h_inst_5600 dl01d1 $PINS I=n648 Z=copt_net_2767 VDD=VDD VSS=VSS
Xcopt_h_inst_5604 dl01d1 $PINS I=bank_b[106] Z=copt_net_2771 VDD=VDD VSS=VSS
Xcopt_h_inst_5605 dl01d1 $PINS I=n240 Z=copt_net_2772 VDD=VDD VSS=VSS
Xcopt_h_inst_5683 dl02d1 $PINS I=load_row[11] Z=copt_net_2849 VDD=VDD VSS=VSS
.ENDS

.SUBCKT unpu_dma_DW01_add_4 A[31] A[30] A[29] A[28] A[27] A[26] A[25] A[24]
+ A[23] A[22] A[21] A[20] A[19] A[18] A[17] A[16] A[15] A[14] A[13] A[12] A[11]
+ A[10] A[9] A[8] A[7] A[6] A[5] A[4] A[3] A[2] A[1] A[0] B[31] B[30] B[29]
+ B[28] B[27] B[26] B[25] B[24] B[23] B[22] B[21] B[20] B[19] B[18] B[17] B[16]
+ B[15] B[14] B[13] B[12] B[11] B[10] B[9] B[8] B[7] B[6] B[5] B[4] B[3] B[2]
+ B[1] B[0] CI SUM[31] SUM[30] SUM[29] SUM[28] SUM[27] SUM[26] SUM[25] SUM[24]
+ SUM[23] SUM[22] SUM[21] SUM[20] SUM[19] SUM[18] SUM[17] SUM[16] SUM[15]
+ SUM[14] SUM[13] SUM[12] SUM[11] SUM[10] SUM[9] SUM[8] SUM[7] SUM[6] SUM[5]
+ SUM[4] SUM[3] SUM[2] SUM[1] SUM[0] CO VDD VSS
*.CONNECT SUM[1] A[1]
*.CONNECT SUM[0] A[0]
XctmTdsLR_1_1263 nd12d1 $PINS A1=n45 A2=n40 ZN=n39 VDD=VDD VSS=VSS
XU19 nd02d1 $PINS A1=n27 A2=A[18] ZN=n23 VDD=VDD VSS=VSS
XU24 nr02d1 $PINS A1=n28 A2=n30 ZN=n27 VDD=VDD VSS=VSS
XU27 nr02d1 $PINS A1=n30 A2=n32 ZN=n29 VDD=VDD VSS=VSS
XU37 nr02d1 $PINS A1=n38 A2=n39 ZN=n37 VDD=VDD VSS=VSS
XctmTdsLR_1_1285 oaim22d1 $PINS A1=n29 A2=n28 B1=n29 B2=n28 ZN=SUM[17] VDD=VDD
+ VSS=VSS
XU41 nr02d1 $PINS A1=n41 A2=n43 ZN=n40 VDD=VDD VSS=VSS
XU44 nr02d1 $PINS A1=n43 A2=n45 ZN=n42 VDD=VDD VSS=VSS
XU49 nr02d1 $PINS A1=n48 A2=n62 ZN=n46 VDD=VDD VSS=VSS
XU50 nr02d1 $PINS A1=n48 A2=n63 ZN=n47 VDD=VDD VSS=VSS
XU55 nr02d1 $PINS A1=n52 A2=n53 ZN=n51 VDD=VDD VSS=VSS
XU59 nr02d1 $PINS A1=n55 A2=n57 ZN=n54 VDD=VDD VSS=VSS
XU62 nr02d1 $PINS A1=n57 A2=n59 ZN=n56 VDD=VDD VSS=VSS
XU69 nd02d1 $PINS A1=n85 A2=n63 ZN=n1 VDD=VDD VSS=VSS
XU71 nr02d1 $PINS A1=A[7] A2=B[7] ZN=n62 VDD=VDD VSS=VSS
XU72 nd02d1 $PINS A1=B[7] A2=A[7] ZN=n63 VDD=VDD VSS=VSS
XU86 nr02d1 $PINS A1=A[5] A2=B[5] ZN=n71 VDD=VDD VSS=VSS
XU87 nd02d1 $PINS A1=B[5] A2=A[5] ZN=n72 VDD=VDD VSS=VSS
XctmTdsLR_1_1396 aoim22d1 $PINS A1=n3 A2=gre_a_INV_185_3 B1=n3
+ B2=gre_a_INV_185_3 Z=SUM[5] VDD=VDD VSS=VSS
XU93 nr02d1 $PINS A1=A[4] A2=B[4] ZN=n75 VDD=VDD VSS=VSS
XU94 nd02d1 $PINS A1=B[4] A2=A[4] ZN=n76 VDD=VDD VSS=VSS
XU99 nd02d1 $PINS A1=n196 A2=n81 ZN=n5 VDD=VDD VSS=VSS
XU102 nd02d1 $PINS A1=B[3] A2=A[3] ZN=n81 VDD=VDD VSS=VSS
XU108 nd02d1 $PINS A1=B[2] A2=A[2] ZN=n84 VDD=VDD VSS=VSS
XU112 nd03d1 $PINS A1=A[11] A2=A[10] A3=n54 ZN=n48 VDD=VDD VSS=VSS
XU113 aoim31d1 $PINS B1=n68 B2=gre_a_INV_185_3 B3=n71 A=n67 ZN=n65 VDD=VDD
+ VSS=VSS
XU115 or02d0 $PINS A1=n45 A2=n34 Z=n32 VDD=VDD VSS=VSS
XU116 nd12d1 $PINS A1=n59 A2=n54 ZN=n53 VDD=VDD VSS=VSS
Xgre_a_INV_185_inst_5818 inv0d1 $PINS I=n74 ZN=gre_a_INV_185_3 VDD=VDD VSS=VSS
XU118 nd03d1 $PINS A1=A[15] A2=A[14] A3=n40 ZN=n34 VDD=VDD VSS=VSS
XU119 xr02d1 $PINS A1=n59 A2=n57 Z=SUM[8] VDD=VDD VSS=VSS
XctmTdsLR_1_1264 oaim22d1 $PINS A1=n56 A2=n55 B1=n56 B2=n55 ZN=SUM[9] VDD=VDD
+ VSS=VSS
XctmTdsLR_1_1265 oaim22d1 $PINS A1=n42 A2=n41 B1=n42 B2=n41 ZN=SUM[13] VDD=VDD
+ VSS=VSS
XctmTdsLR_1_1271 aoim22d1 $PINS A1=n8 A2=A[30] B1=n8 B2=A[30] Z=SUM[30] VDD=VDD
+ VSS=VSS
XctmTdsLR_1_1381 aoim22d1 $PINS A1=n4 A2=n77 B1=n4 B2=n77 Z=SUM[4] VDD=VDD
+ VSS=VSS
XU124 xr02d1 $PINS A1=n45 A2=n43 Z=SUM[12] VDD=VDD VSS=VSS
XU125 xr02d1 $PINS A1=n32 A2=n30 Z=SUM[16] VDD=VDD VSS=VSS
XU126 ah01d1 $PINS A=n19 B=A[19] CO=n18 S=SUM[19] VDD=VDD VSS=VSS
XU127 ah01d1 $PINS A=n18 B=A[20] CO=n17 S=SUM[20] VDD=VDD VSS=VSS
XU128 ah01d1 $PINS A=n17 B=A[21] CO=n16 S=SUM[21] VDD=VDD VSS=VSS
XU129 ah01d1 $PINS A=n16 B=A[22] CO=n15 S=SUM[22] VDD=VDD VSS=VSS
XU130 ah01d1 $PINS A=n15 B=A[23] CO=n14 S=SUM[23] VDD=VDD VSS=VSS
XU131 ah01d1 $PINS A=n14 B=A[24] CO=n13 S=SUM[24] VDD=VDD VSS=VSS
XU132 ah01d1 $PINS A=n13 B=A[25] CO=n12 S=SUM[25] VDD=VDD VSS=VSS
XU133 ah01d1 $PINS A=n12 B=A[26] CO=n11 S=SUM[26] VDD=VDD VSS=VSS
XU134 ah01d1 $PINS A=n11 B=A[27] CO=n10 S=SUM[27] VDD=VDD VSS=VSS
XU135 ah01d1 $PINS A=n10 B=A[28] CO=n9 S=SUM[28] VDD=VDD VSS=VSS
XU136 ah01d1 $PINS A=n9 B=A[29] CO=n8 S=SUM[29] VDD=VDD VSS=VSS
XctmTdsLR_1_1286 aoim22d1 $PINS A1=n51 A2=A[11] B1=n51 B2=A[11] Z=SUM[11]
+ VDD=VDD VSS=VSS
XctmTdsLR_1_1255 inv0d0 $PINS I=n46 ZN=tmp_net104 VDD=VDD VSS=VSS
XctmTdsLR_1_1401 aoim22d1 $PINS A1=n1 A2=n65 B1=n1 B2=n65 Z=SUM[7] VDD=VDD
+ VSS=VSS
XU140 xr02d1 $PINS A1=n53 A2=n52 Z=SUM[10] VDD=VDD VSS=VSS
XU141 xr02d1 $PINS A1=n39 A2=n38 Z=SUM[14] VDD=VDD VSS=VSS
XctmTdsLR_1_1344 ora21d1 $PINS B1=B[2] B2=A[2] A=n84 Z=SUM[2] VDD=VDD VSS=VSS
XctmTdsLR_1_1358 aoim22d1 $PINS A1=n5 A2=n84 B1=n5 B2=n84 Z=SUM[3] VDD=VDD
+ VSS=VSS
XctmTdsLR_1_1402 oaim22d1 $PINS A1=n70 A2=n2 B1=n70 B2=n2 ZN=SUM[6] VDD=VDD
+ VSS=VSS
XctmTdsLR_2_1256 nr02d1 $PINS A1=tmp_net104 A2=n65 ZN=tmp_net105 VDD=VDD
+ VSS=VSS
XU146 nr02d1 $PINS A1=A[6] A2=B[6] ZN=n68 VDD=VDD VSS=VSS
XU147 nd02d0 $PINS A1=B[6] A2=A[6] ZN=n69 VDD=VDD VSS=VSS
XctmTdsLR_1_1308 nd12d1 $PINS A1=n32 A2=n27 ZN=tmp_net118 VDD=VDD VSS=VSS
XU150 aoi21d1 $PINS B1=n64 B2=n46 A=n47 ZN=n45 VDD=VDD VSS=VSS
XU151 inv0d0 $PINS I=n65 ZN=n64 VDD=VDD VSS=VSS
XU153 oai21d1 $PINS B1=n75 B2=n77 A=n76 ZN=n74 VDD=VDD VSS=VSS
XU154 inv0d0 $PINS I=n84 ZN=n82 VDD=VDD VSS=VSS
XU155 aoi21d1 $PINS B1=n196 B2=n82 A=n79 ZN=n77 VDD=VDD VSS=VSS
XU156 inv0d0 $PINS I=n81 ZN=n79 VDD=VDD VSS=VSS
XctmTdsLR_2_1309 oaim22d1 $PINS A1=A[18] A2=tmp_net118 B1=A[18] B2=tmp_net118
+ ZN=SUM[18] VDD=VDD VSS=VSS
XctmTdsLR_1_1310 aoim22d1 $PINS A1=n37 A2=A[15] B1=n37 B2=A[15] Z=SUM[15]
+ VDD=VDD VSS=VSS
XU160 aoi21d1 $PINS B1=n64 B2=n85 A=n61 ZN=n59 VDD=VDD VSS=VSS
XU161 inv0d0 $PINS I=n63 ZN=n61 VDD=VDD VSS=VSS
XU164 inv0d0 $PINS I=n62 ZN=n85 VDD=VDD VSS=VSS
XU166 oai21d1 $PINS B1=gre_a_INV_185_3 B2=n71 A=n72 ZN=n70 VDD=VDD VSS=VSS
XU167 nd12d1 $PINS A1=n68 A2=n69 ZN=n2 VDD=VDD VSS=VSS
XU168 nd12d1 $PINS A1=n71 A2=n72 ZN=n3 VDD=VDD VSS=VSS
XU169 nd12d1 $PINS A1=n75 A2=n76 ZN=n4 VDD=VDD VSS=VSS
XU170 or02d0 $PINS A1=A[3] A2=B[3] Z=n196 VDD=VDD VSS=VSS
XU171 inv0d0 $PINS I=A[12] ZN=n43 VDD=VDD VSS=VSS
XU172 inv0d0 $PINS I=A[13] ZN=n41 VDD=VDD VSS=VSS
XU173 inv0d0 $PINS I=A[14] ZN=n38 VDD=VDD VSS=VSS
XU174 inv0d0 $PINS I=A[8] ZN=n57 VDD=VDD VSS=VSS
XU175 inv0d0 $PINS I=A[9] ZN=n55 VDD=VDD VSS=VSS
XU177 inv0d0 $PINS I=A[10] ZN=n52 VDD=VDD VSS=VSS
XU179 inv0d0 $PINS I=A[16] ZN=n30 VDD=VDD VSS=VSS
XU180 inv0d0 $PINS I=A[17] ZN=n28 VDD=VDD VSS=VSS
XU183 oai21d1 $PINS B1=n68 B2=n72 A=n69 ZN=n67 VDD=VDD VSS=VSS
XctmTdsLR_3_1257 aoim211d1 $PINS C1=tmp_net105 C2=n47 A=n34 B=n23 ZN=n19
+ VDD=VDD VSS=VSS
XctmTdsLR_2_1272 nd02d1 $PINS A1=n8 A2=A[30] ZN=tmp_net109 VDD=VDD VSS=VSS
XctmTdsLR_3_1273 oaim22d1 $PINS A1=A[31] A2=tmp_net109 B1=A[31] B2=tmp_net109
+ ZN=SUM[31] VDD=VDD VSS=VSS
.ENDS

.SUBCKT unpu_dma_DW01_add_3 A[31] A[30] A[29] A[28] A[27] A[26] A[25] A[24]
+ A[23] A[22] A[21] A[20] A[19] A[18] A[17] A[16] A[15] A[14] A[13] A[12] A[11]
+ A[10] A[9] A[8] A[7] A[6] A[5] A[4] A[3] A[2] A[1] A[0] B[31] B[30] B[29]
+ B[28] B[27] B[26] B[25] B[24] B[23] B[22] B[21] B[20] B[19] B[18] B[17] B[16]
+ B[15] B[14] B[13] B[12] B[11] B[10] B[9] B[8] B[7] B[6] B[5] B[4] B[3] B[2]
+ B[1] B[0] CI SUM[31] SUM[30] SUM[29] SUM[28] SUM[27] SUM[26] SUM[25] SUM[24]
+ SUM[23] SUM[22] SUM[21] SUM[20] SUM[19] SUM[18] SUM[17] SUM[16] SUM[15]
+ SUM[14] SUM[13] SUM[12] SUM[11] SUM[10] SUM[9] SUM[8] SUM[7] SUM[6] SUM[5]
+ SUM[4] SUM[3] SUM[2] SUM[1] SUM[0] CO VDD VSS
*.CONNECT SUM[1] A[1]
*.CONNECT SUM[0] A[0]
XctmTdsLR_1_1356 aoim22d1 $PINS A1=n4 A2=n89 B1=n4 B2=n89 Z=SUM[3] VDD=VDD
+ VSS=VSS
XU3 ah01d1 $PINS A=n8 B=A[29] CO=n7 S=SUM[29] VDD=VDD VSS=VSS
XU4 ah01d1 $PINS A=n9 B=A[28] CO=n8 S=SUM[28] VDD=VDD VSS=VSS
XU5 ah01d1 $PINS A=n10 B=A[27] CO=n9 S=SUM[27] VDD=VDD VSS=VSS
XU6 ah01d1 $PINS A=n11 B=A[26] CO=n10 S=SUM[26] VDD=VDD VSS=VSS
XU7 ah01d1 $PINS A=n12 B=A[25] CO=n11 S=SUM[25] VDD=VDD VSS=VSS
XU8 ah01d1 $PINS A=n13 B=A[24] CO=n12 S=SUM[24] VDD=VDD VSS=VSS
XU9 ah01d1 $PINS A=n14 B=A[23] CO=n13 S=SUM[23] VDD=VDD VSS=VSS
XU10 ah01d1 $PINS A=n15 B=A[22] CO=n14 S=SUM[22] VDD=VDD VSS=VSS
XU11 ah01d1 $PINS A=n16 B=A[21] CO=n15 S=SUM[21] VDD=VDD VSS=VSS
XU12 ah01d1 $PINS A=n17 B=A[20] CO=n16 S=SUM[20] VDD=VDD VSS=VSS
XU13 ah01d1 $PINS A=n18 B=A[19] CO=n17 S=SUM[19] VDD=VDD VSS=VSS
XU14 ah01d1 $PINS A=n204 B=A[18] CO=n18 S=SUM[18] VDD=VDD VSS=VSS
XU21 nr02d1 $PINS A1=n23 A2=n38 ZN=n22 VDD=VDD VSS=VSS
XU22 nd02d1 $PINS A1=n28 A2=A[16] ZN=n23 VDD=VDD VSS=VSS
XU28 nr02d1 $PINS A1=n29 A2=n31 ZN=n28 VDD=VDD VSS=VSS
XU31 nr02d1 $PINS A1=n31 A2=n38 ZN=n30 VDD=VDD VSS=VSS
XU32 nd02d1 $PINS A1=A[13] A2=A[14] ZN=n31 VDD=VDD VSS=VSS
XU35 xr02d1 $PINS A1=n38 A2=n37 Z=SUM[13] VDD=VDD VSS=VSS
XctmTdsLR_1_1399 aoim22d1 $PINS A1=n55 A2=A[10] B1=n55 B2=A[10] Z=SUM[10]
+ VDD=VDD VSS=VSS
XU46 nd02d1 $PINS A1=A[11] A2=A[12] ZN=n43 VDD=VDD VSS=VSS
XU49 xr02d1 $PINS A1=n50 A2=n49 Z=SUM[11] VDD=VDD VSS=VSS
XU50 nr02d1 $PINS A1=n49 A2=n50 ZN=n46 VDD=VDD VSS=VSS
XU57 nd02d1 $PINS A1=A[9] A2=A[10] ZN=n52 VDD=VDD VSS=VSS
XU61 nr02d1 $PINS A1=n58 A2=n60 ZN=n55 VDD=VDD VSS=VSS
XU68 nr02d1 $PINS A1=n73 A2=n63 ZN=n61 VDD=VDD VSS=VSS
XU69 nr02d1 $PINS A1=n74 A2=n63 ZN=n62 VDD=VDD VSS=VSS
XU70 nd02d1 $PINS A1=A[7] A2=A[8] ZN=n63 VDD=VDD VSS=VSS
XU73 xr02d1 $PINS A1=n70 A2=n69 Z=SUM[7] VDD=VDD VSS=VSS
XU74 nr02d1 $PINS A1=n69 A2=n70 ZN=n66 VDD=VDD VSS=VSS
XU82 nd02d1 $PINS A1=n91 A2=n74 ZN=n1 VDD=VDD VSS=VSS
XU84 nr02d1 $PINS A1=A[6] A2=B[6] ZN=n73 VDD=VDD VSS=VSS
XU85 nd02d1 $PINS A1=B[6] A2=A[6] ZN=n74 VDD=VDD VSS=VSS
XU89 nr02d1 $PINS A1=n79 A2=n82 ZN=n77 VDD=VDD VSS=VSS
XU93 nr02d1 $PINS A1=A[5] A2=B[5] ZN=n79 VDD=VDD VSS=VSS
XU94 nd02d1 $PINS A1=B[5] A2=A[5] ZN=n80 VDD=VDD VSS=VSS
XctmTdsLR_1_1379 nd12d1 $PINS A1=n79 A2=n80 ZN=tmp_net127 VDD=VDD VSS=VSS
XU99 nr02d1 $PINS A1=A[4] A2=B[4] ZN=n82 VDD=VDD VSS=VSS
XU100 nd02d1 $PINS A1=B[4] A2=A[4] ZN=n83 VDD=VDD VSS=VSS
XctmTdsLR_1_1373 aoim22d1 $PINS A1=n3 A2=n84 B1=n3 B2=n84 Z=SUM[4] VDD=VDD
+ VSS=VSS
XU106 nr02d1 $PINS A1=A[3] A2=B[3] ZN=n86 VDD=VDD VSS=VSS
XU107 nd02d1 $PINS A1=B[3] A2=A[3] ZN=n87 VDD=VDD VSS=VSS
XctmTdsLR_1_1374 aoim22d1 $PINS A1=n1 A2=n76 B1=n1 B2=n76 Z=SUM[6] VDD=VDD
+ VSS=VSS
XU112 nd02d1 $PINS A1=B[2] A2=A[2] ZN=n89 VDD=VDD VSS=VSS
XctmTdsLR_1_1400 aoim22d1 $PINS A1=n66 A2=A[8] B1=n66 B2=A[8] Z=SUM[8] VDD=VDD
+ VSS=VSS
XU119 nr02d1 $PINS A1=n37 A2=n38 ZN=n34 VDD=VDD VSS=VSS
XU120 inv0d0 $PINS I=n39 ZN=n38 VDD=VDD VSS=VSS
XctmTdsLR_2_1380 oaim22d1 $PINS A1=n81 A2=tmp_net127 B1=n81 B2=tmp_net127
+ ZN=SUM[5] VDD=VDD VSS=VSS
XctmTdsLR_1_1252 oaim22d1 $PINS A1=n22 A2=n21 B1=n22 B2=n21 ZN=SUM[17] VDD=VDD
+ VSS=VSS
XU123 nd12d1 $PINS A1=n86 A2=n87 ZN=n4 VDD=VDD VSS=VSS
XU124 or02d0 $PINS A1=n60 A2=n52 Z=n50 VDD=VDD VSS=VSS
XU125 nr13d1 $PINS A1=n39 A2=n21 A3=n23 ZN=n204 VDD=VDD VSS=VSS
XctmTdsLR_1_1393 inv0d0 $PINS I=n61 ZN=tmp_net130 VDD=VDD VSS=VSS
XctmTdsLR_2_1394 nr02d1 $PINS A1=tmp_net130 A2=n76 ZN=tmp_net131 VDD=VDD
+ VSS=VSS
XU128 nd12d1 $PINS A1=n82 A2=n83 ZN=n3 VDD=VDD VSS=VSS
XctmTdsLR_3_1395 aoim211d1 $PINS C1=tmp_net131 C2=n62 A=n52 B=n43 ZN=n39
+ VDD=VDD VSS=VSS
XU131 xr02d1 $PINS A1=n60 A2=n58 Z=SUM[9] VDD=VDD VSS=VSS
XctmTdsLR_1_1243 nd02d1 $PINS A1=n39 A2=n28 ZN=tmp_net102 VDD=VDD VSS=VSS
XctmTdsLR_2_1244 oaim22d1 $PINS A1=A[16] A2=tmp_net102 B1=A[16] B2=tmp_net102
+ ZN=SUM[16] VDD=VDD VSS=VSS
XctmTdsLR_1_1357 ora21d1 $PINS B1=B[2] B2=A[2] A=n89 Z=SUM[2] VDD=VDD VSS=VSS
XU135 aoi21d1 $PINS B1=n75 B2=n61 A=n62 ZN=n60 VDD=VDD VSS=VSS
XU136 inv0d0 $PINS I=n76 ZN=n75 VDD=VDD VSS=VSS
XU137 inv0d0 $PINS I=n85 ZN=n84 VDD=VDD VSS=VSS
XU138 oai21d1 $PINS B1=n86 B2=n89 A=n87 ZN=n85 VDD=VDD VSS=VSS
XU139 aoi21d1 $PINS B1=n85 B2=n77 A=n78 ZN=n76 VDD=VDD VSS=VSS
XU140 oai21d1 $PINS B1=n79 B2=n83 A=n80 ZN=n78 VDD=VDD VSS=VSS
XU143 aoi21d1 $PINS B1=n75 B2=n91 A=n72 ZN=n70 VDD=VDD VSS=VSS
XU144 inv0d0 $PINS I=n74 ZN=n72 VDD=VDD VSS=VSS
XU146 oai21d1 $PINS B1=n84 B2=n82 A=n83 ZN=n81 VDD=VDD VSS=VSS
XU147 inv0d0 $PINS I=n73 ZN=n91 VDD=VDD VSS=VSS
XU148 inv0d0 $PINS I=A[15] ZN=n29 VDD=VDD VSS=VSS
XU149 inv0d0 $PINS I=A[17] ZN=n21 VDD=VDD VSS=VSS
XctmTdsLR_1_1253 oaim22d1 $PINS A1=n30 A2=n29 B1=n30 B2=n29 ZN=SUM[15] VDD=VDD
+ VSS=VSS
XctmTdsLR_1_1254 aoim22d1 $PINS A1=n34 A2=A[14] B1=n34 B2=A[14] Z=SUM[14]
+ VDD=VDD VSS=VSS
XU155 inv0d0 $PINS I=A[7] ZN=n69 VDD=VDD VSS=VSS
XU156 inv0d0 $PINS I=A[9] ZN=n58 VDD=VDD VSS=VSS
XU157 inv0d0 $PINS I=A[11] ZN=n49 VDD=VDD VSS=VSS
XU158 inv0d0 $PINS I=A[13] ZN=n37 VDD=VDD VSS=VSS
XctmTdsLR_1_1245 aoim22d1 $PINS A1=n46 A2=A[12] B1=n46 B2=A[12] Z=SUM[12]
+ VDD=VDD VSS=VSS
XctmTdsLR_1_1258 aoim22d1 $PINS A1=n7 A2=A[30] B1=n7 B2=A[30] Z=SUM[30] VDD=VDD
+ VSS=VSS
XctmTdsLR_2_1259 nd02d1 $PINS A1=n7 A2=A[30] ZN=tmp_net106 VDD=VDD VSS=VSS
XctmTdsLR_3_1260 oaim22d1 $PINS A1=A[31] A2=tmp_net106 B1=A[31] B2=tmp_net106
+ ZN=SUM[31] VDD=VDD VSS=VSS
.ENDS

.SUBCKT unpu_dma ZCTSNET_49 rst_n dma_addr[31] dma_addr[30] dma_addr[29]
+ dma_addr[28] dma_addr[27] dma_addr[26] dma_addr[25] dma_addr[24] dma_addr[23]
+ dma_addr[22] dma_addr[21] dma_addr[20] dma_addr[19] dma_addr[18] dma_addr[17]
+ dma_addr[16] dma_addr[15] dma_addr[14] dma_addr[13] dma_addr[12] dma_addr[11]
+ dma_addr[10] dma_addr[9] dma_addr[8] dma_addr[7] dma_addr[6] dma_addr[5]
+ dma_addr[4] dma_addr[3] dma_addr[2] dma_addr[1] dma_addr[0] dma_wdata[31]
+ dma_wdata[30] dma_wdata[29] dma_wdata[28] dma_wdata[27] dma_wdata[26]
+ dma_wdata[25] dma_wdata[24] dma_wdata[23] dma_wdata[22] dma_wdata[21]
+ dma_wdata[20] dma_wdata[19] dma_wdata[18] dma_wdata[17] dma_wdata[16]
+ dma_wdata[15] dma_wdata[14] dma_wdata[13] dma_wdata[12] dma_wdata[11]
+ dma_wdata[10] dma_wdata[9] dma_wdata[8] dma_wdata[7] dma_wdata[6]
+ dma_wdata[5] dma_wdata[4] dma_wdata[3] dma_wdata[2] dma_wdata[1] dma_wdata[0]
+ dma_rdata[31] dma_rdata[30] dma_rdata[29] dma_rdata[28] dma_rdata[27]
+ dma_rdata[26] dma_rdata[25] dma_rdata[24] dma_rdata[23] dma_rdata[22]
+ dma_rdata[21] dma_rdata[20] dma_rdata[19] dma_rdata[18] dma_rdata[17]
+ dma_rdata[16] dma_rdata[15] dma_rdata[14] dma_rdata[13] dma_rdata[12]
+ dma_rdata[11] dma_rdata[10] dma_rdata[9] dma_rdata[8] dma_rdata[7]
+ dma_rdata[6] dma_rdata[5] dma_rdata[4] dma_rdata[3] dma_rdata[2] dma_rdata[1]
+ dma_rdata[0] dma_wstrb[3] dma_wstrb[2] dma_wstrb[1] dma_wstrb[0] dma_valid
+ dma_ready job_start job_kind[1] job_kind[0] job_base_addr[31]
+ job_base_addr[30] job_base_addr[29] job_base_addr[28] job_base_addr[27]
+ job_base_addr[26] job_base_addr[25] job_base_addr[24] job_base_addr[23]
+ job_base_addr[22] job_base_addr[21] job_base_addr[20] job_base_addr[19]
+ job_base_addr[18] job_base_addr[17] job_base_addr[16] job_base_addr[15]
+ job_base_addr[14] job_base_addr[13] job_base_addr[12] job_base_addr[11]
+ job_base_addr[10] job_base_addr[9] job_base_addr[8] job_base_addr[7]
+ job_base_addr[6] job_base_addr[5] job_base_addr[4] job_base_addr[3]
+ job_base_addr[2] job_base_addr[1] job_base_addr[0] job_m[2] job_m[1] job_m[0]
+ job_n[2] job_n[1] job_n[0] job_k[2] job_k[1] job_k[0] job_busy job_done
+ a_load_start a_load_m[2] a_load_m[1] a_load_m[0] a_load_k[2] a_load_k[1]
+ a_load_k[0] a_load_row[31] a_load_row[30] a_load_row[29] a_load_row[28]
+ a_load_row[27] a_load_row[26] a_load_row[25] a_load_row[24] a_load_row[23]
+ a_load_row[22] a_load_row[21] a_load_row[20] a_load_row[19] a_load_row[18]
+ a_load_row[17] a_load_row[16] a_load_row[15] a_load_row[14] a_load_row[13]
+ a_load_row[12] a_load_row[11] a_load_row[10] a_load_row[9] a_load_row[8]
+ a_load_row[7] a_load_row[6] a_load_row[5] a_load_row[4] a_load_row[3]
+ a_load_row[2] a_load_row[1] a_load_row[0] w_load_start w_load_k[2]
+ w_load_k[1] w_load_k[0] w_load_n[2] w_load_n[1] w_load_n[0] w_load_row[31]
+ w_load_row[30] w_load_row[29] w_load_row[28] w_load_row[27] w_load_row[26]
+ w_load_row[25] w_load_row[24] w_load_row[23] w_load_row[22] w_load_row[21]
+ w_load_row[20] w_load_row[19] w_load_row[18] w_load_row[17] w_load_row[16]
+ w_load_row[15] w_load_row[14] w_load_row[13] w_load_row[12] w_load_row[11]
+ w_load_row[10] w_load_row[9] w_load_row[8] w_load_row[7] w_load_row[6]
+ w_load_row[5] w_load_row[4] w_load_row[3] w_load_row[2] w_load_row[1]
+ w_load_row[0] c_src[511] c_src[510] c_src[509] c_src[508] c_src[507]
+ c_src[506] c_src[505] c_src[504] c_src[503] c_src[502] c_src[501] c_src[500]
+ c_src[499] c_src[498] c_src[497] c_src[496] c_src[495] c_src[494] c_src[493]
+ c_src[492] c_src[491] c_src[490] c_src[489] c_src[488] c_src[487] c_src[486]
+ c_src[485] c_src[484] c_src[483] c_src[482] c_src[481] c_src[480] c_src[479]
+ c_src[478] c_src[477] c_src[476] c_src[475] c_src[474] c_src[473] c_src[472]
+ c_src[471] c_src[470] c_src[469] c_src[468] c_src[467] c_src[466] c_src[465]
+ c_src[464] c_src[463] c_src[462] c_src[461] c_src[460] c_src[459] c_src[458]
+ c_src[457] c_src[456] c_src[455] c_src[454] c_src[453] c_src[452] c_src[451]
+ c_src[450] c_src[449] c_src[448] c_src[447] c_src[446] c_src[445] c_src[444]
+ c_src[443] c_src[442] c_src[441] c_src[440] c_src[439] c_src[438] c_src[437]
+ c_src[436] c_src[435] c_src[434] c_src[433] c_src[432] c_src[431] c_src[430]
+ c_src[429] c_src[428] c_src[427] c_src[426] c_src[425] c_src[424] c_src[423]
+ c_src[422] c_src[421] c_src[420] c_src[419] c_src[418] c_src[417] c_src[416]
+ c_src[415] c_src[414] c_src[413] c_src[412] c_src[411] c_src[410] c_src[409]
+ c_src[408] c_src[407] c_src[406] c_src[405] c_src[404] c_src[403] c_src[402]
+ c_src[401] c_src[400] c_src[399] c_src[398] c_src[397] c_src[396] c_src[395]
+ c_src[394] c_src[393] c_src[392] c_src[391] c_src[390] c_src[389] c_src[388]
+ c_src[387] c_src[386] c_src[385] c_src[384] c_src[383] c_src[382] c_src[381]
+ c_src[380] c_src[379] c_src[378] c_src[377] c_src[376] c_src[375] c_src[374]
+ c_src[373] c_src[372] c_src[371] c_src[370] c_src[369] c_src[368] c_src[367]
+ c_src[366] c_src[365] c_src[364] c_src[363] c_src[362] c_src[361] c_src[360]
+ c_src[359] c_src[358] c_src[357] c_src[356] c_src[355] c_src[354] c_src[353]
+ c_src[352] c_src[351] c_src[350] c_src[349] c_src[348] c_src[347] c_src[346]
+ c_src[345] c_src[344] c_src[343] c_src[342] c_src[341] c_src[340] c_src[339]
+ c_src[338] c_src[337] c_src[336] c_src[335] c_src[334] c_src[333] c_src[332]
+ c_src[331] c_src[330] c_src[329] c_src[328] c_src[327] c_src[326] c_src[325]
+ c_src[324] c_src[323] c_src[322] c_src[321] c_src[320] c_src[319] c_src[318]
+ c_src[317] c_src[316] c_src[315] c_src[314] c_src[313] c_src[312] c_src[311]
+ c_src[310] c_src[309] c_src[308] c_src[307] c_src[306] c_src[305] c_src[304]
+ c_src[303] c_src[302] c_src[301] c_src[300] c_src[299] c_src[298] c_src[297]
+ c_src[296] c_src[295] c_src[294] c_src[293] c_src[292] c_src[291] c_src[290]
+ c_src[289] c_src[288] c_src[287] c_src[286] c_src[285] c_src[284] c_src[283]
+ c_src[282] c_src[281] c_src[280] c_src[279] c_src[278] c_src[277] c_src[276]
+ c_src[275] c_src[274] c_src[273] c_src[272] c_src[271] c_src[270] c_src[269]
+ c_src[268] c_src[267] c_src[266] c_src[265] c_src[264] c_src[263] c_src[262]
+ c_src[261] c_src[260] c_src[259] c_src[258] c_src[257] c_src[256] c_src[255]
+ c_src[254] c_src[253] c_src[252] c_src[251] c_src[250] c_src[249] c_src[248]
+ c_src[247] c_src[246] c_src[245] c_src[244] c_src[243] c_src[242] c_src[241]
+ c_src[240] c_src[239] c_src[238] c_src[237] c_src[236] c_src[235] c_src[234]
+ c_src[233] c_src[232] c_src[231] c_src[230] c_src[229] c_src[228] c_src[227]
+ c_src[226] c_src[225] c_src[224] c_src[223] c_src[222] c_src[221] c_src[220]
+ c_src[219] c_src[218] c_src[217] c_src[216] c_src[215] c_src[214] c_src[213]
+ c_src[212] c_src[211] c_src[210] c_src[209] c_src[208] c_src[207] c_src[206]
+ c_src[205] c_src[204] c_src[203] c_src[202] c_src[201] c_src[200] c_src[199]
+ c_src[198] c_src[197] c_src[196] c_src[195] c_src[194] c_src[193] c_src[192]
+ c_src[191] c_src[190] c_src[189] c_src[188] c_src[187] c_src[186] c_src[185]
+ c_src[184] c_src[183] c_src[182] c_src[181] c_src[180] c_src[179] c_src[178]
+ c_src[177] c_src[176] c_src[175] c_src[174] c_src[173] c_src[172] c_src[171]
+ c_src[170] c_src[169] c_src[168] c_src[167] c_src[166] c_src[165] c_src[164]
+ c_src[163] c_src[162] c_src[161] c_src[160] c_src[159] c_src[158] c_src[157]
+ c_src[156] c_src[155] c_src[154] c_src[153] c_src[152] c_src[151] c_src[150]
+ c_src[149] c_src[148] c_src[147] c_src[146] c_src[145] c_src[144] c_src[143]
+ c_src[142] c_src[141] c_src[140] c_src[139] c_src[138] c_src[137] c_src[136]
+ c_src[135] c_src[134] c_src[133] c_src[132] c_src[131] c_src[130] c_src[129]
+ c_src[128] c_src[127] c_src[126] c_src[125] c_src[124] c_src[123] c_src[122]
+ c_src[121] c_src[120] c_src[119] c_src[118] c_src[117] c_src[116] c_src[115]
+ c_src[114] c_src[113] c_src[112] c_src[111] c_src[110] c_src[109] c_src[108]
+ c_src[107] c_src[106] c_src[105] c_src[104] c_src[103] c_src[102] c_src[101]
+ c_src[100] c_src[99] c_src[98] c_src[97] c_src[96] c_src[95] c_src[94]
+ c_src[93] c_src[92] c_src[91] c_src[90] c_src[89] c_src[88] c_src[87]
+ c_src[86] c_src[85] c_src[84] c_src[83] c_src[82] c_src[81] c_src[80]
+ c_src[79] c_src[78] c_src[77] c_src[76] c_src[75] c_src[74] c_src[73]
+ c_src[72] c_src[71] c_src[70] c_src[69] c_src[68] c_src[67] c_src[66]
+ c_src[65] c_src[64] c_src[63] c_src[62] c_src[61] c_src[60] c_src[59]
+ c_src[58] c_src[57] c_src[56] c_src[55] c_src[54] c_src[53] c_src[52]
+ c_src[51] c_src[50] c_src[49] c_src[48] c_src[47] c_src[46] c_src[45]
+ c_src[44] c_src[43] c_src[42] c_src[41] c_src[40] c_src[39] c_src[38]
+ c_src[37] c_src[36] c_src[35] c_src[34] c_src[33] c_src[32] c_src[31]
+ c_src[30] c_src[29] c_src[28] c_src[27] c_src[26] c_src[25] c_src[24]
+ c_src[23] c_src[22] c_src[21] c_src[20] c_src[19] c_src[18] c_src[17]
+ c_src[16] c_src[15] c_src[14] c_src[13] c_src[12] c_src[11] c_src[10]
+ c_src[9] c_src[8] c_src[7] c_src[6] c_src[5] c_src[4] c_src[3] c_src[2]
+ c_src[1] c_src[0] VDD VSS ZCTSNET_50 ZCTSNET_52 ZCTSNET_54 ZCTSNET_55
+ HFSNET_38 HFSNET_39 HFSNET_40 HFSNET_41 HFSNET_42 HFSNET_45 HFSNET_46
+ HFSNET_47 ZCTSNET_0 ZCTSNET_2 ZCTSNET_3 ZCTSNET_5 ZCTSNET_6
*.CONNECT w_load_k[0] a_load_k[0]
*.CONNECT a_load_k[2] w_load_k[2]
*.CONNECT a_load_k[1] w_load_k[1]
Xld_cnt_reg_0_ dfcrn2 $PINS D=n344 CP=ZCTSNET_3 CDN=HFSNET_43 QN=n44 VDD=VDD
+ VSS=VSS
Xm_lat_reg_0_ dfcrn2 $PINS D=n304 CP=ZCTSNET_54 CDN=HFSNET_44 QN=n43 VDD=VDD
+ VSS=VSS
Xm_lat_reg_1_ dfcrn2 $PINS D=n303 CP=ZCTSNET_2 CDN=HFSNET_39 QN=n42 VDD=VDD
+ VSS=VSS
Xm_lat_reg_2_ dfcrn2 $PINS D=n302 CP=ZCTSNET_54 CDN=HFSNET_44 QN=n41 VDD=VDD
+ VSS=VSS
Xk_lat_reg_0_ dfcrn2 $PINS D=n298 CP=ZCTSNET_54 CDN=HFSNET_44 QN=n40 VDD=VDD
+ VSS=VSS
Xk_lat_reg_1_ dfcrn2 $PINS D=n297 CP=ZCTSNET_54 CDN=HFSNET_41 QN=n39 VDD=VDD
+ VSS=VSS
Xk_lat_reg_2_ dfcrn2 $PINS D=n296 CP=ZCTSNET_52 CDN=HFSNET_41 QN=n38 VDD=VDD
+ VSS=VSS
Xld_cnt_reg_1_ dfcrn2 $PINS D=copt_gre_net_3201 CP=ZCTSNET_2 CDN=HFSNET_39
+ QN=n37 VDD=VDD VSS=VSS
Xcur_j_reg_2_ dfcrn2 $PINS D=copt_net_2908 CP=ZCTSNET_0 CDN=HFSNET_40 QN=n36
+ VDD=VDD VSS=VSS
XU14 an02d1 $PINS A1=N_uc_425 A2=n108 Z=w_load_row[31] VDD=VDD VSS=VSS
XU15 an02d1 $PINS A1=N_uc_426 A2=n108 Z=w_load_row[30] VDD=VDD VSS=VSS
XU17 an02d1 $PINS A1=N_uc_427 A2=n108 Z=w_load_row[29] VDD=VDD VSS=VSS
XU18 an02d1 $PINS A1=N_uc_428 A2=n108 Z=w_load_row[28] VDD=VDD VSS=VSS
XU19 an02d1 $PINS A1=N_uc_429 A2=n108 Z=w_load_row[27] VDD=VDD VSS=VSS
XU20 an02d1 $PINS A1=N_uc_430 A2=n108 Z=w_load_row[26] VDD=VDD VSS=VSS
XU21 an02d1 $PINS A1=N_uc_431 A2=n108 Z=w_load_row[25] VDD=VDD VSS=VSS
XU22 an02d1 $PINS A1=N_uc_432 A2=n108 Z=w_load_row[24] VDD=VDD VSS=VSS
XU23 an02d1 $PINS A1=N_uc_433 A2=n108 Z=w_load_row[23] VDD=VDD VSS=VSS
XU24 an02d1 $PINS A1=N_uc_434 A2=n108 Z=w_load_row[22] VDD=VDD VSS=VSS
XU25 an02d1 $PINS A1=N_uc_435 A2=n108 Z=w_load_row[21] VDD=VDD VSS=VSS
XU26 an02d0 $PINS A1=N_uc_436 A2=n108 Z=w_load_row[20] VDD=VDD VSS=VSS
XU27 an02d1 $PINS A1=N_uc_437 A2=n108 Z=w_load_row[19] VDD=VDD VSS=VSS
XU28 an02d0 $PINS A1=N_uc_438 A2=n108 Z=w_load_row[18] VDD=VDD VSS=VSS
XU29 an02d1 $PINS A1=N_uc_439 A2=n108 Z=w_load_row[17] VDD=VDD VSS=VSS
XU30 an02d1 $PINS A1=N_uc_440 A2=n108 Z=w_load_row[16] VDD=VDD VSS=VSS
XU31 an02d1 $PINS A1=N_uc_441 A2=n108 Z=w_load_row[15] VDD=VDD VSS=VSS
XU32 an02d1 $PINS A1=N_uc_442 A2=n108 Z=w_load_row[14] VDD=VDD VSS=VSS
XctmTdsLR_1_1311 aoim22d1 $PINS A1=beat_idx[3] A2=total_beats[3] B1=beat_idx[3]
+ B2=total_beats[3] Z=tmp_net119 VDD=VDD VSS=VSS
XU34 an02d1 $PINS A1=N_uc_444 A2=n108 Z=w_load_row[12] VDD=VDD VSS=VSS
XctmTdsLR_1_1345 nr02d1 $PINS A1=w_load_n[1] A2=w_load_n[0] ZN=tmp_net125
+ VDD=VDD VSS=VSS
XctmTdsLR_2_1312 aoim22d1 $PINS A1=tmp_net119 A2=n896 B1=tmp_net119 B2=n896
+ Z=n842 VDD=VDD VSS=VSS
XU38 nd02d0 $PINS A1=N_uc_448 A2=n108 ZN=w_load_row[8] VDD=VDD VSS=VSS
XHFSINV_120_405 inv0d1 $PINS I=copt_net_2489 ZN=w_load_n[2] VDD=VDD VSS=VSS
XU39 an02d1 $PINS A1=N_uc_449 A2=n108 Z=w_load_row[7] VDD=VDD VSS=VSS
XU43 an02d1 $PINS A1=N_uc_453 A2=n108 Z=w_load_row[3] VDD=VDD VSS=VSS
XU44 an02d1 $PINS A1=N_uc_454 A2=n108 Z=w_load_row[2] VDD=VDD VSS=VSS
XU46 an02d1 $PINS A1=N_uc_456 A2=n108 Z=w_load_row[0] VDD=VDD VSS=VSS
XctmTdsLR_1_1289 aoim22d1 $PINS A1=tmp_net108 A2=n897 B1=tmp_net108 B2=n897
+ Z=n841 VDD=VDD VSS=VSS
XU49 an02d1 $PINS A1=N_uc_35 A2=kind_lat[1] Z=total_beats[3] VDD=VDD VSS=VSS
XU67 nd04d0 $PINS A1=n119 A2=n900 A3=n902 A4=n146 ZN=n138 VDD=VDD VSS=VSS
XU74 nr03d1 $PINS A1=state[0] A2=state[2] A3=n903 ZN=n113 VDD=VDD VSS=VSS
Xcopt_gre_h_inst_5857 dl01d1 $PINS I=n343 Z=copt_gre_net_3201 VDD=VDD VSS=VSS
XU116 an02d0 $PINS A1=N_uc_394 A2=n156 Z=a_load_row[28] VDD=VDD VSS=VSS
XctmTdsLR_2_1346 aoim22d1 $PINS A1=copt_net_2587 A2=copt_net_2489
+ B1=copt_net_2587 B2=copt_net_2489 Z=tmp_net126 VDD=VDD VSS=VSS
XU118 an02d0 $PINS A1=N_uc_396 A2=n156 Z=a_load_row[26] VDD=VDD VSS=VSS
XctmTdsLR_3_1347 oaim22d1 $PINS A1=tmp_net125 A2=tmp_net126 B1=tmp_net125
+ B2=tmp_net126 ZN=n871 VDD=VDD VSS=VSS
XU120 an02d0 $PINS A1=N_uc_398 A2=n156 Z=a_load_row[24] VDD=VDD VSS=VSS
XctmTdsLR_2_1314 aoi21d1 $PINS B1=n702 B2=n703 A=gre_a_INV_177_3
+ ZN=a_load_row[27] VDD=VDD VSS=VSS
XctmTdsLR_1_1359 nd12d1 $PINS A1=copt_net_2719 A2=beat_idx[0] ZN=n844 VDD=VDD
+ VSS=VSS
XU124 an02d0 $PINS A1=N_uc_402 A2=n156 Z=a_load_row[20] VDD=VDD VSS=VSS
XU125 an02d0 $PINS A1=N_uc_403 A2=n156 Z=a_load_row[19] VDD=VDD VSS=VSS
XctmTdsLR_1_2891 aoi21d1 $PINS B1=n662 B2=n663 A=gre_a_INV_1535_3
+ ZN=a_load_row[7] VDD=VDD VSS=VSS
XU127 an02d0 $PINS A1=N_uc_405 A2=n156 Z=a_load_row[17] VDD=VDD VSS=VSS
XU128 an02d0 $PINS A1=N_uc_406 A2=n156 Z=a_load_row[16] VDD=VDD VSS=VSS
XU129 an02d0 $PINS A1=N_uc_407 A2=n156 Z=a_load_row[15] VDD=VDD VSS=VSS
XU130 an02d0 $PINS A1=N_uc_408 A2=n156 Z=a_load_row[14] VDD=VDD VSS=VSS
XctmTdsLR_2_1360 oaim22d1 $PINS A1=copt_net_2696 A2=copt_net_2719
+ B1=copt_net_2696 B2=n844 ZN=n847 VDD=VDD VSS=VSS
XU132 an02d0 $PINS A1=N_uc_410 A2=n156 Z=a_load_row[12] VDD=VDD VSS=VSS
XU133 an02d0 $PINS A1=N_uc_411 A2=n156 Z=a_load_row[11] VDD=VDD VSS=VSS
XU134 an02d0 $PINS A1=N_uc_412 A2=n156 Z=a_load_row[10] VDD=VDD VSS=VSS
XU135 an02d0 $PINS A1=N_uc_413 A2=n156 Z=a_load_row[9] VDD=VDD VSS=VSS
XU136 an02d0 $PINS A1=N_uc_414 A2=n156 Z=a_load_row[8] VDD=VDD VSS=VSS
XctmTdsLR_1_3000 nd12d1 $PINS A1=tmp_net189 A2=n119 ZN=n875 VDD=VDD VSS=VSS
XU138 an02d0 $PINS A1=N_uc_416 A2=n156 Z=a_load_row[6] VDD=VDD VSS=VSS
XU139 an02d0 $PINS A1=N_uc_417 A2=n156 Z=a_load_row[5] VDD=VDD VSS=VSS
XU140 an02d0 $PINS A1=N_uc_418 A2=n156 Z=a_load_row[4] VDD=VDD VSS=VSS
XU141 an02d0 $PINS A1=N_uc_419 A2=n156 Z=a_load_row[3] VDD=VDD VSS=VSS
XU142 an02d0 $PINS A1=N_uc_420 A2=n156 Z=a_load_row[2] VDD=VDD VSS=VSS
XU143 an02d0 $PINS A1=N_uc_421 A2=n156 Z=a_load_row[1] VDD=VDD VSS=VSS
XU144 an02d0 $PINS A1=N_uc_422 A2=n156 Z=a_load_row[0] VDD=VDD VSS=VSS
XU213 aoi221d1 $PINS B1=w_load_k[1] B2=n910 C1=a_load_k[0] C2=n899
+ A=w_load_k[2] ZN=n109 VDD=VDD VSS=VSS
XU214 oai222d1 $PINS A1=n107 A2=n38 B1=n110 B2=n41 C1=n889 C2=n906
+ ZN=total_beats[2] VDD=VDD VSS=VSS
XU215 oai222d1 $PINS A1=n107 A2=n39 B1=n110 B2=n42 C1=n889 C2=n907
+ ZN=total_beats[1] VDD=VDD VSS=VSS
XU364 aor22d1 $PINS A1=w_load_k[2] A2=n119 B1=copt_net_612 B2=HFSNET_12 Z=n296
+ VDD=VDD VSS=VSS
XU365 aor22d1 $PINS A1=w_load_k[1] A2=n119 B1=copt_net_1449 B2=HFSNET_12 Z=n297
+ VDD=VDD VSS=VSS
XU366 aor22d1 $PINS A1=a_load_k[0] A2=n119 B1=copt_net_1046 B2=HFSNET_12 Z=n298
+ VDD=VDD VSS=VSS
XU367 aor22d1 $PINS A1=job_n[2] A2=HFSNET_12 B1=copt_net_2489 B2=n119 Z=n299
+ VDD=VDD VSS=VSS
XU368 aor22d1 $PINS A1=copt_net_2661 A2=HFSNET_12 B1=w_load_n[1] B2=n119 Z=n300
+ VDD=VDD VSS=VSS
XU369 aor22d1 $PINS A1=copt_net_1294 A2=HFSNET_12 B1=w_load_n[0] B2=n119 Z=n301
+ VDD=VDD VSS=VSS
XU370 aor22d1 $PINS A1=copt_net_2207 A2=n119 B1=job_m[2] B2=HFSNET_12 Z=n302
+ VDD=VDD VSS=VSS
XU371 aor22d1 $PINS A1=a_load_m[1] A2=n119 B1=job_m[1] B2=HFSNET_12 Z=n303
+ VDD=VDD VSS=VSS
XU372 aor22d4 $PINS A1=copt_net_2842 A2=n119 B1=job_m[0] B2=HFSNET_12 Z=n304
+ VDD=VDD VSS=VSS
XU407 oai21d1 $PINS B1=n903 B2=n138 A=n139 ZN=n339 VDD=VDD VSS=VSS
XU408 oaim21d1 $PINS B1=n140 B2=n901 A=n138 ZN=n139 VDD=VDD VSS=VSS
XU409 oai21d1 $PINS B1=n909 B2=n138 A=n141 ZN=n340 VDD=VDD VSS=VSS
XU410 aon211d1 $PINS C1=copt_net_2732 C2=n142 B=n143 A=n138 ZN=n141 VDD=VDD
+ VSS=VSS
XU412 oai22d1 $PINS A1=copt_net_2762 A2=n149 B1=copt_net_2409 B2=n145 ZN=n343
+ VDD=VDD VSS=VSS
XU413 oai21d1 $PINS B1=copt_net_2409 B2=n149 A=n106 ZN=n344 VDD=VDD VSS=VSS
XU414 oai21d1 $PINS B1=n910 B2=n145 A=n140 ZN=n149 VDD=VDD VSS=VSS
XU452 or02d0 $PINS A1=n145 A2=n899 Z=n106 VDD=VDD VSS=VSS
XU453 or02d0 $PINS A1=copt_net_2408 A2=kind_lat[1] Z=n110 VDD=VDD VSS=VSS
XU454 aoi221d1 $PINS B1=a_load_m[0] B2=copt_net_2409 C1=a_load_m[1]
+ C2=copt_net_2762 A=a_load_m[2] ZN=n157 VDD=VDD VSS=VSS
Xmult_117_U7 ah01d1 $PINS A=mult_117_n13 B=mult_117_n15 CO=mult_117_n7
+ S=mult_117_n8 VDD=VDD VSS=VSS
Xmult_117_U6 ah01d1 $PINS A=mult_117_n10 B=mult_117_n12 CO=mult_117_n5
+ S=mult_117_n6 VDD=VDD VSS=VSS
Xmult_117_U5 ah01d1 $PINS A=mult_117_n16 B=mult_117_n14 CO=mult_117_n4
+ S=N_uc_33 VDD=VDD VSS=VSS
Xmult_117_U4 ad01d0 $PINS A=mult_117_n11 B=mult_117_n4 CI=mult_117_n8
+ CO=mult_117_n3 S=N_uc_34 VDD=VDD VSS=VSS
Xmult_117_U3 ad01d0 $PINS A=mult_117_n7 B=mult_117_n6 CI=mult_117_n3
+ CO=mult_117_n2 S=N_uc_35 VDD=VDD VSS=VSS
Xadd_212_3 unpu_dma_DW01_add_3 $PINS A[31]=base_lat[31] A[30]=base_lat[30]
+ A[29]=base_lat[29] A[28]=base_lat[28] A[27]=base_lat[27] A[26]=base_lat[26]
+ A[25]=base_lat[25] A[24]=base_lat[24] A[23]=base_lat[23] A[22]=base_lat[22]
+ A[21]=base_lat[21] A[20]=base_lat[20] A[19]=base_lat[19] A[18]=base_lat[18]
+ A[17]=base_lat[17] A[16]=base_lat[16] A[15]=base_lat[15] A[14]=base_lat[14]
+ A[13]=base_lat[13] A[12]=base_lat[12] A[11]=base_lat[11] A[10]=base_lat[10]
+ A[9]=base_lat[9] A[8]=base_lat[8] A[7]=base_lat[7] A[6]=base_lat[6]
+ A[5]=base_lat[5] A[4]=base_lat[4] A[3]=base_lat[3] A[2]=base_lat[2]
+ A[1]=base_lat[1] A[0]=base_lat[0] B[31]=VSS B[30]=VSS B[29]=VSS B[28]=VSS
+ B[27]=VSS B[26]=VSS B[25]=VSS B[24]=VSS B[23]=VSS B[22]=VSS B[21]=VSS B[20]=VSS
+ B[19]=VSS B[18]=VSS B[17]=VSS B[16]=VSS B[15]=VSS B[14]=VSS B[13]=VSS B[12]=VSS
+ B[11]=VSS B[10]=VSS B[9]=VSS B[8]=VSS B[7]=VSS B[6]=beat_idx[4]
+ B[5]=beat_idx[3] B[4]=beat_idx[2] B[3]=beat_idx[1] B[2]=beat_idx[0] B[1]=VSS
+ B[0]=VSS CI=VSS SUM[31]=N_uc_388 SUM[30]=N_uc_387 SUM[29]=N_uc_386
+ SUM[28]=N_uc_385 SUM[27]=N_uc_384 SUM[26]=N_uc_383 SUM[25]=N_uc_382
+ SUM[24]=N_uc_381 SUM[23]=N_uc_380 SUM[22]=N_uc_379 SUM[21]=N_uc_378
+ SUM[20]=N_uc_377 SUM[19]=N_uc_376 SUM[18]=N_uc_375 SUM[17]=N_uc_374
+ SUM[16]=N_uc_373 SUM[15]=N_uc_372 SUM[14]=N_uc_371 SUM[13]=N_uc_370
+ SUM[12]=N_uc_369 SUM[11]=N_uc_368 SUM[10]=N_uc_367 SUM[9]=N_uc_366
+ SUM[8]=N_uc_365 SUM[7]=N_uc_364 SUM[6]=N_uc_363 SUM[5]=N_uc_362 SUM[4]=N_uc_361
+ SUM[3]=N_uc_360 SUM[2]=N_uc_359 SUM[1]=N_uc_358 SUM[0]=N_uc_357 VDD=VDD VSS=VSS
Xadd_0_root_add_0_root_add_212_2 unpu_dma_DW01_add_4 $PINS A[31]=base_lat[31]
+ A[30]=base_lat[30] A[29]=base_lat[29] A[28]=base_lat[28] A[27]=base_lat[27]
+ A[26]=base_lat[26] A[25]=base_lat[25] A[24]=base_lat[24] A[23]=base_lat[23]
+ A[22]=base_lat[22] A[21]=base_lat[21] A[20]=base_lat[20] A[19]=base_lat[19]
+ A[18]=base_lat[18] A[17]=base_lat[17] A[16]=base_lat[16] A[15]=base_lat[15]
+ A[14]=base_lat[14] A[13]=base_lat[13] A[12]=base_lat[12] A[11]=base_lat[11]
+ A[10]=base_lat[10] A[9]=base_lat[9] A[8]=base_lat[8] A[7]=base_lat[7]
+ A[6]=base_lat[6] A[5]=base_lat[5] A[4]=base_lat[4] A[3]=base_lat[3]
+ A[2]=base_lat[2] A[1]=base_lat[1] A[0]=base_lat[0] B[31]=VSS B[30]=VSS
+ B[29]=VSS B[28]=VSS B[27]=VSS B[26]=VSS B[25]=VSS B[24]=VSS B[23]=VSS B[22]=VSS
+ B[21]=VSS B[20]=VSS B[19]=VSS B[18]=VSS B[17]=VSS B[16]=VSS B[15]=VSS B[14]=VSS
+ B[13]=VSS B[12]=VSS B[11]=VSS B[10]=VSS B[9]=VSS B[8]=VSS B[7]=N_uc_300
+ B[6]=N_uc_299 B[5]=N_uc_298 B[4]=N_uc_297 B[3]=copt_net_2705 B[2]=N_uc_295
+ B[1]=VSS B[0]=VSS CI=VSS SUM[31]=N_uc_356 SUM[30]=N_uc_355 SUM[29]=N_uc_354
+ SUM[28]=N_uc_353 SUM[27]=N_uc_352 SUM[26]=N_uc_351 SUM[25]=N_uc_350
+ SUM[24]=N_uc_349 SUM[23]=N_uc_348 SUM[22]=N_uc_347 SUM[21]=N_uc_346
+ SUM[20]=N_uc_345 SUM[19]=N_uc_344 SUM[18]=N_uc_343 SUM[17]=N_uc_342
+ SUM[16]=N_uc_341 SUM[15]=N_uc_340 SUM[14]=N_uc_339 SUM[13]=N_uc_338
+ SUM[12]=N_uc_337 SUM[11]=N_uc_336 SUM[10]=N_uc_335 SUM[9]=N_uc_334
+ SUM[8]=N_uc_333 SUM[7]=N_uc_332 SUM[6]=N_uc_331 SUM[5]=N_uc_330 SUM[4]=N_uc_329
+ SUM[3]=N_uc_328 SUM[2]=N_uc_327 SUM[1]=N_uc_326 SUM[0]=N_uc_325 VDD=VDD VSS=VSS
Xstage_reg_2__31_ dfcrq2 $PINS D=n228 CP=ZCTSNET_3 CDN=HFSNET_41 Q=stage[63]
+ VDD=VDD VSS=VSS
Xstage_reg_2__30_ dfcrq2 $PINS D=n229 CP=ZCTSNET_54 CDN=HFSNET_41 Q=stage[62]
+ VDD=VDD VSS=VSS
Xstage_reg_2__29_ dfcrq2 $PINS D=n230 CP=ZCTSNET_1 CDN=HFSNET_47 Q=stage[61]
+ VDD=VDD VSS=VSS
Xstage_reg_2__28_ dfcrq2 $PINS D=n231 CP=ZCTSNET_54 CDN=HFSNET_44 Q=stage[60]
+ VDD=VDD VSS=VSS
Xstage_reg_2__27_ dfcrq2 $PINS D=n232 CP=ZCTSNET_49 CDN=HFSNET_47 Q=stage[59]
+ VDD=VDD VSS=VSS
Xstage_reg_2__26_ dfcrq2 $PINS D=n233 CP=ZCTSNET_3 CDN=HFSNET_44 Q=stage[58]
+ VDD=VDD VSS=VSS
Xstage_reg_2__25_ dfcrq2 $PINS D=n234 CP=ZCTSNET_1 CDN=HFSNET_43 Q=stage[57]
+ VDD=VDD VSS=VSS
Xstage_reg_2__24_ dfcrq2 $PINS D=n235 CP=ZCTSNET_3 CDN=HFSNET_44 Q=stage[56]
+ VDD=VDD VSS=VSS
Xstage_reg_2__15_ dfcrq2 $PINS D=n244 CP=ZCTSNET_6 CDN=HFSNET_46 Q=stage[47]
+ VDD=VDD VSS=VSS
Xstage_reg_2__14_ dfcrq2 $PINS D=n245 CP=ZCTSNET_3 CDN=HFSNET_41 Q=stage[46]
+ VDD=VDD VSS=VSS
Xstage_reg_2__13_ dfcrq2 $PINS D=n246 CP=ZCTSNET_3 CDN=HFSNET_43 Q=stage[45]
+ VDD=VDD VSS=VSS
Xstage_reg_2__12_ dfcrq2 $PINS D=n247 CP=ZCTSNET_54 CDN=HFSNET_39 Q=stage[44]
+ VDD=VDD VSS=VSS
Xstage_reg_2__11_ dfcrq2 $PINS D=n248 CP=ZCTSNET_3 CDN=HFSNET_41 Q=stage[43]
+ VDD=VDD VSS=VSS
Xstage_reg_2__10_ dfcrq2 $PINS D=n249 CP=ZCTSNET_2 CDN=HFSNET_39 Q=stage[42]
+ VDD=VDD VSS=VSS
Xstage_reg_2__9_ dfcrq2 $PINS D=n250 CP=ZCTSNET_3 CDN=HFSNET_41 Q=stage[41]
+ VDD=VDD VSS=VSS
Xstage_reg_2__8_ dfcrq2 $PINS D=n251 CP=ZCTSNET_3 CDN=HFSNET_44 Q=stage[40]
+ VDD=VDD VSS=VSS
Xstage_reg_0__31_ dfcrq2 $PINS D=n164 CP=ZCTSNET_5 CDN=HFSNET_46 Q=stage[127]
+ VDD=VDD VSS=VSS
Xstage_reg_0__30_ dfcrq2 $PINS D=n165 CP=ZCTSNET_54 CDN=HFSNET_44 Q=stage[126]
+ VDD=VDD VSS=VSS
Xstage_reg_0__29_ dfcrq2 $PINS D=n166 CP=ZCTSNET_5 CDN=HFSNET_47 Q=stage[125]
+ VDD=VDD VSS=VSS
Xstage_reg_0__28_ dfcrq2 $PINS D=n167 CP=ZCTSNET_54 CDN=HFSNET_44 Q=stage[124]
+ VDD=VDD VSS=VSS
Xstage_reg_0__27_ dfcrq2 $PINS D=n168 CP=ZCTSNET_5 CDN=HFSNET_47 Q=stage[123]
+ VDD=VDD VSS=VSS
Xstage_reg_0__26_ dfcrq2 $PINS D=n169 CP=ZCTSNET_3 CDN=HFSNET_44 Q=stage[122]
+ VDD=VDD VSS=VSS
Xstage_reg_0__25_ dfcrq2 $PINS D=n170 CP=ZCTSNET_5 CDN=HFSNET_47 Q=stage[121]
+ VDD=VDD VSS=VSS
Xstage_reg_0__24_ dfcrq2 $PINS D=n171 CP=ZCTSNET_3 CDN=HFSNET_44 Q=stage[120]
+ VDD=VDD VSS=VSS
Xstage_reg_0__15_ dfcrq2 $PINS D=n180 CP=ZCTSNET_54 CDN=HFSNET_39 Q=stage[111]
+ VDD=VDD VSS=VSS
Xstage_reg_0__14_ dfcrq2 $PINS D=n181 CP=ZCTSNET_54 CDN=HFSNET_44 Q=stage[110]
+ VDD=VDD VSS=VSS
Xstage_reg_0__13_ dfcrq2 $PINS D=n182 CP=ZCTSNET_6 CDN=HFSNET_46 Q=stage[109]
+ VDD=VDD VSS=VSS
Xstage_reg_0__12_ dfcrq2 $PINS D=n183 CP=ZCTSNET_54 CDN=HFSNET_39 Q=stage[108]
+ VDD=VDD VSS=VSS
Xstage_reg_0__11_ dfcrq2 $PINS D=n184 CP=ZCTSNET_6 CDN=HFSNET_46 Q=stage[107]
+ VDD=VDD VSS=VSS
Xstage_reg_0__10_ dfcrq2 $PINS D=n185 CP=ZCTSNET_54 CDN=HFSNET_39 Q=stage[106]
+ VDD=VDD VSS=VSS
Xstage_reg_0__9_ dfcrq2 $PINS D=n186 CP=ZCTSNET_54 CDN=HFSNET_39 Q=stage[105]
+ VDD=VDD VSS=VSS
Xstage_reg_0__8_ dfcrq2 $PINS D=n187 CP=ZCTSNET_2 CDN=HFSNET_39 Q=stage[104]
+ VDD=VDD VSS=VSS
Xstage_reg_3__31_ dfcrq2 $PINS D=n260 CP=ZCTSNET_5 CDN=HFSNET_46 Q=stage[31]
+ VDD=VDD VSS=VSS
Xstage_reg_3__30_ dfcrq2 $PINS D=n261 CP=ZCTSNET_54 CDN=HFSNET_41 Q=stage[30]
+ VDD=VDD VSS=VSS
Xstage_reg_3__29_ dfcrq2 $PINS D=n262 CP=ZCTSNET_1 CDN=HFSNET_43 Q=stage[29]
+ VDD=VDD VSS=VSS
Xstage_reg_3__28_ dfcrq2 $PINS D=n263 CP=ZCTSNET_3 CDN=HFSNET_44 Q=stage[28]
+ VDD=VDD VSS=VSS
Xstage_reg_3__27_ dfcrq2 $PINS D=n264 CP=ZCTSNET_49 CDN=HFSNET_47 Q=stage[27]
+ VDD=VDD VSS=VSS
Xstage_reg_3__26_ dfcrq2 $PINS D=n265 CP=ZCTSNET_3 CDN=HFSNET_44 Q=stage[26]
+ VDD=VDD VSS=VSS
Xstage_reg_3__25_ dfcrq2 $PINS D=n266 CP=ZCTSNET_49 CDN=HFSNET_47 Q=stage[25]
+ VDD=VDD VSS=VSS
Xstage_reg_3__24_ dfcrq2 $PINS D=n267 CP=ZCTSNET_3 CDN=HFSNET_44 Q=stage[24]
+ VDD=VDD VSS=VSS
Xstage_reg_3__15_ dfcrq2 $PINS D=n276 CP=ZCTSNET_6 CDN=HFSNET_46 Q=stage[15]
+ VDD=VDD VSS=VSS
Xstage_reg_3__14_ dfcrq2 $PINS D=n277 CP=ZCTSNET_54 CDN=HFSNET_41 Q=stage[14]
+ VDD=VDD VSS=VSS
Xstage_reg_3__13_ dfcrq2 $PINS D=n278 CP=ZCTSNET_3 CDN=HFSNET_43 Q=stage[13]
+ VDD=VDD VSS=VSS
Xstage_reg_3__12_ dfcrq2 $PINS D=n279 CP=ZCTSNET_3 CDN=HFSNET_44 Q=stage[12]
+ VDD=VDD VSS=VSS
Xstage_reg_3__11_ dfcrq2 $PINS D=n280 CP=ZCTSNET_3 CDN=HFSNET_41 Q=stage[11]
+ VDD=VDD VSS=VSS
Xstage_reg_3__10_ dfcrq2 $PINS D=n281 CP=ZCTSNET_3 CDN=HFSNET_44 Q=stage[10]
+ VDD=VDD VSS=VSS
Xstage_reg_3__9_ dfcrq2 $PINS D=n282 CP=ZCTSNET_3 CDN=HFSNET_43 Q=stage[9]
+ VDD=VDD VSS=VSS
Xstage_reg_3__8_ dfcrq2 $PINS D=n283 CP=ZCTSNET_3 CDN=HFSNET_44 Q=stage[8]
+ VDD=VDD VSS=VSS
Xstage_reg_1__31_ dfcrq2 $PINS D=n196 CP=ZCTSNET_1 CDN=HFSNET_43 Q=stage[95]
+ VDD=VDD VSS=VSS
Xstage_reg_1__30_ dfcrq2 $PINS D=n197 CP=ZCTSNET_54 CDN=HFSNET_41 Q=stage[94]
+ VDD=VDD VSS=VSS
Xstage_reg_1__29_ dfcrq2 $PINS D=n198 CP=ZCTSNET_1 CDN=HFSNET_43 Q=stage[93]
+ VDD=VDD VSS=VSS
Xstage_reg_1__28_ dfcrq2 $PINS D=n199 CP=ZCTSNET_54 CDN=HFSNET_41 Q=stage[92]
+ VDD=VDD VSS=VSS
Xstage_reg_1__27_ dfcrq2 $PINS D=n200 CP=ZCTSNET_49 CDN=HFSNET_47 Q=stage[91]
+ VDD=VDD VSS=VSS
Xstage_reg_1__26_ dfcrq2 $PINS D=n201 CP=ZCTSNET_1 CDN=HFSNET_43 Q=stage[90]
+ VDD=VDD VSS=VSS
Xstage_reg_1__25_ dfcrq2 $PINS D=n202 CP=ZCTSNET_49 CDN=HFSNET_47 Q=stage[89]
+ VDD=VDD VSS=VSS
Xstage_reg_1__24_ dfcrq2 $PINS D=n203 CP=ZCTSNET_1 CDN=HFSNET_43 Q=stage[88]
+ VDD=VDD VSS=VSS
Xstage_reg_1__15_ dfcrq2 $PINS D=n212 CP=ZCTSNET_6 CDN=HFSNET_46 Q=stage[79]
+ VDD=VDD VSS=VSS
Xstage_reg_1__14_ dfcrq2 $PINS D=n213 CP=ZCTSNET_50 CDN=HFSNET_42 Q=stage[78]
+ VDD=VDD VSS=VSS
Xstage_reg_1__13_ dfcrq2 $PINS D=n214 CP=ZCTSNET_6 CDN=HFSNET_46 Q=stage[77]
+ VDD=VDD VSS=VSS
Xstage_reg_1__12_ dfcrq2 $PINS D=n215 CP=ZCTSNET_50 CDN=HFSNET_42 Q=stage[76]
+ VDD=VDD VSS=VSS
Xstage_reg_1__11_ dfcrq2 $PINS D=n216 CP=ZCTSNET_6 CDN=HFSNET_46 Q=stage[75]
+ VDD=VDD VSS=VSS
Xstage_reg_1__10_ dfcrq2 $PINS D=n217 CP=ZCTSNET_50 CDN=HFSNET_42 Q=stage[74]
+ VDD=VDD VSS=VSS
Xstage_reg_1__9_ dfcrq2 $PINS D=n218 CP=ZCTSNET_3 CDN=HFSNET_43 Q=stage[73]
+ VDD=VDD VSS=VSS
Xstage_reg_1__8_ dfcrq2 $PINS D=n219 CP=ZCTSNET_3 CDN=HFSNET_44 Q=stage[72]
+ VDD=VDD VSS=VSS
Xstage_reg_2__7_ dfcrq2 $PINS D=n252 CP=ZCTSNET_6 CDN=HFSNET_46 Q=stage[39]
+ VDD=VDD VSS=VSS
Xstage_reg_2__6_ dfcrq2 $PINS D=n253 CP=ZCTSNET_3 CDN=HFSNET_41 Q=stage[38]
+ VDD=VDD VSS=VSS
Xstage_reg_2__5_ dfcrq2 $PINS D=n254 CP=ZCTSNET_1 CDN=HFSNET_43 Q=stage[37]
+ VDD=VDD VSS=VSS
Xstage_reg_2__4_ dfcrq2 $PINS D=n255 CP=ZCTSNET_54 CDN=HFSNET_39 Q=stage[36]
+ VDD=VDD VSS=VSS
Xstage_reg_2__3_ dfcrq2 $PINS D=n256 CP=ZCTSNET_1 CDN=HFSNET_43 Q=stage[35]
+ VDD=VDD VSS=VSS
Xstage_reg_2__2_ dfcrq2 $PINS D=n257 CP=ZCTSNET_1 CDN=HFSNET_44 Q=stage[34]
+ VDD=VDD VSS=VSS
Xstage_reg_2__1_ dfcrq2 $PINS D=n258 CP=ZCTSNET_1 CDN=HFSNET_43 Q=stage[33]
+ VDD=VDD VSS=VSS
Xstage_reg_2__0_ dfcrq2 $PINS D=n259 CP=ZCTSNET_1 CDN=HFSNET_44 Q=stage[32]
+ VDD=VDD VSS=VSS
Xstage_reg_0__7_ dfcrq2 $PINS D=n188 CP=ZCTSNET_6 CDN=HFSNET_46 Q=stage[103]
+ VDD=VDD VSS=VSS
Xstage_reg_0__6_ dfcrq2 $PINS D=n189 CP=ZCTSNET_54 CDN=HFSNET_39 Q=stage[102]
+ VDD=VDD VSS=VSS
Xstage_reg_0__5_ dfcrq2 $PINS D=n190 CP=ZCTSNET_6 CDN=HFSNET_39 Q=stage[101]
+ VDD=VDD VSS=VSS
Xstage_reg_0__4_ dfcrq2 $PINS D=n191 CP=ZCTSNET_3 CDN=HFSNET_44 Q=stage[100]
+ VDD=VDD VSS=VSS
Xstage_reg_0__3_ dfcrq2 $PINS D=n192 CP=ZCTSNET_3 CDN=HFSNET_43 Q=stage[99]
+ VDD=VDD VSS=VSS
Xstage_reg_0__2_ dfcrq2 $PINS D=n193 CP=ZCTSNET_3 CDN=HFSNET_44 Q=stage[98]
+ VDD=VDD VSS=VSS
Xstage_reg_0__1_ dfcrq2 $PINS D=n194 CP=ZCTSNET_1 CDN=HFSNET_43 Q=stage[97]
+ VDD=VDD VSS=VSS
Xstage_reg_0__0_ dfcrq2 $PINS D=n195 CP=ZCTSNET_1 CDN=HFSNET_43 Q=stage[96]
+ VDD=VDD VSS=VSS
Xstage_reg_2__23_ dfcrq2 $PINS D=n236 CP=ZCTSNET_3 CDN=HFSNET_44 Q=stage[55]
+ VDD=VDD VSS=VSS
Xstage_reg_2__22_ dfcrq2 $PINS D=n237 CP=ZCTSNET_54 CDN=HFSNET_41 Q=stage[54]
+ VDD=VDD VSS=VSS
Xstage_reg_2__21_ dfcrq2 $PINS D=n238 CP=ZCTSNET_1 CDN=HFSNET_47 Q=stage[53]
+ VDD=VDD VSS=VSS
Xstage_reg_2__20_ dfcrq2 $PINS D=n239 CP=ZCTSNET_54 CDN=HFSNET_44 Q=stage[52]
+ VDD=VDD VSS=VSS
Xstage_reg_2__19_ dfcrq2 $PINS D=n240 CP=ZCTSNET_1 CDN=HFSNET_43 Q=stage[51]
+ VDD=VDD VSS=VSS
Xstage_reg_2__18_ dfcrq2 $PINS D=n241 CP=ZCTSNET_54 CDN=HFSNET_42 Q=stage[50]
+ VDD=VDD VSS=VSS
Xstage_reg_2__17_ dfcrq2 $PINS D=n242 CP=ZCTSNET_6 CDN=HFSNET_46 Q=stage[49]
+ VDD=VDD VSS=VSS
Xstage_reg_2__16_ dfcrq2 $PINS D=n243 CP=ZCTSNET_3 CDN=HFSNET_44 Q=stage[48]
+ VDD=VDD VSS=VSS
Xstage_reg_0__23_ dfcrq2 $PINS D=n172 CP=ZCTSNET_5 CDN=HFSNET_46 Q=stage[119]
+ VDD=VDD VSS=VSS
Xstage_reg_0__22_ dfcrq2 $PINS D=n173 CP=ZCTSNET_54 CDN=HFSNET_44 Q=stage[118]
+ VDD=VDD VSS=VSS
Xstage_reg_0__21_ dfcrq2 $PINS D=n174 CP=ZCTSNET_1 CDN=HFSNET_43 Q=stage[117]
+ VDD=VDD VSS=VSS
Xstage_reg_0__20_ dfcrq2 $PINS D=n175 CP=ZCTSNET_3 CDN=HFSNET_44 Q=stage[116]
+ VDD=VDD VSS=VSS
Xstage_reg_0__19_ dfcrq2 $PINS D=n176 CP=ZCTSNET_1 CDN=HFSNET_43 Q=stage[115]
+ VDD=VDD VSS=VSS
Xstage_reg_0__18_ dfcrq2 $PINS D=n177 CP=ZCTSNET_3 CDN=HFSNET_44 Q=stage[114]
+ VDD=VDD VSS=VSS
Xstage_reg_0__17_ dfcrq2 $PINS D=n178 CP=ZCTSNET_54 CDN=HFSNET_39 Q=stage[113]
+ VDD=VDD VSS=VSS
Xstage_reg_0__16_ dfcrq2 $PINS D=n179 CP=ZCTSNET_3 CDN=HFSNET_44 Q=stage[112]
+ VDD=VDD VSS=VSS
Xstage_reg_3__7_ dfcrq2 $PINS D=n284 CP=ZCTSNET_3 CDN=HFSNET_43 Q=stage[7]
+ VDD=VDD VSS=VSS
Xstage_reg_3__6_ dfcrq2 $PINS D=n285 CP=ZCTSNET_3 CDN=HFSNET_44 Q=stage[6]
+ VDD=VDD VSS=VSS
Xstage_reg_3__5_ dfcrq2 $PINS D=n286 CP=ZCTSNET_3 CDN=HFSNET_43 Q=stage[5]
+ VDD=VDD VSS=VSS
Xstage_reg_3__4_ dfcrq2 $PINS D=n287 CP=ZCTSNET_54 CDN=HFSNET_39 Q=stage[4]
+ VDD=VDD VSS=VSS
Xstage_reg_3__3_ dfcrq2 $PINS D=n288 CP=ZCTSNET_1 CDN=HFSNET_43 Q=stage[3]
+ VDD=VDD VSS=VSS
Xstage_reg_3__2_ dfcrq2 $PINS D=n289 CP=ZCTSNET_3 CDN=HFSNET_44 Q=stage[2]
+ VDD=VDD VSS=VSS
Xstage_reg_3__1_ dfcrq2 $PINS D=n290 CP=ZCTSNET_1 CDN=HFSNET_43 Q=stage[1]
+ VDD=VDD VSS=VSS
Xstage_reg_3__0_ dfcrq2 $PINS D=n291 CP=ZCTSNET_1 CDN=HFSNET_43 Q=stage[0]
+ VDD=VDD VSS=VSS
Xstage_reg_1__7_ dfcrq2 $PINS D=n220 CP=ZCTSNET_3 CDN=HFSNET_43 Q=stage[71]
+ VDD=VDD VSS=VSS
Xstage_reg_1__6_ dfcrq2 $PINS D=n221 CP=ZCTSNET_2 CDN=HFSNET_39 Q=stage[70]
+ VDD=VDD VSS=VSS
Xstage_reg_1__5_ dfcrq2 $PINS D=n222 CP=ZCTSNET_3 CDN=HFSNET_43 Q=stage[69]
+ VDD=VDD VSS=VSS
Xstage_reg_1__4_ dfcrq2 $PINS D=n223 CP=ZCTSNET_2 CDN=HFSNET_39 Q=stage[68]
+ VDD=VDD VSS=VSS
Xstage_reg_1__3_ dfcrq2 $PINS D=n224 CP=ZCTSNET_1 CDN=HFSNET_43 Q=stage[67]
+ VDD=VDD VSS=VSS
Xstage_reg_1__2_ dfcrq2 $PINS D=n225 CP=ZCTSNET_3 CDN=HFSNET_44 Q=stage[66]
+ VDD=VDD VSS=VSS
Xstage_reg_1__1_ dfcrq2 $PINS D=n226 CP=ZCTSNET_1 CDN=HFSNET_43 Q=stage[65]
+ VDD=VDD VSS=VSS
Xstage_reg_1__0_ dfcrq2 $PINS D=n227 CP=ZCTSNET_1 CDN=HFSNET_43 Q=stage[64]
+ VDD=VDD VSS=VSS
Xstage_reg_3__23_ dfcrq2 $PINS D=n268 CP=ZCTSNET_49 CDN=HFSNET_47 Q=stage[23]
+ VDD=VDD VSS=VSS
Xstage_reg_3__22_ dfcrq2 $PINS D=n269 CP=ZCTSNET_54 CDN=HFSNET_44 Q=stage[22]
+ VDD=VDD VSS=VSS
Xstage_reg_3__21_ dfcrq2 $PINS D=n270 CP=ZCTSNET_1 CDN=HFSNET_47 Q=stage[21]
+ VDD=VDD VSS=VSS
Xstage_reg_3__20_ dfcrq2 $PINS D=n271 CP=ZCTSNET_3 CDN=HFSNET_44 Q=stage[20]
+ VDD=VDD VSS=VSS
Xstage_reg_3__19_ dfcrq2 $PINS D=n272 CP=ZCTSNET_1 CDN=HFSNET_43 Q=stage[19]
+ VDD=VDD VSS=VSS
Xstage_reg_3__18_ dfcrq2 $PINS D=n273 CP=ZCTSNET_54 CDN=HFSNET_44 Q=stage[18]
+ VDD=VDD VSS=VSS
Xstage_reg_3__17_ dfcrq2 $PINS D=n274 CP=ZCTSNET_3 CDN=HFSNET_43 Q=stage[17]
+ VDD=VDD VSS=VSS
Xstage_reg_3__16_ dfcrq2 $PINS D=n275 CP=ZCTSNET_3 CDN=HFSNET_44 Q=stage[16]
+ VDD=VDD VSS=VSS
Xstage_reg_1__23_ dfcrq2 $PINS D=n204 CP=ZCTSNET_1 CDN=HFSNET_47 Q=stage[87]
+ VDD=VDD VSS=VSS
Xstage_reg_1__22_ dfcrq2 $PINS D=n205 CP=ZCTSNET_1 CDN=HFSNET_43 Q=stage[86]
+ VDD=VDD VSS=VSS
Xstage_reg_1__21_ dfcrq2 $PINS D=n206 CP=ZCTSNET_1 CDN=HFSNET_47 Q=stage[85]
+ VDD=VDD VSS=VSS
Xstage_reg_1__20_ dfcrq2 $PINS D=n207 CP=ZCTSNET_1 CDN=HFSNET_43 Q=stage[84]
+ VDD=VDD VSS=VSS
Xstage_reg_1__19_ dfcrq2 $PINS D=n208 CP=ZCTSNET_1 CDN=HFSNET_43 Q=stage[83]
+ VDD=VDD VSS=VSS
Xstage_reg_1__18_ dfcrq2 $PINS D=n209 CP=ZCTSNET_50 CDN=HFSNET_42 Q=stage[82]
+ VDD=VDD VSS=VSS
Xstage_reg_1__17_ dfcrq2 $PINS D=n210 CP=ZCTSNET_6 CDN=HFSNET_46 Q=stage[81]
+ VDD=VDD VSS=VSS
Xstage_reg_1__16_ dfcrq2 $PINS D=n211 CP=ZCTSNET_50 CDN=HFSNET_42 Q=stage[80]
+ VDD=VDD VSS=VSS
Xn_lat_reg_2_ dfcrq2 $PINS D=n299 CP=ZCTSNET_0 CDN=HFSNET_40 Q=aps_rename_1_
+ VDD=VDD VSS=VSS
Xn_lat_reg_1_ dfcrq2 $PINS D=n300 CP=ZCTSNET_0 CDN=HFSNET_40 Q=aps_rename_26_
+ VDD=VDD VSS=VSS
Xn_lat_reg_0_ dfcrq2 $PINS D=n301 CP=ZCTSNET_0 CDN=HFSNET_40 Q=aps_rename_27_
+ VDD=VDD VSS=VSS
Xbase_lat_reg_31_ dfcrq2 $PINS D=copt_net_2394 CP=ZCTSNET_55 CDN=rst_n
+ Q=base_lat[31] VDD=VDD VSS=VSS
Xbase_lat_reg_0_ dfcrq2 $PINS D=n336 CP=ZCTSNET_0 CDN=HFSNET_40 Q=base_lat[0]
+ VDD=VDD VSS=VSS
Xbase_lat_reg_1_ dfcrq2 $PINS D=copt_net_2857 CP=ZCTSNET_0 CDN=HFSNET_40
+ Q=base_lat[1] VDD=VDD VSS=VSS
Xbase_lat_reg_30_ dfcrq2 $PINS D=n306 CP=ZCTSNET_55 CDN=rst_n Q=base_lat[30]
+ VDD=VDD VSS=VSS
Xbase_lat_reg_29_ dfcrq2 $PINS D=n307 CP=ZCTSNET_55 CDN=rst_n Q=base_lat[29]
+ VDD=VDD VSS=VSS
Xbase_lat_reg_28_ dfcrq2 $PINS D=copt_net_2909 CP=ZCTSNET_55 CDN=rst_n
+ Q=base_lat[28] VDD=VDD VSS=VSS
Xbase_lat_reg_27_ dfcrq2 $PINS D=n309 CP=ZCTSNET_55 CDN=rst_n Q=base_lat[27]
+ VDD=VDD VSS=VSS
Xbase_lat_reg_26_ dfcrq2 $PINS D=n310 CP=ZCTSNET_55 CDN=rst_n Q=base_lat[26]
+ VDD=VDD VSS=VSS
Xbase_lat_reg_25_ dfcrq2 $PINS D=n311 CP=ZCTSNET_55 CDN=rst_n Q=base_lat[25]
+ VDD=VDD VSS=VSS
Xbase_lat_reg_24_ dfcrq2 $PINS D=n312 CP=ZCTSNET_55 CDN=rst_n Q=base_lat[24]
+ VDD=VDD VSS=VSS
Xbase_lat_reg_23_ dfcrq2 $PINS D=n313 CP=ZCTSNET_55 CDN=rst_n Q=base_lat[23]
+ VDD=VDD VSS=VSS
Xbase_lat_reg_22_ dfcrq2 $PINS D=copt_net_2889 CP=ZCTSNET_55 CDN=HFSNET_40
+ Q=base_lat[22] VDD=VDD VSS=VSS
Xbase_lat_reg_21_ dfcrq2 $PINS D=copt_net_2901 CP=ZCTSNET_55 CDN=HFSNET_38
+ Q=base_lat[21] VDD=VDD VSS=VSS
Xstate_reg_1_ dfcrq2 $PINS D=copt_net_2877 CP=ZCTSNET_54 CDN=HFSNET_41
+ Q=state[1] VDD=VDD VSS=VSS
Xstate_reg_2_ dfcrq2 $PINS D=n342 CP=ZCTSNET_54 CDN=HFSNET_41 Q=state[2]
+ VDD=VDD VSS=VSS
Xstate_reg_0_ dfcrq2 $PINS D=copt_net_2855 CP=ZCTSNET_54 CDN=HFSNET_41
+ Q=state[0] VDD=VDD VSS=VSS
Xbase_lat_reg_20_ dfcrq2 $PINS D=n316 CP=ZCTSNET_0 CDN=HFSNET_40 Q=base_lat[20]
+ VDD=VDD VSS=VSS
Xkind_lat_reg_1_ dfcrq2 $PINS D=n337 CP=ZCTSNET_0 CDN=HFSNET_40 Q=kind_lat[1]
+ VDD=VDD VSS=VSS
Xkind_lat_reg_0_ dfcrq2 $PINS D=n338 CP=ZCTSNET_0 CDN=HFSNET_40 Q=kind_lat[0]
+ VDD=VDD VSS=VSS
Xbase_lat_reg_19_ dfcrq2 $PINS D=n317 CP=ZCTSNET_0 CDN=HFSNET_40 Q=base_lat[19]
+ VDD=VDD VSS=VSS
Xbase_lat_reg_18_ dfcrq2 $PINS D=n318 CP=ZCTSNET_55 CDN=HFSNET_38
+ Q=base_lat[18] VDD=VDD VSS=VSS
Xbase_lat_reg_17_ dfcrq2 $PINS D=n319 CP=ZCTSNET_55 CDN=HFSNET_40
+ Q=base_lat[17] VDD=VDD VSS=VSS
Xbase_lat_reg_16_ dfcrq2 $PINS D=n320 CP=ZCTSNET_55 CDN=HFSNET_38
+ Q=base_lat[16] VDD=VDD VSS=VSS
Xbase_lat_reg_15_ dfcrq2 $PINS D=n321 CP=ZCTSNET_55 CDN=HFSNET_40
+ Q=base_lat[15] VDD=VDD VSS=VSS
Xbase_lat_reg_13_ dfcrq2 $PINS D=copt_net_605 CP=ZCTSNET_55 CDN=HFSNET_38
+ Q=base_lat[13] VDD=VDD VSS=VSS
Xbase_lat_reg_14_ dfcrq2 $PINS D=n322 CP=ZCTSNET_55 CDN=HFSNET_38
+ Q=base_lat[14] VDD=VDD VSS=VSS
Xbase_lat_reg_11_ dfcrq2 $PINS D=n325 CP=ZCTSNET_55 CDN=rst_n Q=base_lat[11]
+ VDD=VDD VSS=VSS
Xbase_lat_reg_12_ dfcrq2 $PINS D=n324 CP=ZCTSNET_55 CDN=rst_n Q=base_lat[12]
+ VDD=VDD VSS=VSS
Xbase_lat_reg_7_ dfcrq2 $PINS D=n329 CP=ZCTSNET_55 CDN=HFSNET_38 Q=base_lat[7]
+ VDD=VDD VSS=VSS
Xbase_lat_reg_8_ dfcrq2 $PINS D=n328 CP=ZCTSNET_55 CDN=HFSNET_38 Q=base_lat[8]
+ VDD=VDD VSS=VSS
Xbase_lat_reg_9_ dfcrq2 $PINS D=n327 CP=ZCTSNET_55 CDN=HFSNET_38 Q=base_lat[9]
+ VDD=VDD VSS=VSS
Xbase_lat_reg_10_ dfcrq2 $PINS D=n326 CP=ZCTSNET_55 CDN=rst_n Q=base_lat[10]
+ VDD=VDD VSS=VSS
Xcur_m_reg_2_ dfcrq2 $PINS D=ropt_net_3206 CP=ZCTSNET_54 CDN=HFSNET_41
+ Q=cur_m_2_ VDD=VDD VSS=VSS
Xbeat_idx_reg_4_ dfcrq2 $PINS D=n341 CP=ZCTSNET_0 CDN=HFSNET_40 Q=beat_idx[4]
+ VDD=VDD VSS=VSS
Xbase_lat_reg_6_ dfcrq2 $PINS D=copt_net_2878 CP=ZCTSNET_55 CDN=HFSNET_38
+ Q=base_lat[6] VDD=VDD VSS=VSS
Xcur_j_reg_1_ dfcrq2 $PINS D=n163 CP=ZCTSNET_2 CDN=HFSNET_39 Q=N_uc_296 VDD=VDD
+ VSS=VSS
Xbase_lat_reg_2_ dfcrq2 $PINS D=copt_net_2924 CP=ZCTSNET_0 CDN=HFSNET_40
+ Q=base_lat[2] VDD=VDD VSS=VSS
Xcur_j_reg_0_ dfcrq2 $PINS D=n162 CP=ZCTSNET_0 CDN=HFSNET_41 Q=N_uc_295 VDD=VDD
+ VSS=VSS
Xbeat_idx_reg_2_ dfcrq2 $PINS D=copt_net_2886 CP=ZCTSNET_0 CDN=HFSNET_40
+ Q=beat_idx[2] VDD=VDD VSS=VSS
Xbase_lat_reg_4_ dfcrq2 $PINS D=n332 CP=ZCTSNET_0 CDN=HFSNET_40 Q=base_lat[4]
+ VDD=VDD VSS=VSS
Xbeat_idx_reg_3_ dfcrq2 $PINS D=copt_net_751 CP=ZCTSNET_0 CDN=HFSNET_40
+ Q=beat_idx[3] VDD=VDD VSS=VSS
Xbase_lat_reg_3_ dfcrq2 $PINS D=copt_net_2920 CP=ZCTSNET_0 CDN=HFSNET_40
+ Q=base_lat[3] VDD=VDD VSS=VSS
Xbase_lat_reg_5_ dfcrq2 $PINS D=n331 CP=ZCTSNET_55 CDN=HFSNET_40 Q=base_lat[5]
+ VDD=VDD VSS=VSS
Xbeat_idx_reg_0_ dfcrq2 $PINS D=copt_net_2898 CP=ZCTSNET_0 CDN=HFSNET_40
+ Q=beat_idx[0] VDD=VDD VSS=VSS
Xcur_m_reg_0_ dfcrq2 $PINS D=n160 CP=ZCTSNET_54 CDN=HFSNET_41 Q=N_uc_24 VDD=VDD
+ VSS=VSS
Xbeat_idx_reg_1_ dfcrq2 $PINS D=copt_net_2856 CP=ZCTSNET_0 CDN=HFSNET_40
+ Q=beat_idx[1] VDD=VDD VSS=VSS
Xcur_m_reg_1_ dfcrn2 $PINS D=copt_net_618 CP=ZCTSNET_0 CDN=HFSNET_40 QN=n35
+ VDD=VDD VSS=VSS
XU3 aoi22d1 $PINS A1=stage[52] A2=n787 B1=stage[20] B2=n786 ZN=n765 VDD=VDD
+ VSS=VSS
XU4 aoi21d1 $PINS B1=n693 B2=n692 A=gre_a_INV_32_3 ZN=a_load_row[22] VDD=VDD
+ VSS=VSS
Xropt_h_inst_5862 dl01d1 $PINS I=n158 Z=ropt_net_3206 VDD=VDD VSS=VSS
XU6 aoi22d1 $PINS A1=stage[56] A2=n787 B1=stage[24] B2=n786 ZN=n773 VDD=VDD
+ VSS=VSS
XU7 nd12d1 $PINS A1=n43 A2=w_load_n[0] ZN=n63 VDD=VDD VSS=VSS
XU8 aoi22d1 $PINS A1=copt_net_978 A2=n787 B1=copt_net_1015 B2=n786 ZN=n785
+ VDD=VDD VSS=VSS
XU9 nd02d0 $PINS A1=n887 A2=copt_net_2732 ZN=n874 VDD=VDD VSS=VSS
XctmTdsLR_1_1290 oaim22d1 $PINS A1=N_uc_68 A2=copt_net_2719 B1=N_uc_68
+ B2=copt_net_2719 ZN=tmp_net113 VDD=VDD VSS=VSS
XU12 aoi22d1 $PINS A1=stage[101] A2=n713 B1=copt_net_816 B2=n720 ZN=n658
+ VDD=VDD VSS=VSS
XU13 aoi21d1 $PINS B1=n733 B2=n732 A=n3 ZN=w_load_row[4] VDD=VDD VSS=VSS
XU40 inv0d0 $PINS I=n108 ZN=n3 VDD=VDD VSS=VSS
Xcopt_h_inst_3022 dl03d1 $PINS I=dma_rdata[21] Z=copt_net_192 VDD=VDD VSS=VSS
XU42 aoi22d1 $PINS A1=stage[49] A2=n711 B1=stage[17] B2=n710 ZN=n683 VDD=VDD
+ VSS=VSS
XU45 aoi22d1 $PINS A1=copt_net_874 A2=n713 B1=stage[93] B2=n712 ZN=n706 VDD=VDD
+ VSS=VSS
XU47 aoi21d1 $PINS B1=n735 B2=n734 A=n4 ZN=w_load_row[5] VDD=VDD VSS=VSS
XU50 inv0d0 $PINS I=n108 ZN=n4 VDD=VDD VSS=VSS
XU51 an12d4 $PINS A2=dma_valid A1=n904 Z=dma_wstrb[1] VDD=VDD VSS=VSS
XU52 aoi22d1 $PINS A1=N_uc_179 A2=n633 B1=N_uc_147 B2=n632 ZN=n605 VDD=VDD
+ VSS=VSS
XZCTSBUF_109329_2554 buffd4 $PINS I=ZCTSNET_54 Z=ZCTSNET_1 VDD=VDD VSS=VSS
XctmTdsLR_1_1361 aoim22d1 $PINS A1=n886 A2=n35 B1=n886 B2=n35 Z=N_uc_298
+ VDD=VDD VSS=VSS
XU55 aoi21d1 $PINS B1=n709 B2=n708 A=gre_a_INV_14_3 ZN=a_load_row[30] VDD=VDD
+ VSS=VSS
XU57 aoi21d1 $PINS B1=n737 B2=n736 A=n7 ZN=w_load_row[6] VDD=VDD VSS=VSS
XU58 inv0d0 $PINS I=n108 ZN=n7 VDD=VDD VSS=VSS
XU59 an12d4 $PINS A2=dma_valid A1=n904 Z=dma_wstrb[2] VDD=VDD VSS=VSS
XU60 aoi22d1 $PINS A1=N_uc_172 A2=n633 B1=N_uc_140 B2=n632 ZN=n619 VDD=VDD
+ VSS=VSS
XU61 oai211d1 $PINS C1=n902 C2=N_uc_25 A=n875 B=n874 ZN=n881 VDD=VDD VSS=VSS
XU62 aoi21d1 $PINS B1=n715 B2=n714 A=gre_a_INV_88_3 ZN=a_load_row[31] VDD=VDD
+ VSS=VSS
XU64 aoi21d1 $PINS B1=n727 B2=n726 A=n9 ZN=w_load_row[1] VDD=VDD VSS=VSS
XU65 inv0d0 $PINS I=n108 ZN=n9 VDD=VDD VSS=VSS
XU66 aon211d1 $PINS C1=copt_net_2705 C2=copt_net_2688 B=n861 A=n866 ZN=n864
+ VDD=VDD VSS=VSS
XU68 aoi22d1 $PINS A1=copt_net_928 A2=n713 B1=stage[81] B2=n720 ZN=n682 VDD=VDD
+ VSS=VSS
XU69 aoi22d1 $PINS A1=copt_net_841 A2=n787 B1=copt_net_924 B2=n786 ZN=n775
+ VDD=VDD VSS=VSS
XU70 nr13d1 $PINS A1=copt_net_2762 A2=n106 A3=n107 ZN=w_load_start VDD=VDD
+ VSS=VSS
XU71 an03d4 $PINS A1=dma_valid A2=n836 A3=kind_lat[1] Z=dma_wstrb[3] VDD=VDD
+ VSS=VSS
XU72 aoi22d1 $PINS A1=N_uc_249 A2=n635 B1=N_uc_217 B2=n634 ZN=n592 VDD=VDD
+ VSS=VSS
XU73 nr02d2 $PINS A1=copt_net_2688 A2=N_uc_296 ZN=n635 VDD=VDD VSS=VSS
XU75 nr02d2 $PINS A1=n639 A2=N_uc_295 ZN=n633 VDD=VDD VSS=VSS
XHFSBUF_3802_437 buffd3 $PINS I=HFSNET_16 Z=HFSNET_15 VDD=VDD VSS=VSS
XHFSBUF_1393_412 buffd1 $PINS I=HFSNET_13 Z=HFSNET_12 VDD=VDD VSS=VSS
XU78 nr02d1 $PINS A1=n792 A2=copt_net_2762 ZN=n788 VDD=VDD VSS=VSS
XU79 nr02d2 $PINS A1=copt_net_2762 A2=n792 ZN=n711 VDD=VDD VSS=VSS
XU80 nr02d2 $PINS A1=n910 A2=n792 ZN=n786 VDD=VDD VSS=VSS
XU81 nr02d2 $PINS A1=n639 A2=n638 ZN=n632 VDD=VDD VSS=VSS
XU82 nr02d2 $PINS A1=n44 A2=copt_net_2762 ZN=n789 VDD=VDD VSS=VSS
XU83 nr02d2 $PINS A1=n638 A2=N_uc_296 ZN=n634 VDD=VDD VSS=VSS
XU84 nr02d2 $PINS A1=copt_net_2762 A2=n44 ZN=n710 VDD=VDD VSS=VSS
XU85 nr02d2 $PINS A1=n792 A2=n910 ZN=n713 VDD=VDD VSS=VSS
XU86 nr02d2 $PINS A1=n910 A2=n44 ZN=n787 VDD=VDD VSS=VSS
XU87 nr02d1 $PINS A1=n44 A2=n910 ZN=n712 VDD=VDD VSS=VSS
XU88 nr02d4 $PINS A1=copt_net_2666 A2=N_uc_25 ZN=n535 VDD=VDD VSS=VSS
XU89 inv0d0 $PINS I=n35 ZN=N_uc_25 VDD=VDD VSS=VSS
XctmTdsLR_1_1397 aor22d4 $PINS A1=HFSNET_15 A2=N_uc_327 B1=n904 B2=N_uc_359
+ Z=dma_addr[2] VDD=VDD VSS=VSS
XctmTdsLR_1_1382 aor22d4 $PINS A1=HFSNET_16 A2=N_uc_325 B1=n904 B2=N_uc_357
+ Z=dma_addr[0] VDD=VDD VSS=VSS
XU92 mi02d1 $PINS I0=N_uc_358 I1=N_uc_326 S=HFSNET_15 ZN=dma_addr[1] VDD=VDD
+ VSS=VSS
XU93 mi02d1 $PINS I0=N_uc_368 I1=N_uc_336 S=HFSNET_16 ZN=dma_addr[11] VDD=VDD
+ VSS=VSS
XU94 mi02d1 $PINS I0=N_uc_370 I1=N_uc_338 S=HFSNET_16 ZN=dma_addr[13] VDD=VDD
+ VSS=VSS
XctmTdsLR_1_1362 or02d1 $PINS A1=n887 A2=n35 Z=HFSNET_23 VDD=VDD VSS=VSS
XHFSINV_406_409 inv0d1 $PINS I=copt_net_2831 ZN=a_load_m[1] VDD=VDD VSS=VSS
XHFSINV_172_410 inv0d1 $PINS I=n41 ZN=a_load_m[2] VDD=VDD VSS=VSS
XU98 an02d4 $PINS A1=N_uc_272 A2=HFSNET_15 Z=dma_wdata[20] VDD=VDD VSS=VSS
XU99 an02d7 $PINS A1=N_uc_271 A2=HFSNET_15 Z=dma_wdata[21] VDD=VDD VSS=VSS
XU100 an02d4 $PINS A1=N_uc_262 A2=HFSNET_16 Z=dma_wdata[30] VDD=VDD VSS=VSS
XU101 an02d7 $PINS A1=N_uc_261 A2=HFSNET_15 Z=dma_wdata[31] VDD=VDD VSS=VSS
XU102 nr03d1 $PINS A1=state[1] A2=state[2] A3=n909 ZN=aps_rename_24_ VDD=VDD
+ VSS=VSS
XHFSINV_6219_413 inv0d2 $PINS I=n119 ZN=HFSNET_13 VDD=VDD VSS=VSS
XctmTdsLR_1_1363 or02d1 $PINS A1=N_uc_25 A2=n887 Z=HFSNET_33 VDD=VDD VSS=VSS
XctmTdsLR_1_1375 aoim22d1 $PINS A1=n866 A2=n865 B1=n866 B2=copt_net_2688 Z=n162
+ VDD=VDD VSS=VSS
XU106 bufbd4 $PINS I=n934 Z=dma_addr[7] VDD=VDD VSS=VSS
XU107 mx02d1 $PINS I0=N_uc_364 I1=N_uc_332 S=HFSNET_16 Z=n934 VDD=VDD VSS=VSS
XU108 bufbd4 $PINS I=n921 Z=dma_addr[22] VDD=VDD VSS=VSS
XU109 mx02d1 $PINS I0=N_uc_379 I1=N_uc_347 S=HFSNET_16 Z=n921 VDD=VDD VSS=VSS
XU110 an02d4 $PINS A1=N_uc_264 A2=HFSNET_16 Z=dma_wdata[28] VDD=VDD VSS=VSS
XU111 an02d4 $PINS A1=N_uc_275 A2=HFSNET_15 Z=dma_wdata[17] VDD=VDD VSS=VSS
XU112 an02d4 $PINS A1=N_uc_284 A2=HFSNET_15 Z=dma_wdata[8] VDD=VDD VSS=VSS
XU113 bufbd4 $PINS I=n935 Z=dma_addr[6] VDD=VDD VSS=VSS
XU114 mx02d0 $PINS I0=N_uc_363 I1=N_uc_331 S=HFSNET_16 Z=n935 VDD=VDD VSS=VSS
XU122 bufbd4 $PINS I=n915 Z=dma_addr[28] VDD=VDD VSS=VSS
XU145 mx02d1 $PINS I0=N_uc_385 I1=N_uc_353 S=HFSNET_16 Z=n915 VDD=VDD VSS=VSS
XU146 bufbd4 $PINS I=n922 Z=dma_addr[21] VDD=VDD VSS=VSS
XU147 mx02d1 $PINS I0=N_uc_378 I1=N_uc_346 S=HFSNET_16 Z=n922 VDD=VDD VSS=VSS
XU148 an02d4 $PINS A1=N_uc_266 A2=HFSNET_16 Z=dma_wdata[26] VDD=VDD VSS=VSS
XU149 an02d4 $PINS A1=N_uc_276 A2=HFSNET_15 Z=dma_wdata[16] VDD=VDD VSS=VSS
XU150 an02d7 $PINS A1=N_uc_285 A2=HFSNET_15 Z=dma_wdata[7] VDD=VDD VSS=VSS
XU151 bufbd4 $PINS I=n937 Z=dma_addr[4] VDD=VDD VSS=VSS
XU152 mx02d1 $PINS I0=N_uc_361 I1=N_uc_329 S=HFSNET_16 Z=n937 VDD=VDD VSS=VSS
XU153 bufbd4 $PINS I=n916 Z=dma_addr[27] VDD=VDD VSS=VSS
XU154 mx02d1 $PINS I0=N_uc_384 I1=N_uc_352 S=HFSNET_16 Z=n916 VDD=VDD VSS=VSS
XU155 bufbd4 $PINS I=n923 Z=dma_addr[20] VDD=VDD VSS=VSS
XU156 mx02d1 $PINS I0=N_uc_377 I1=N_uc_345 S=HFSNET_16 Z=n923 VDD=VDD VSS=VSS
XU157 an02d7 $PINS A1=N_uc_267 A2=HFSNET_15 Z=dma_wdata[25] VDD=VDD VSS=VSS
XU158 an02d4 $PINS A1=N_uc_277 A2=HFSNET_15 Z=dma_wdata[15] VDD=VDD VSS=VSS
XU159 an02d4 $PINS A1=N_uc_286 A2=HFSNET_15 Z=dma_wdata[6] VDD=VDD VSS=VSS
XU160 bufbd4 $PINS I=n917 Z=dma_addr[26] VDD=VDD VSS=VSS
XU161 mx02d0 $PINS I0=N_uc_383 I1=N_uc_351 S=HFSNET_16 Z=n917 VDD=VDD VSS=VSS
XU162 bufbd4 $PINS I=n924 Z=dma_addr[19] VDD=VDD VSS=VSS
XU163 mx02d1 $PINS I0=N_uc_376 I1=N_uc_344 S=HFSNET_16 Z=n924 VDD=VDD VSS=VSS
XU164 bufbd4 $PINS I=n931 Z=dma_addr[10] VDD=VDD VSS=VSS
XU165 mx02d1 $PINS I0=N_uc_367 I1=N_uc_335 S=HFSNET_16 Z=n931 VDD=VDD VSS=VSS
XU166 an02d4 $PINS A1=N_uc_268 A2=HFSNET_16 Z=dma_wdata[24] VDD=VDD VSS=VSS
XU167 an02d4 $PINS A1=N_uc_278 A2=HFSNET_15 Z=dma_wdata[14] VDD=VDD VSS=VSS
XU168 an02d4 $PINS A1=N_uc_287 A2=HFSNET_15 Z=dma_wdata[5] VDD=VDD VSS=VSS
XU169 bufbd4 $PINS I=n918 Z=dma_addr[25] VDD=VDD VSS=VSS
XU170 mx02d1 $PINS I0=N_uc_382 I1=N_uc_350 S=HFSNET_16 Z=n918 VDD=VDD VSS=VSS
XU171 bufbd4 $PINS I=n925 Z=dma_addr[18] VDD=VDD VSS=VSS
XU172 mx02d1 $PINS I0=N_uc_375 I1=N_uc_343 S=HFSNET_16 Z=n925 VDD=VDD VSS=VSS
XU173 bufbd4 $PINS I=n936 Z=dma_addr[5] VDD=VDD VSS=VSS
XU174 mx02d1 $PINS I0=N_uc_362 I1=N_uc_330 S=HFSNET_15 Z=n936 VDD=VDD VSS=VSS
XU175 an02d4 $PINS A1=N_uc_269 A2=HFSNET_15 Z=dma_wdata[23] VDD=VDD VSS=VSS
XU176 an02d4 $PINS A1=N_uc_279 A2=HFSNET_15 Z=dma_wdata[13] VDD=VDD VSS=VSS
XU177 an02d4 $PINS A1=N_uc_288 A2=HFSNET_15 Z=dma_wdata[4] VDD=VDD VSS=VSS
XctmTdsLR_1_1398 oaim22d1 $PINS A1=copt_net_2705 A2=n862 B1=copt_net_2705
+ B2=n860 ZN=n163 VDD=VDD VSS=VSS
XctmTdsLR_1_1403 nd02d1 $PINS A1=n881 A2=copt_net_2083 ZN=tmp_net132 VDD=VDD
+ VSS=VSS
XctmTdsLR_2_1404 oai31d1 $PINS B1=n879 B2=n35 B3=copt_net_2083 A=tmp_net132
+ ZN=n158 VDD=VDD VSS=VSS
XU181 bufbd4 $PINS I=n919 Z=dma_addr[24] VDD=VDD VSS=VSS
XU182 mx02d0 $PINS I0=N_uc_381 I1=N_uc_349 S=HFSNET_16 Z=n919 VDD=VDD VSS=VSS
XU183 bufbd4 $PINS I=n929 Z=dma_addr[14] VDD=VDD VSS=VSS
XU184 mx02d0 $PINS I0=N_uc_371 I1=N_uc_339 S=HFSNET_16 Z=n929 VDD=VDD VSS=VSS
XU185 bufbd4 $PINS I=n938 Z=dma_addr[3] VDD=VDD VSS=VSS
XU186 mx02d1 $PINS I0=N_uc_360 I1=N_uc_328 S=HFSNET_15 Z=n938 VDD=VDD VSS=VSS
XU187 an02d4 $PINS A1=N_uc_280 A2=HFSNET_15 Z=dma_wdata[12] VDD=VDD VSS=VSS
XU188 an02d4 $PINS A1=N_uc_289 A2=HFSNET_15 Z=dma_wdata[3] VDD=VDD VSS=VSS
XU189 bufbd4 $PINS I=n920 Z=dma_addr[23] VDD=VDD VSS=VSS
XU190 mx02d1 $PINS I0=N_uc_380 I1=N_uc_348 S=HFSNET_16 Z=n920 VDD=VDD VSS=VSS
XU191 bufbd4 $PINS I=n927 Z=dma_addr[16] VDD=VDD VSS=VSS
XU192 mx02d1 $PINS I0=N_uc_373 I1=N_uc_341 S=HFSNET_16 Z=n927 VDD=VDD VSS=VSS
XU193 bufbd4 $PINS I=n932 Z=dma_addr[9] VDD=VDD VSS=VSS
XU194 mx02d1 $PINS I0=N_uc_366 I1=N_uc_334 S=HFSNET_16 Z=n932 VDD=VDD VSS=VSS
XU195 an02d4 $PINS A1=N_uc_273 A2=HFSNET_15 Z=dma_wdata[19] VDD=VDD VSS=VSS
XU196 an02d4 $PINS A1=N_uc_283 A2=HFSNET_15 Z=dma_wdata[9] VDD=VDD VSS=VSS
XU197 an02d4 $PINS A1=N_uc_290 A2=HFSNET_15 Z=dma_wdata[2] VDD=VDD VSS=VSS
XU198 an02d7 $PINS A1=N_uc_263 A2=HFSNET_15 Z=dma_wdata[29] VDD=VDD VSS=VSS
XctmTdsLR_1_1405 aoim22d1 $PINS A1=n35 A2=n879 B1=n35 B2=n880 Z=n159 VDD=VDD
+ VSS=VSS
XctmTdsLR_1_2885 oai211d1 $PINS C1=mult_117_n2 C2=tmp_net183 A=tmp_net184
+ B=kind_lat[1] ZN=tmp_net107 VDD=VDD VSS=VSS
Xcopt_h_inst_3023 dl02d1 $PINS I=dma_rdata[1] Z=copt_net_193 VDD=VDD VSS=VSS
XU202 bufbd4 $PINS I=n913 Z=dma_addr[30] VDD=VDD VSS=VSS
XU203 mx02d1 $PINS I0=N_uc_387 I1=N_uc_355 S=HFSNET_16 Z=n913 VDD=VDD VSS=VSS
XU204 bufbd4 $PINS I=n930 Z=dma_addr[12] VDD=VDD VSS=VSS
XU205 mx02d0 $PINS I0=N_uc_369 I1=N_uc_337 S=HFSNET_16 Z=n930 VDD=VDD VSS=VSS
XU206 bufbd4 $PINS I=n926 Z=dma_addr[17] VDD=VDD VSS=VSS
XU207 mx02d1 $PINS I0=N_uc_374 I1=N_uc_342 S=HFSNET_16 Z=n926 VDD=VDD VSS=VSS
XU208 an02d4 $PINS A1=N_uc_270 A2=HFSNET_15 Z=dma_wdata[22] VDD=VDD VSS=VSS
XU209 an02d4 $PINS A1=N_uc_291 A2=HFSNET_15 Z=dma_wdata[1] VDD=VDD VSS=VSS
XU210 an02d7 $PINS A1=N_uc_281 A2=HFSNET_15 Z=dma_wdata[11] VDD=VDD VSS=VSS
XU211 bufbd4 $PINS I=n914 Z=dma_addr[29] VDD=VDD VSS=VSS
XU212 mx02d1 $PINS I0=N_uc_386 I1=N_uc_354 S=HFSNET_16 Z=n914 VDD=VDD VSS=VSS
XU216 bufbd4 $PINS I=n933 Z=dma_addr[8] VDD=VDD VSS=VSS
XU217 mx02d1 $PINS I0=N_uc_365 I1=N_uc_333 S=HFSNET_16 Z=n933 VDD=VDD VSS=VSS
XU218 bufbd4 $PINS I=n928 Z=dma_addr[15] VDD=VDD VSS=VSS
XU219 mx02d1 $PINS I0=N_uc_372 I1=N_uc_340 S=HFSNET_16 Z=n928 VDD=VDD VSS=VSS
XU220 an02d7 $PINS A1=N_uc_265 A2=HFSNET_15 Z=dma_wdata[27] VDD=VDD VSS=VSS
XU221 an02d4 $PINS A1=N_uc_274 A2=HFSNET_15 Z=dma_wdata[18] VDD=VDD VSS=VSS
XU222 an02d4 $PINS A1=N_uc_292 A2=HFSNET_15 Z=dma_wdata[0] VDD=VDD VSS=VSS
XU223 an02d4 $PINS A1=N_uc_282 A2=HFSNET_15 Z=dma_wdata[10] VDD=VDD VSS=VSS
XctmTdsLR_1_1246 aoi21d1 $PINS B1=total_beats[1] B2=total_beats[0] A=n895
+ ZN=tmp_net103 VDD=VDD VSS=VSS
XHFSBUF_532_447 buffd1 $PINS I=HFSNET_27 Z=HFSNET_25 VDD=VDD VSS=VSS
XU226 nd02d1 $PINS A1=n591 A2=n590 ZN=N_uc_282 VDD=VDD VSS=VSS
XU227 nd02d1 $PINS A1=n593 A2=n592 ZN=N_uc_281 VDD=VDD VSS=VSS
XU228 nd02d1 $PINS A1=n589 A2=n588 ZN=N_uc_283 VDD=VDD VSS=VSS
XU229 nd02d1 $PINS A1=n595 A2=n594 ZN=N_uc_280 VDD=VDD VSS=VSS
XU230 nd02d1 $PINS A1=n597 A2=n596 ZN=N_uc_279 VDD=VDD VSS=VSS
XU231 nd02d1 $PINS A1=n599 A2=n598 ZN=N_uc_278 VDD=VDD VSS=VSS
XU232 nd02d1 $PINS A1=n601 A2=n600 ZN=N_uc_277 VDD=VDD VSS=VSS
XU233 nd02d1 $PINS A1=n603 A2=n602 ZN=N_uc_276 VDD=VDD VSS=VSS
XU234 nd02d1 $PINS A1=n605 A2=n604 ZN=N_uc_275 VDD=VDD VSS=VSS
XU235 nd02d1 $PINS A1=n607 A2=n606 ZN=N_uc_274 VDD=VDD VSS=VSS
XU236 nd02d1 $PINS A1=n609 A2=n608 ZN=N_uc_273 VDD=VDD VSS=VSS
XU237 nd02d1 $PINS A1=n611 A2=n610 ZN=N_uc_272 VDD=VDD VSS=VSS
XU238 nd02d1 $PINS A1=n613 A2=n612 ZN=N_uc_271 VDD=VDD VSS=VSS
XU239 nd02d1 $PINS A1=n615 A2=n614 ZN=N_uc_270 VDD=VDD VSS=VSS
XU240 nd02d1 $PINS A1=n617 A2=n616 ZN=N_uc_269 VDD=VDD VSS=VSS
XU241 nd02d1 $PINS A1=n619 A2=n618 ZN=N_uc_268 VDD=VDD VSS=VSS
XU242 nd02d1 $PINS A1=n621 A2=n620 ZN=N_uc_267 VDD=VDD VSS=VSS
XU243 nd02d1 $PINS A1=n623 A2=n622 ZN=N_uc_266 VDD=VDD VSS=VSS
XctmTdsLR_1_1383 nd12d1 $PINS A1=copt_net_2728 A2=n851 ZN=n852 VDD=VDD VSS=VSS
XU245 nd02d1 $PINS A1=n571 A2=n570 ZN=N_uc_292 VDD=VDD VSS=VSS
XU246 nd02d1 $PINS A1=n573 A2=n572 ZN=N_uc_291 VDD=VDD VSS=VSS
XU247 nd02d1 $PINS A1=n575 A2=n574 ZN=N_uc_290 VDD=VDD VSS=VSS
XU248 nd02d1 $PINS A1=n577 A2=n576 ZN=N_uc_289 VDD=VDD VSS=VSS
XU249 nd02d1 $PINS A1=n579 A2=n578 ZN=N_uc_288 VDD=VDD VSS=VSS
XU250 nd02d1 $PINS A1=n581 A2=n580 ZN=N_uc_287 VDD=VDD VSS=VSS
XU251 nd02d1 $PINS A1=n583 A2=n582 ZN=N_uc_286 VDD=VDD VSS=VSS
XU252 nd02d1 $PINS A1=n585 A2=n584 ZN=N_uc_285 VDD=VDD VSS=VSS
XU253 nd02d1 $PINS A1=n587 A2=n586 ZN=N_uc_284 VDD=VDD VSS=VSS
XU254 nd02d1 $PINS A1=n629 A2=n628 ZN=N_uc_263 VDD=VDD VSS=VSS
XU255 nd02d1 $PINS A1=n631 A2=n630 ZN=N_uc_262 VDD=VDD VSS=VSS
XU256 nd02d1 $PINS A1=n637 A2=n636 ZN=N_uc_261 VDD=VDD VSS=VSS
XU257 nd02d1 $PINS A1=n361 A2=n360 ZN=N_uc_219 VDD=VDD VSS=VSS
XU258 nd02d1 $PINS A1=n363 A2=n362 ZN=N_uc_218 VDD=VDD VSS=VSS
XU259 nd02d1 $PINS A1=n365 A2=n364 ZN=N_uc_217 VDD=VDD VSS=VSS
XU260 nd02d1 $PINS A1=n367 A2=n366 ZN=N_uc_216 VDD=VDD VSS=VSS
XU261 nd02d1 $PINS A1=n369 A2=n368 ZN=N_uc_215 VDD=VDD VSS=VSS
XU262 nd02d1 $PINS A1=n371 A2=n370 ZN=N_uc_214 VDD=VDD VSS=VSS
XU263 nd02d1 $PINS A1=n373 A2=n372 ZN=N_uc_213 VDD=VDD VSS=VSS
XU264 nd02d1 $PINS A1=n375 A2=n374 ZN=N_uc_212 VDD=VDD VSS=VSS
XU265 nd02d1 $PINS A1=n377 A2=n376 ZN=N_uc_211 VDD=VDD VSS=VSS
XU266 nd02d1 $PINS A1=n379 A2=n378 ZN=N_uc_210 VDD=VDD VSS=VSS
XU267 nd02d1 $PINS A1=n381 A2=n380 ZN=N_uc_209 VDD=VDD VSS=VSS
XU268 nd02d1 $PINS A1=n383 A2=n382 ZN=N_uc_208 VDD=VDD VSS=VSS
XU269 nd02d1 $PINS A1=n385 A2=n384 ZN=N_uc_207 VDD=VDD VSS=VSS
XU270 nd02d1 $PINS A1=n387 A2=n386 ZN=N_uc_206 VDD=VDD VSS=VSS
XU271 nd02d1 $PINS A1=n389 A2=n388 ZN=N_uc_205 VDD=VDD VSS=VSS
XU272 nd02d1 $PINS A1=n391 A2=n390 ZN=N_uc_204 VDD=VDD VSS=VSS
XU273 nd02d1 $PINS A1=n393 A2=n392 ZN=N_uc_203 VDD=VDD VSS=VSS
XU274 nd02d1 $PINS A1=n395 A2=n394 ZN=N_uc_202 VDD=VDD VSS=VSS
XU275 nd02d1 $PINS A1=n154 A2=n153 ZN=N_uc_228 VDD=VDD VSS=VSS
XU276 nd02d1 $PINS A1=n345 A2=n155 ZN=N_uc_227 VDD=VDD VSS=VSS
XU277 nd02d1 $PINS A1=n347 A2=n346 ZN=N_uc_226 VDD=VDD VSS=VSS
XU278 nd02d1 $PINS A1=n349 A2=n348 ZN=N_uc_225 VDD=VDD VSS=VSS
XU279 nd02d1 $PINS A1=n351 A2=n350 ZN=N_uc_224 VDD=VDD VSS=VSS
XU280 nd02d1 $PINS A1=n353 A2=n352 ZN=N_uc_223 VDD=VDD VSS=VSS
XU281 nd02d1 $PINS A1=n355 A2=n354 ZN=N_uc_222 VDD=VDD VSS=VSS
XU282 nd02d1 $PINS A1=n357 A2=n356 ZN=N_uc_221 VDD=VDD VSS=VSS
XU283 nd02d1 $PINS A1=n359 A2=n358 ZN=N_uc_220 VDD=VDD VSS=VSS
XU284 nd02d1 $PINS A1=n397 A2=n396 ZN=N_uc_201 VDD=VDD VSS=VSS
XU285 nd02d1 $PINS A1=n399 A2=n398 ZN=N_uc_200 VDD=VDD VSS=VSS
XU286 nd02d1 $PINS A1=n401 A2=n400 ZN=N_uc_199 VDD=VDD VSS=VSS
XU287 nd02d1 $PINS A1=n403 A2=n402 ZN=N_uc_198 VDD=VDD VSS=VSS
XU288 nd02d1 $PINS A1=n405 A2=n404 ZN=N_uc_197 VDD=VDD VSS=VSS
XU289 nd02d1 $PINS A1=n91 A2=n90 ZN=N_uc_251 VDD=VDD VSS=VSS
XU290 nd02d1 $PINS A1=n93 A2=n92 ZN=N_uc_250 VDD=VDD VSS=VSS
XU291 nd02d1 $PINS A1=n95 A2=n94 ZN=N_uc_249 VDD=VDD VSS=VSS
XU292 nd02d1 $PINS A1=n97 A2=n96 ZN=N_uc_248 VDD=VDD VSS=VSS
XU293 nd02d1 $PINS A1=n99 A2=n98 ZN=N_uc_247 VDD=VDD VSS=VSS
XU294 nd02d1 $PINS A1=n101 A2=n100 ZN=N_uc_246 VDD=VDD VSS=VSS
XU295 nd02d1 $PINS A1=n103 A2=n102 ZN=N_uc_245 VDD=VDD VSS=VSS
XU296 nd02d1 $PINS A1=n105 A2=n104 ZN=N_uc_244 VDD=VDD VSS=VSS
XU297 nd02d1 $PINS A1=n112 A2=n111 ZN=N_uc_243 VDD=VDD VSS=VSS
XU298 nd02d1 $PINS A1=n115 A2=n114 ZN=N_uc_242 VDD=VDD VSS=VSS
XU299 nd02d1 $PINS A1=n117 A2=n116 ZN=N_uc_241 VDD=VDD VSS=VSS
XU300 nd02d1 $PINS A1=n120 A2=n118 ZN=N_uc_240 VDD=VDD VSS=VSS
XU301 nd02d1 $PINS A1=n122 A2=n121 ZN=N_uc_239 VDD=VDD VSS=VSS
XU302 nd02d1 $PINS A1=n124 A2=n123 ZN=N_uc_238 VDD=VDD VSS=VSS
XU303 nd02d1 $PINS A1=n126 A2=n125 ZN=N_uc_237 VDD=VDD VSS=VSS
XU304 nd02d1 $PINS A1=n128 A2=n127 ZN=N_uc_236 VDD=VDD VSS=VSS
XU305 nd02d1 $PINS A1=n130 A2=n129 ZN=N_uc_235 VDD=VDD VSS=VSS
XU306 nd02d1 $PINS A1=n132 A2=n131 ZN=N_uc_234 VDD=VDD VSS=VSS
XU307 nd02d1 $PINS A1=n73 A2=n72 ZN=N_uc_260 VDD=VDD VSS=VSS
XU308 nd02d1 $PINS A1=n75 A2=n74 ZN=N_uc_259 VDD=VDD VSS=VSS
XU309 nd02d1 $PINS A1=n77 A2=n76 ZN=N_uc_258 VDD=VDD VSS=VSS
XU310 nd02d1 $PINS A1=n79 A2=n78 ZN=N_uc_257 VDD=VDD VSS=VSS
XU311 nd02d1 $PINS A1=n81 A2=n80 ZN=N_uc_256 VDD=VDD VSS=VSS
XU312 nd02d1 $PINS A1=n83 A2=n82 ZN=N_uc_255 VDD=VDD VSS=VSS
XU313 nd02d1 $PINS A1=n85 A2=n84 ZN=N_uc_254 VDD=VDD VSS=VSS
XU314 nd02d1 $PINS A1=n87 A2=n86 ZN=N_uc_253 VDD=VDD VSS=VSS
XU315 nd02d1 $PINS A1=n89 A2=n88 ZN=N_uc_252 VDD=VDD VSS=VSS
XU316 nd02d1 $PINS A1=n425 A2=n424 ZN=N_uc_187 VDD=VDD VSS=VSS
XU317 nd02d1 $PINS A1=n427 A2=n426 ZN=N_uc_186 VDD=VDD VSS=VSS
XU318 nd02d1 $PINS A1=n429 A2=n428 ZN=N_uc_185 VDD=VDD VSS=VSS
XU319 nd02d1 $PINS A1=n431 A2=n430 ZN=N_uc_184 VDD=VDD VSS=VSS
XU320 nd02d1 $PINS A1=n433 A2=n432 ZN=N_uc_183 VDD=VDD VSS=VSS
XU321 nd02d1 $PINS A1=n435 A2=n434 ZN=N_uc_182 VDD=VDD VSS=VSS
XU322 nd02d1 $PINS A1=n437 A2=n436 ZN=N_uc_181 VDD=VDD VSS=VSS
XU323 nd02d1 $PINS A1=n439 A2=n438 ZN=N_uc_180 VDD=VDD VSS=VSS
XU324 nd02d1 $PINS A1=n407 A2=n406 ZN=N_uc_196 VDD=VDD VSS=VSS
XU325 nd02d1 $PINS A1=n409 A2=n408 ZN=N_uc_195 VDD=VDD VSS=VSS
XU326 nd02d1 $PINS A1=n411 A2=n410 ZN=N_uc_194 VDD=VDD VSS=VSS
XU327 nd02d1 $PINS A1=n413 A2=n412 ZN=N_uc_193 VDD=VDD VSS=VSS
XU328 nd02d1 $PINS A1=n415 A2=n414 ZN=N_uc_192 VDD=VDD VSS=VSS
XU329 nd02d1 $PINS A1=n417 A2=n416 ZN=N_uc_191 VDD=VDD VSS=VSS
XU330 nd02d1 $PINS A1=n419 A2=n418 ZN=N_uc_190 VDD=VDD VSS=VSS
XU331 nd02d1 $PINS A1=n421 A2=n420 ZN=N_uc_189 VDD=VDD VSS=VSS
XU332 nd02d1 $PINS A1=n423 A2=n422 ZN=N_uc_188 VDD=VDD VSS=VSS
XU333 nd02d1 $PINS A1=n134 A2=n133 ZN=N_uc_233 VDD=VDD VSS=VSS
XU334 nd02d1 $PINS A1=n136 A2=n135 ZN=N_uc_232 VDD=VDD VSS=VSS
XU335 nd02d1 $PINS A1=n144 A2=n137 ZN=N_uc_231 VDD=VDD VSS=VSS
XU336 nd02d1 $PINS A1=n150 A2=n148 ZN=N_uc_230 VDD=VDD VSS=VSS
XU337 nd02d1 $PINS A1=n152 A2=n151 ZN=N_uc_229 VDD=VDD VSS=VSS
XU338 nd02d1 $PINS A1=n489 A2=n488 ZN=N_uc_155 VDD=VDD VSS=VSS
XU339 nd02d1 $PINS A1=n491 A2=n490 ZN=N_uc_154 VDD=VDD VSS=VSS
XU340 nd02d1 $PINS A1=n493 A2=n492 ZN=N_uc_153 VDD=VDD VSS=VSS
XU341 nd02d1 $PINS A1=n495 A2=n494 ZN=N_uc_152 VDD=VDD VSS=VSS
XU342 nd02d1 $PINS A1=n497 A2=n496 ZN=N_uc_151 VDD=VDD VSS=VSS
XU343 nd02d1 $PINS A1=n499 A2=n498 ZN=N_uc_150 VDD=VDD VSS=VSS
XU344 nd02d1 $PINS A1=n501 A2=n500 ZN=N_uc_149 VDD=VDD VSS=VSS
XU345 nd02d1 $PINS A1=n503 A2=n502 ZN=N_uc_148 VDD=VDD VSS=VSS
XU346 nd02d1 $PINS A1=n505 A2=n504 ZN=N_uc_147 VDD=VDD VSS=VSS
XU347 nd02d1 $PINS A1=n507 A2=n506 ZN=N_uc_146 VDD=VDD VSS=VSS
XU348 nd02d1 $PINS A1=n509 A2=n508 ZN=N_uc_145 VDD=VDD VSS=VSS
XU349 nd02d1 $PINS A1=n511 A2=n510 ZN=N_uc_144 VDD=VDD VSS=VSS
XU350 nd02d1 $PINS A1=n513 A2=n512 ZN=N_uc_143 VDD=VDD VSS=VSS
XU351 nd02d1 $PINS A1=n515 A2=n514 ZN=N_uc_142 VDD=VDD VSS=VSS
XU352 nd02d1 $PINS A1=n517 A2=n516 ZN=N_uc_141 VDD=VDD VSS=VSS
XU353 nd02d1 $PINS A1=n519 A2=n518 ZN=N_uc_140 VDD=VDD VSS=VSS
XU354 nd02d1 $PINS A1=n521 A2=n520 ZN=N_uc_139 VDD=VDD VSS=VSS
XU355 nd02d1 $PINS A1=n523 A2=n522 ZN=N_uc_138 VDD=VDD VSS=VSS
XU356 nd02d1 $PINS A1=n471 A2=n470 ZN=N_uc_164 VDD=VDD VSS=VSS
XU357 nd02d1 $PINS A1=n473 A2=n472 ZN=N_uc_163 VDD=VDD VSS=VSS
XU358 nd02d1 $PINS A1=n475 A2=n474 ZN=N_uc_162 VDD=VDD VSS=VSS
XU359 nd02d1 $PINS A1=n477 A2=n476 ZN=N_uc_161 VDD=VDD VSS=VSS
XU360 nd02d1 $PINS A1=n479 A2=n478 ZN=N_uc_160 VDD=VDD VSS=VSS
XU361 nd02d1 $PINS A1=n481 A2=n480 ZN=N_uc_159 VDD=VDD VSS=VSS
XU362 nd02d1 $PINS A1=n483 A2=n482 ZN=N_uc_158 VDD=VDD VSS=VSS
XU363 nd02d1 $PINS A1=n485 A2=n484 ZN=N_uc_157 VDD=VDD VSS=VSS
XU373 nd02d1 $PINS A1=n487 A2=n486 ZN=N_uc_156 VDD=VDD VSS=VSS
XU374 nd02d1 $PINS A1=n525 A2=n524 ZN=N_uc_137 VDD=VDD VSS=VSS
XU375 nd02d1 $PINS A1=n527 A2=n526 ZN=N_uc_136 VDD=VDD VSS=VSS
XU376 nd02d1 $PINS A1=n529 A2=n528 ZN=N_uc_135 VDD=VDD VSS=VSS
XU377 nd02d1 $PINS A1=n441 A2=n440 ZN=N_uc_179 VDD=VDD VSS=VSS
XU378 nd02d1 $PINS A1=n443 A2=n442 ZN=N_uc_178 VDD=VDD VSS=VSS
XU379 nd02d1 $PINS A1=n445 A2=n444 ZN=N_uc_177 VDD=VDD VSS=VSS
XU380 nd02d1 $PINS A1=n447 A2=n446 ZN=N_uc_176 VDD=VDD VSS=VSS
XU381 nd02d1 $PINS A1=n449 A2=n448 ZN=N_uc_175 VDD=VDD VSS=VSS
XU382 nd02d1 $PINS A1=n451 A2=n450 ZN=N_uc_174 VDD=VDD VSS=VSS
XU383 nd02d1 $PINS A1=n453 A2=n452 ZN=N_uc_173 VDD=VDD VSS=VSS
XU384 nd02d1 $PINS A1=n455 A2=n454 ZN=N_uc_172 VDD=VDD VSS=VSS
XU385 nd02d1 $PINS A1=n457 A2=n456 ZN=N_uc_171 VDD=VDD VSS=VSS
XU386 nd02d1 $PINS A1=n459 A2=n458 ZN=N_uc_170 VDD=VDD VSS=VSS
XU387 nd02d1 $PINS A1=n461 A2=n460 ZN=N_uc_169 VDD=VDD VSS=VSS
XU388 nd02d1 $PINS A1=n463 A2=n462 ZN=N_uc_168 VDD=VDD VSS=VSS
XU389 nd02d1 $PINS A1=n465 A2=n464 ZN=N_uc_167 VDD=VDD VSS=VSS
XU390 nd02d1 $PINS A1=n467 A2=n466 ZN=N_uc_166 VDD=VDD VSS=VSS
XU391 nd02d1 $PINS A1=n469 A2=n468 ZN=N_uc_165 VDD=VDD VSS=VSS
XU392 aoi31d2 $PINS B1=n42 B2=n41 B3=n910 A=n157 ZN=n156 VDD=VDD VSS=VSS
XU393 aoi31d2 $PINS B1=copt_net_2811 B2=copt_net_2762 B3=copt_net_2269 A=n109
+ ZN=n108 VDD=VDD VSS=VSS
XHFSINV_133_440 inv0d1 $PINS I=HFSNET_23 ZN=HFSNET_18 VDD=VDD VSS=VSS
XHFSINV_278_441 inv0d1 $PINS I=HFSNET_23 ZN=HFSNET_19 VDD=VDD VSS=VSS
XHFSINV_360_442 inv0d1 $PINS I=HFSNET_23 ZN=HFSNET_20 VDD=VDD VSS=VSS
XHFSINV_486_443 inv0d2 $PINS I=HFSNET_23 ZN=HFSNET_21 VDD=VDD VSS=VSS
XHFSINV_762_444 inv0d1 $PINS I=HFSNET_23 ZN=HFSNET_22 VDD=VDD VSS=VSS
XHFSINV_150_451 inv0d2 $PINS I=HFSNET_33 ZN=HFSNET_29 VDD=VDD VSS=VSS
XHFSINV_598_452 inv0d2 $PINS I=HFSNET_33 ZN=HFSNET_30 VDD=VDD VSS=VSS
XHFSINV_430_453 inv0d1 $PINS I=HFSNET_33 ZN=HFSNET_31 VDD=VDD VSS=VSS
XHFSINV_326_454 inv0d2 $PINS I=HFSNET_33 ZN=HFSNET_32 VDD=VDD VSS=VSS
XctmTdsLR_2_1384 oaim22d1 $PINS A1=beat_idx[3] A2=copt_net_2728 B1=beat_idx[3]
+ B2=n852 ZN=n856 VDD=VDD VSS=VSS
XctmTdsLR_2_1316 aoi21d1 $PINS B1=n698 B2=n699 A=gre_a_INV_2111_3
+ ZN=a_load_row[25] VDD=VDD VSS=VSS
XctmTdsLR_1_2889 aoi21d1 $PINS B1=n684 B2=n685 A=gre_a_INV_3758_3
+ ZN=a_load_row[18] VDD=VDD VSS=VSS
XctmTdsLR_2_1267 aoim22d1 $PINS A1=tmp_net107 A2=copt_net_2728 B1=tmp_net107
+ B2=copt_net_2728 Z=tmp_net108 VDD=VDD VSS=VSS
XctmTdsLR_2_1318 aoi21d1 $PINS B1=n690 B2=n691 A=gre_a_INV_150_3
+ ZN=a_load_row[21] VDD=VDD VSS=VSS
XctmTdsLR_2_1291 aoim22d1 $PINS A1=tmp_net103 A2=copt_net_2696 B1=tmp_net103
+ B2=copt_net_2696 Z=tmp_net114 VDD=VDD VSS=VSS
XHFSINV_9769_438 invbd2 $PINS I=n904 ZN=HFSNET_16 VDD=VDD VSS=VSS
XctmTdsLR_3_1292 aoim22d1 $PINS A1=beat_idx[0] A2=total_beats[0] B1=beat_idx[0]
+ B2=total_beats[0] Z=tmp_net115 VDD=VDD VSS=VSS
XctmTdsLR_1_1385 nd02d1 $PINS A1=n854 A2=beat_idx[3] ZN=tmp_net128 VDD=VDD
+ VSS=VSS
XHFSBUF_484_448 buffd1 $PINS I=HFSNET_27 Z=HFSNET_26 VDD=VDD VSS=VSS
XHFSBUF_568_449 buffd1 $PINS I=n533 Z=HFSNET_27 VDD=VDD VSS=VSS
XHFSBUF_133_450 buffd1 $PINS I=n533 Z=HFSNET_28 VDD=VDD VSS=VSS
XHFSBUF_117_456 buffd3 $PINS I=n535 Z=HFSNET_34 VDD=VDD VSS=VSS
XHFSBUF_720_457 buffd3 $PINS I=n535 Z=HFSNET_35 VDD=VDD VSS=VSS
XHFSBUF_422_458 buffd1 $PINS I=n535 Z=HFSNET_36 VDD=VDD VSS=VSS
XHFSINV_9756_640 inv0d2 $PINS I=HFSNET_45 ZN=HFSNET_43 VDD=VDD VSS=VSS
XHFSINV_9607_641 inv0d2 $PINS I=HFSNET_45 ZN=HFSNET_44 VDD=VDD VSS=VSS
XctmTdsLR_4_1293 an03d1 $PINS A1=tmp_net113 A2=tmp_net114 A3=tmp_net115 Z=n840
+ VDD=VDD VSS=VSS
XctmTdsLR_2_1295 aoi21d1 $PINS B1=n706 B2=n707 A=gre_a_INV_364_3
+ ZN=a_load_row[29] VDD=VDD VSS=VSS
XctmTdsLR_2_1297 aoi21d1 $PINS B1=n694 B2=n695 A=gre_a_INV_772_3
+ ZN=a_load_row[23] VDD=VDD VSS=VSS
XU434 nd02d1 $PINS A1=n905 A2=HFSNET_15 ZN=n142 VDD=VDD VSS=VSS
XctmTdsLR_1_1298 oaim21d1 $PINS B1=n743 B2=n742 A=n108 ZN=w_load_row[9] VDD=VDD
+ VSS=VSS
XctmTdsLR_1_1299 oaim21d1 $PINS B1=n747 B2=n746 A=n108 ZN=w_load_row[11]
+ VDD=VDD VSS=VSS
XU439 buffd1 $PINS I=n788 Z=n797 VDD=VDD VSS=VSS
XctmTdsLR_2_1320 aoi21d1 $PINS B1=n674 B2=n675 A=gre_a_INV_1704_3
+ ZN=a_load_row[13] VDD=VDD VSS=VSS
XctmTdsLR_1_1321 aoi22d2 $PINS A1=N_uc_356 A2=HFSNET_16 B1=N_uc_388 B2=n904
+ ZN=dma_addr[31] VDD=VDD VSS=VSS
XctmTdsLR_1_1322 oaim21d1 $PINS B1=n744 B2=n745 A=n108 ZN=w_load_row[10]
+ VDD=VDD VSS=VSS
XctmTdsLR_1_1323 oaim21d1 $PINS B1=n750 B2=n751 A=n108 ZN=w_load_row[13]
+ VDD=VDD VSS=VSS
XctmTdsLR_2_1386 oai31d1 $PINS B1=n855 B2=n848 B3=beat_idx[3] A=tmp_net128
+ ZN=n292 VDD=VDD VSS=VSS
XctmTdsLR_1_1387 nd02d1 $PINS A1=n846 A2=copt_net_2696 ZN=tmp_net129 VDD=VDD
+ VSS=VSS
XctmTdsLR_2_1388 oai31d1 $PINS B1=n855 B2=n878 B3=copt_net_2696 A=tmp_net129
+ ZN=n294 VDD=VDD VSS=VSS
XctmTdsLR_1_1389 aoim22d1 $PINS A1=n875 A2=n874 B1=n875 B2=copt_net_2666 Z=n160
+ VDD=VDD VSS=VSS
XctmTdsLR_2_2886 aoim22d1 $PINS A1=mult_117_n5 A2=n891 B1=mult_117_n5 B2=n891
+ Z=tmp_net183 VDD=VDD VSS=VSS
XctmTdsLR_3_2887 nd02d1 $PINS A1=mult_117_n2 A2=tmp_net183 ZN=tmp_net184
+ VDD=VDD VSS=VSS
XctmTdsLR_2_3001 nr04d1 $PINS A1=n868 A2=n871 A3=n870 A4=n869 ZN=tmp_net189
+ VDD=VDD VSS=VSS
Xcopt_h_inst_3024 dl02d1 $PINS I=dma_rdata[3] Z=copt_net_194 VDD=VDD VSS=VSS
Xcopt_h_inst_3025 dl02d1 $PINS I=dma_rdata[2] Z=copt_net_195 VDD=VDD VSS=VSS
Xcopt_h_inst_3026 dl02d1 $PINS I=dma_rdata[0] Z=copt_net_196 VDD=VDD VSS=VSS
Xcopt_h_inst_3027 dl02d1 $PINS I=dma_rdata[19] Z=copt_net_197 VDD=VDD VSS=VSS
Xcopt_h_inst_3028 dl02d1 $PINS I=dma_rdata[11] Z=copt_net_198 VDD=VDD VSS=VSS
Xcopt_h_inst_3029 dl02d1 $PINS I=dma_rdata[29] Z=copt_net_199 VDD=VDD VSS=VSS
Xcopt_h_inst_3030 dl02d1 $PINS I=dma_rdata[27] Z=copt_net_200 VDD=VDD VSS=VSS
XU463 nd12d1 $PINS A1=n857 A2=HFSNET_15 ZN=n869 VDD=VDD VSS=VSS
XU464 inv0d0 $PINS I=n888 ZN=n905 VDD=VDD VSS=VSS
XU465 nd02d1 $PINS A1=n905 A2=n61 ZN=n140 VDD=VDD VSS=VSS
XU466 buffd1 $PINS I=n712 Z=n720 VDD=VDD VSS=VSS
Xcopt_h_inst_3031 dl02d1 $PINS I=dma_rdata[25] Z=copt_net_201 VDD=VDD VSS=VSS
Xcopt_h_inst_3032 dl02d1 $PINS I=dma_rdata[5] Z=copt_net_202 VDD=VDD VSS=VSS
XU470 inv0d0 $PINS I=n44 ZN=n792 VDD=VDD VSS=VSS
XU471 inv0d0 $PINS I=n861 ZN=n858 VDD=VDD VSS=VSS
Xcopt_h_inst_3033 dl02d1 $PINS I=dma_rdata[8] Z=copt_net_203 VDD=VDD VSS=VSS
Xcopt_h_inst_3034 dl02d1 $PINS I=dma_rdata[16] Z=copt_net_204 VDD=VDD VSS=VSS
Xcopt_h_inst_3036 dl02d1 $PINS I=dma_rdata[24] Z=copt_net_206 VDD=VDD VSS=VSS
Xcopt_h_inst_3037 dl02d1 $PINS I=dma_rdata[7] Z=copt_net_207 VDD=VDD VSS=VSS
Xcopt_h_inst_3038 dl02d1 $PINS I=dma_rdata[23] Z=copt_net_208 VDD=VDD VSS=VSS
Xcopt_h_inst_3039 dl02d1 $PINS I=dma_rdata[13] Z=copt_net_209 VDD=VDD VSS=VSS
Xcopt_h_inst_3040 dl02d1 $PINS I=dma_rdata[20] Z=copt_net_210 VDD=VDD VSS=VSS
Xcopt_h_inst_3041 dl02d1 $PINS I=dma_rdata[31] Z=copt_net_211 VDD=VDD VSS=VSS
Xcopt_h_inst_3042 dl02d1 $PINS I=dma_rdata[6] Z=copt_net_212 VDD=VDD VSS=VSS
Xcopt_h_inst_3043 dl02d1 $PINS I=dma_rdata[10] Z=copt_net_213 VDD=VDD VSS=VSS
Xcopt_h_inst_3044 dl02d1 $PINS I=dma_rdata[14] Z=copt_net_214 VDD=VDD VSS=VSS
Xcopt_h_inst_3045 dl02d1 $PINS I=dma_rdata[18] Z=copt_net_215 VDD=VDD VSS=VSS
Xcopt_h_inst_3047 dl02d1 $PINS I=dma_rdata[17] Z=copt_net_217 VDD=VDD VSS=VSS
Xcopt_h_inst_3048 dl02d1 $PINS I=dma_rdata[15] Z=copt_net_218 VDD=VDD VSS=VSS
XU486 inv0d0 $PINS I=dma_valid ZN=n901 VDD=VDD VSS=VSS
XU487 oan211d1 $PINS C1=n902 C2=n142 B=n145 A=n898 ZN=n342 VDD=VDD VSS=VSS
XU488 inv0d0 $PINS I=n138 ZN=n898 VDD=VDD VSS=VSS
XU489 nr03d1 $PINS A1=n110 A2=n910 A3=n106 ZN=a_load_start VDD=VDD VSS=VSS
Xcopt_h_inst_3049 dl02d1 $PINS I=dma_rdata[4] Z=copt_net_219 VDD=VDD VSS=VSS
Xcopt_h_inst_3050 dl02d1 $PINS I=dma_rdata[28] Z=copt_net_220 VDD=VDD VSS=VSS
XU492 nd02d0 $PINS A1=job_start A2=n143 ZN=n119 VDD=VDD VSS=VSS
Xcopt_h_inst_3051 dl02d1 $PINS I=dma_rdata[12] Z=copt_net_221 VDD=VDD VSS=VSS
XU496 an03d2 $PINS A1=n61 A2=n878 A3=n877 Z=n60 VDD=VDD VSS=VSS
XU497 an02d0 $PINS A1=n904 A2=copt_net_2732 Z=n61 VDD=VDD VSS=VSS
Xcopt_h_inst_3052 dl02d1 $PINS I=dma_rdata[22] Z=copt_net_222 VDD=VDD VSS=VSS
Xcopt_h_inst_3053 dl02d1 $PINS I=dma_rdata[30] Z=copt_net_223 VDD=VDD VSS=VSS
Xcopt_h_inst_3435 dl02d1 $PINS I=n323 Z=copt_net_605 VDD=VDD VSS=VSS
Xcopt_h_inst_3442 dl02d1 $PINS I=job_k[2] Z=copt_net_612 VDD=VDD VSS=VSS
XU502 an02d2 $PINS A1=n61 A2=n67 Z=n62 VDD=VDD VSS=VSS
XU505 inv0d0 $PINS I=copt_net_2732 ZN=n902 VDD=VDD VSS=VSS
XU506 inv0d0 $PINS I=n848 ZN=n851 VDD=VDD VSS=VSS
Xcopt_h_inst_3448 dl02d1 $PINS I=n159 Z=copt_net_618 VDD=VDD VSS=VSS
Xcopt_h_inst_3581 dl02d1 $PINS I=stage[36] Z=copt_net_750 VDD=VDD VSS=VSS
Xcopt_h_inst_3582 dl02d1 $PINS I=n292 Z=copt_net_751 VDD=VDD VSS=VSS
XU510 xn02d1 $PINS A1=copt_net_2083 A2=n884 ZN=N_uc_299 VDD=VDD VSS=VSS
XU511 inv0d0 $PINS I=copt_net_2587 ZN=n885 VDD=VDD VSS=VSS
XU512 inv0d1 $PINS I=copt_net_2666 ZN=n887 VDD=VDD VSS=VSS
XU513 inv0d0 $PINS I=copt_net_2083 ZN=n883 VDD=VDD VSS=VSS
XU514 inv0d0 $PINS I=copt_net_2688 ZN=n638 VDD=VDD VSS=VSS
XU515 inv0d0 $PINS I=copt_net_2705 ZN=n639 VDD=VDD VSS=VSS
XU516 inv0d0 $PINS I=copt_net_2408 ZN=n836 VDD=VDD VSS=VSS
XU517 inv0d0 $PINS I=state[0] ZN=n909 VDD=VDD VSS=VSS
XU518 aoi31d2 $PINS B1=state[0] B2=n903 B3=dma_ready A=n147 ZN=n146 VDD=VDD
+ VSS=VSS
XU519 nr03d1 $PINS A1=n145 A2=copt_net_2762 A3=copt_net_2409 ZN=n147 VDD=VDD
+ VSS=VSS
XU520 mx02d0 $PINS I0=copt_net_940 I1=copt_net_196 S=n62 Z=n291 VDD=VDD VSS=VSS
XU521 mx02d0 $PINS I0=copt_net_824 I1=copt_net_193 S=n62 Z=n290 VDD=VDD VSS=VSS
XU522 mx02d0 $PINS I0=copt_net_858 I1=copt_net_195 S=n62 Z=n289 VDD=VDD VSS=VSS
XU523 mx02d0 $PINS I0=copt_net_822 I1=copt_net_194 S=n62 Z=n288 VDD=VDD VSS=VSS
XU524 mx02d0 $PINS I0=copt_net_1019 I1=copt_net_219 S=n62 Z=n287 VDD=VDD
+ VSS=VSS
XU525 mx02d0 $PINS I0=copt_net_810 I1=copt_net_202 S=n62 Z=n286 VDD=VDD VSS=VSS
XU526 mx02d0 $PINS I0=copt_net_850 I1=copt_net_212 S=n62 Z=n285 VDD=VDD VSS=VSS
XU527 mx02d0 $PINS I0=copt_net_852 I1=copt_net_207 S=n62 Z=n284 VDD=VDD VSS=VSS
XU528 mx02d0 $PINS I0=copt_net_843 I1=copt_net_203 S=n62 Z=n283 VDD=VDD VSS=VSS
XU529 mx02d0 $PINS I0=copt_net_795 I1=dma_rdata[9] S=n62 Z=n282 VDD=VDD VSS=VSS
XU530 mx02d0 $PINS I0=copt_net_959 I1=copt_net_213 S=n62 Z=n281 VDD=VDD VSS=VSS
XU531 mx02d0 $PINS I0=copt_net_1032 I1=copt_net_198 S=n62 Z=n280 VDD=VDD
+ VSS=VSS
XU532 mx02d0 $PINS I0=copt_net_977 I1=copt_net_221 S=n62 Z=n279 VDD=VDD VSS=VSS
XU533 mx02d0 $PINS I0=copt_net_811 I1=copt_net_209 S=n62 Z=n278 VDD=VDD VSS=VSS
XU534 mx02d0 $PINS I0=copt_net_988 I1=copt_net_214 S=n62 Z=n277 VDD=VDD VSS=VSS
XU535 mx02d0 $PINS I0=copt_net_863 I1=copt_net_218 S=n62 Z=n276 VDD=VDD VSS=VSS
XU536 mx02d0 $PINS I0=copt_net_908 I1=copt_net_204 S=n62 Z=n275 VDD=VDD VSS=VSS
XU537 mx02d0 $PINS I0=copt_net_846 I1=copt_net_217 S=n62 Z=n274 VDD=VDD VSS=VSS
XU538 mx02d0 $PINS I0=copt_net_984 I1=copt_net_215 S=n62 Z=n273 VDD=VDD VSS=VSS
XU539 mx02d0 $PINS I0=copt_net_918 I1=copt_net_197 S=n62 Z=n272 VDD=VDD VSS=VSS
XU540 mx02d0 $PINS I0=copt_net_931 I1=copt_net_210 S=n62 Z=n271 VDD=VDD VSS=VSS
XU541 mx02d0 $PINS I0=copt_net_854 I1=copt_net_192 S=n62 Z=n270 VDD=VDD VSS=VSS
XU542 mx02d0 $PINS I0=copt_net_1012 I1=copt_net_222 S=n62 Z=n269 VDD=VDD
+ VSS=VSS
XU543 mx02d0 $PINS I0=copt_net_909 I1=copt_net_208 S=n62 Z=n268 VDD=VDD VSS=VSS
XU544 mx02d0 $PINS I0=copt_net_922 I1=copt_net_206 S=n62 Z=n267 VDD=VDD VSS=VSS
XU545 mx02d0 $PINS I0=copt_net_924 I1=copt_net_201 S=n62 Z=n266 VDD=VDD VSS=VSS
XU546 mx02d0 $PINS I0=copt_net_826 I1=dma_rdata[26] S=n62 Z=n265 VDD=VDD
+ VSS=VSS
XU547 mx02d0 $PINS I0=copt_net_883 I1=copt_net_196 S=n64 Z=n259 VDD=VDD VSS=VSS
XU548 mx02d0 $PINS I0=copt_net_938 I1=copt_net_193 S=n64 Z=n258 VDD=VDD VSS=VSS
XU549 mx02d0 $PINS I0=copt_net_900 I1=copt_net_195 S=n64 Z=n257 VDD=VDD VSS=VSS
XU550 mx02d0 $PINS I0=copt_net_839 I1=copt_net_194 S=n64 Z=n256 VDD=VDD VSS=VSS
XU551 mx02d0 $PINS I0=copt_net_750 I1=copt_net_219 S=n64 Z=n255 VDD=VDD VSS=VSS
XU552 mx02d0 $PINS I0=copt_net_968 I1=copt_net_202 S=n64 Z=n254 VDD=VDD VSS=VSS
XU553 mx02d0 $PINS I0=copt_net_906 I1=copt_net_212 S=n64 Z=n253 VDD=VDD VSS=VSS
XU554 mx02d0 $PINS I0=copt_net_965 I1=copt_net_207 S=n64 Z=n252 VDD=VDD VSS=VSS
XU555 mx02d0 $PINS I0=copt_net_862 I1=copt_net_203 S=n64 Z=n251 VDD=VDD VSS=VSS
XU556 mx02d0 $PINS I0=copt_net_1113 I1=dma_rdata[9] S=n64 Z=n250 VDD=VDD
+ VSS=VSS
XU557 mx02d0 $PINS I0=copt_net_868 I1=copt_net_213 S=n64 Z=n249 VDD=VDD VSS=VSS
XU558 mx02d0 $PINS I0=copt_net_1072 I1=copt_net_198 S=n64 Z=n248 VDD=VDD
+ VSS=VSS
XU559 mx02d0 $PINS I0=copt_net_871 I1=copt_net_221 S=n64 Z=n247 VDD=VDD VSS=VSS
XU560 mx02d0 $PINS I0=copt_net_896 I1=copt_net_209 S=n64 Z=n246 VDD=VDD VSS=VSS
XU561 mx02d0 $PINS I0=copt_net_958 I1=copt_net_214 S=n64 Z=n245 VDD=VDD VSS=VSS
XU562 mx02d0 $PINS I0=copt_net_898 I1=copt_net_218 S=n64 Z=n244 VDD=VDD VSS=VSS
XU563 mx02d0 $PINS I0=copt_net_904 I1=copt_net_204 S=n64 Z=n243 VDD=VDD VSS=VSS
XU564 mx02d0 $PINS I0=copt_net_893 I1=copt_net_217 S=n64 Z=n242 VDD=VDD VSS=VSS
XU565 mx02d0 $PINS I0=copt_net_953 I1=copt_net_215 S=n64 Z=n241 VDD=VDD VSS=VSS
XU566 mx02d0 $PINS I0=copt_net_897 I1=copt_net_197 S=n64 Z=n240 VDD=VDD VSS=VSS
XU567 mx02d0 $PINS I0=copt_net_993 I1=copt_net_210 S=n64 Z=n239 VDD=VDD VSS=VSS
XU568 mx02d0 $PINS I0=copt_net_834 I1=copt_net_192 S=n64 Z=n238 VDD=VDD VSS=VSS
XU569 mx02d0 $PINS I0=copt_net_1003 I1=copt_net_222 S=n64 Z=n237 VDD=VDD
+ VSS=VSS
XU570 mx02d0 $PINS I0=copt_net_1209 I1=copt_net_208 S=n64 Z=n236 VDD=VDD
+ VSS=VSS
XU571 mx02d0 $PINS I0=copt_net_999 I1=copt_net_206 S=n64 Z=n235 VDD=VDD VSS=VSS
XU572 mx02d0 $PINS I0=copt_net_841 I1=copt_net_201 S=n64 Z=n234 VDD=VDD VSS=VSS
XU573 mx02d0 $PINS I0=copt_net_890 I1=dma_rdata[26] S=n64 Z=n233 VDD=VDD
+ VSS=VSS
XU574 mx02d0 $PINS I0=copt_net_913 I1=copt_net_196 S=n65 Z=n227 VDD=VDD VSS=VSS
XU575 mx02d0 $PINS I0=copt_net_882 I1=copt_net_193 S=n65 Z=n226 VDD=VDD VSS=VSS
XU576 mx02d0 $PINS I0=copt_net_849 I1=copt_net_195 S=n65 Z=n225 VDD=VDD VSS=VSS
XU577 mx02d0 $PINS I0=copt_net_814 I1=copt_net_194 S=n65 Z=n224 VDD=VDD VSS=VSS
XU578 mx02d0 $PINS I0=copt_net_914 I1=copt_net_219 S=n65 Z=n223 VDD=VDD VSS=VSS
XU579 mx02d0 $PINS I0=copt_net_816 I1=copt_net_202 S=n65 Z=n222 VDD=VDD VSS=VSS
XU580 mx02d0 $PINS I0=copt_net_840 I1=copt_net_212 S=n65 Z=n221 VDD=VDD VSS=VSS
XU581 mx02d0 $PINS I0=copt_net_792 I1=copt_net_207 S=n65 Z=n220 VDD=VDD VSS=VSS
XU582 mx02d0 $PINS I0=copt_net_912 I1=copt_net_203 S=n65 Z=n219 VDD=VDD VSS=VSS
XU583 mx02d0 $PINS I0=copt_net_960 I1=dma_rdata[9] S=n65 Z=n218 VDD=VDD VSS=VSS
XU584 mx02d0 $PINS I0=copt_net_937 I1=copt_net_213 S=n65 Z=n217 VDD=VDD VSS=VSS
XU585 mx02d0 $PINS I0=copt_net_995 I1=copt_net_198 S=n65 Z=n216 VDD=VDD VSS=VSS
XU586 mx02d0 $PINS I0=copt_net_889 I1=copt_net_221 S=n65 Z=n215 VDD=VDD VSS=VSS
XU587 mx02d0 $PINS I0=copt_net_943 I1=copt_net_209 S=n65 Z=n214 VDD=VDD VSS=VSS
XU588 mx02d0 $PINS I0=copt_net_903 I1=copt_net_214 S=n65 Z=n213 VDD=VDD VSS=VSS
XU589 mx02d0 $PINS I0=copt_net_967 I1=copt_net_218 S=n65 Z=n212 VDD=VDD VSS=VSS
XU590 mx02d0 $PINS I0=copt_net_917 I1=copt_net_204 S=n65 Z=n211 VDD=VDD VSS=VSS
XU591 mx02d0 $PINS I0=copt_net_829 I1=copt_net_217 S=n65 Z=n210 VDD=VDD VSS=VSS
XU592 mx02d0 $PINS I0=copt_net_961 I1=copt_net_215 S=n65 Z=n209 VDD=VDD VSS=VSS
XU593 mx02d0 $PINS I0=copt_net_837 I1=copt_net_197 S=n65 Z=n208 VDD=VDD VSS=VSS
XU594 mx02d0 $PINS I0=copt_net_963 I1=copt_net_210 S=n65 Z=n207 VDD=VDD VSS=VSS
XU595 mx02d0 $PINS I0=copt_net_929 I1=copt_net_192 S=n65 Z=n206 VDD=VDD VSS=VSS
XU596 mx02d0 $PINS I0=copt_net_1029 I1=copt_net_222 S=n65 Z=n205 VDD=VDD
+ VSS=VSS
XU597 mx02d0 $PINS I0=copt_net_1013 I1=copt_net_208 S=n65 Z=n204 VDD=VDD
+ VSS=VSS
XU598 mx02d0 $PINS I0=copt_net_892 I1=copt_net_206 S=n65 Z=n203 VDD=VDD VSS=VSS
XU599 mx02d0 $PINS I0=copt_net_933 I1=copt_net_201 S=n65 Z=n202 VDD=VDD VSS=VSS
XU600 mx02d0 $PINS I0=copt_net_865 I1=dma_rdata[26] S=n65 Z=n201 VDD=VDD
+ VSS=VSS
XU601 mx02d0 $PINS I0=copt_net_861 I1=copt_net_196 S=n60 Z=n195 VDD=VDD VSS=VSS
XU602 mx02d0 $PINS I0=copt_net_820 I1=copt_net_193 S=n60 Z=n194 VDD=VDD VSS=VSS
XU603 mx02d0 $PINS I0=copt_net_828 I1=copt_net_195 S=n60 Z=n193 VDD=VDD VSS=VSS
XU604 mx02d0 $PINS I0=copt_net_832 I1=copt_net_194 S=n60 Z=n192 VDD=VDD VSS=VSS
XU605 mx02d0 $PINS I0=copt_net_1025 I1=copt_net_219 S=n60 Z=n191 VDD=VDD
+ VSS=VSS
XU606 mx02d0 $PINS I0=copt_net_1031 I1=copt_net_202 S=n60 Z=n190 VDD=VDD
+ VSS=VSS
XU607 mx02d0 $PINS I0=copt_net_804 I1=copt_net_212 S=n60 Z=n189 VDD=VDD VSS=VSS
XU608 mx02d0 $PINS I0=copt_net_910 I1=copt_net_207 S=n60 Z=n188 VDD=VDD VSS=VSS
XU609 mx02d0 $PINS I0=copt_net_1068 I1=copt_net_203 S=n60 Z=n187 VDD=VDD
+ VSS=VSS
XU610 mx02d0 $PINS I0=copt_net_864 I1=dma_rdata[9] S=n60 Z=n186 VDD=VDD VSS=VSS
XU611 mx02d0 $PINS I0=copt_net_980 I1=copt_net_213 S=n60 Z=n185 VDD=VDD VSS=VSS
XU612 mx02d0 $PINS I0=copt_net_976 I1=copt_net_198 S=n60 Z=n184 VDD=VDD VSS=VSS
XU613 mx02d0 $PINS I0=copt_net_950 I1=copt_net_221 S=n60 Z=n183 VDD=VDD VSS=VSS
XU614 mx02d0 $PINS I0=copt_net_899 I1=copt_net_209 S=n60 Z=n182 VDD=VDD VSS=VSS
XU615 mx02d0 $PINS I0=copt_net_982 I1=copt_net_214 S=n60 Z=n181 VDD=VDD VSS=VSS
XU616 mx02d0 $PINS I0=copt_net_920 I1=copt_net_218 S=n60 Z=n180 VDD=VDD VSS=VSS
XU617 mx02d0 $PINS I0=copt_net_952 I1=copt_net_204 S=n60 Z=n179 VDD=VDD VSS=VSS
XU618 mx02d0 $PINS I0=copt_net_928 I1=copt_net_217 S=n60 Z=n178 VDD=VDD VSS=VSS
XU619 mx02d0 $PINS I0=copt_net_981 I1=copt_net_215 S=n60 Z=n177 VDD=VDD VSS=VSS
XU620 mx02d0 $PINS I0=copt_net_838 I1=copt_net_197 S=n60 Z=n176 VDD=VDD VSS=VSS
XU621 mx02d0 $PINS I0=copt_net_939 I1=copt_net_210 S=n60 Z=n175 VDD=VDD VSS=VSS
XU622 mx02d0 $PINS I0=copt_net_831 I1=copt_net_192 S=n60 Z=n174 VDD=VDD VSS=VSS
XU623 mx02d0 $PINS I0=copt_net_1002 I1=copt_net_222 S=n60 Z=n173 VDD=VDD
+ VSS=VSS
XU624 mx02d0 $PINS I0=copt_net_948 I1=copt_net_208 S=n60 Z=n172 VDD=VDD VSS=VSS
XU625 mx02d0 $PINS I0=copt_net_1027 I1=copt_net_206 S=n60 Z=n171 VDD=VDD
+ VSS=VSS
XU626 mx02d0 $PINS I0=copt_net_934 I1=copt_net_201 S=n60 Z=n170 VDD=VDD VSS=VSS
XU627 mx02d0 $PINS I0=copt_net_1038 I1=dma_rdata[26] S=n60 Z=n169 VDD=VDD
+ VSS=VSS
XU628 mx02d0 $PINS I0=copt_net_805 I1=copt_net_200 S=n62 Z=n264 VDD=VDD VSS=VSS
XU629 mx02d0 $PINS I0=copt_net_925 I1=copt_net_220 S=n62 Z=n263 VDD=VDD VSS=VSS
XU630 mx02d0 $PINS I0=copt_net_823 I1=copt_net_199 S=n62 Z=n262 VDD=VDD VSS=VSS
XU631 mx02d0 $PINS I0=copt_net_1015 I1=copt_net_223 S=n62 Z=n261 VDD=VDD
+ VSS=VSS
XU632 mx02d0 $PINS I0=copt_net_926 I1=copt_net_211 S=n62 Z=n260 VDD=VDD VSS=VSS
XU633 mx02d0 $PINS I0=copt_net_830 I1=copt_net_200 S=n64 Z=n232 VDD=VDD VSS=VSS
XU634 mx02d0 $PINS I0=copt_net_997 I1=copt_net_220 S=n64 Z=n231 VDD=VDD VSS=VSS
XU635 mx02d0 $PINS I0=copt_net_847 I1=copt_net_199 S=n64 Z=n230 VDD=VDD VSS=VSS
XU636 mx02d0 $PINS I0=copt_net_978 I1=copt_net_223 S=n64 Z=n229 VDD=VDD VSS=VSS
XU637 mx02d0 $PINS I0=copt_net_1255 I1=copt_net_211 S=n64 Z=n228 VDD=VDD
+ VSS=VSS
XU638 mx02d0 $PINS I0=copt_net_879 I1=copt_net_200 S=n65 Z=n200 VDD=VDD VSS=VSS
XU639 mx02d0 $PINS I0=copt_net_973 I1=copt_net_220 S=n65 Z=n199 VDD=VDD VSS=VSS
XU640 mx02d0 $PINS I0=copt_net_869 I1=copt_net_199 S=n65 Z=n198 VDD=VDD VSS=VSS
XU641 mx02d0 $PINS I0=copt_net_986 I1=copt_net_223 S=n65 Z=n197 VDD=VDD VSS=VSS
XU642 mx02d0 $PINS I0=copt_net_936 I1=copt_net_211 S=n65 Z=n196 VDD=VDD VSS=VSS
XU643 mx02d0 $PINS I0=copt_net_873 I1=copt_net_200 S=n60 Z=n168 VDD=VDD VSS=VSS
XU644 mx02d0 $PINS I0=copt_net_966 I1=copt_net_220 S=n60 Z=n167 VDD=VDD VSS=VSS
XU645 mx02d0 $PINS I0=copt_net_874 I1=copt_net_199 S=n60 Z=n166 VDD=VDD VSS=VSS
XU646 mx02d0 $PINS I0=copt_net_992 I1=copt_net_223 S=n60 Z=n165 VDD=VDD VSS=VSS
XU647 mx02d0 $PINS I0=copt_net_891 I1=copt_net_211 S=n60 Z=n164 VDD=VDD VSS=VSS
XU648 inv0d0 $PINS I=N_uc_33 ZN=n907 VDD=VDD VSS=VSS
Xcopt_h_inst_3624 dl02d1 $PINS I=stage[71] Z=copt_net_792 VDD=VDD VSS=VSS
Xcopt_h_inst_3627 dl02d1 $PINS I=stage[9] Z=copt_net_795 VDD=VDD VSS=VSS
Xcopt_h_inst_3636 dl02d1 $PINS I=stage[102] Z=copt_net_804 VDD=VDD VSS=VSS
Xcopt_h_inst_3637 dl02d1 $PINS I=stage[27] Z=copt_net_805 VDD=VDD VSS=VSS
Xcopt_h_inst_3642 dl02d1 $PINS I=stage[5] Z=copt_net_810 VDD=VDD VSS=VSS
Xcopt_h_inst_3643 dl02d1 $PINS I=stage[13] Z=copt_net_811 VDD=VDD VSS=VSS
Xcopt_h_inst_3646 dl02d1 $PINS I=stage[67] Z=copt_net_814 VDD=VDD VSS=VSS
XU656 inv0d0 $PINS I=n43 ZN=a_load_m[0] VDD=VDD VSS=VSS
XU657 inv0d0 $PINS I=copt_net_2409 ZN=n899 VDD=VDD VSS=VSS
XU658 inv0d0 $PINS I=w_load_n[0] ZN=n894 VDD=VDD VSS=VSS
XU659 inv0d0 $PINS I=total_beats[2] ZN=n890 VDD=VDD VSS=VSS
XU660 inv0d0 $PINS I=N_uc_34 ZN=n906 VDD=VDD VSS=VSS
XU661 inv0d0 $PINS I=w_load_n[1] ZN=n893 VDD=VDD VSS=VSS
XU662 nd03d0 $PINS A1=state[0] A2=n900 A3=state[1] ZN=n145 VDD=VDD VSS=VSS
XU663 inv0d0 $PINS I=state[2] ZN=n900 VDD=VDD VSS=VSS
Xcopt_h_inst_3648 dl02d1 $PINS I=stage[69] Z=copt_net_816 VDD=VDD VSS=VSS
Xcopt_h_inst_3652 dl02d1 $PINS I=stage[97] Z=copt_net_820 VDD=VDD VSS=VSS
XU666 inv0d1 $PINS I=copt_net_2762 ZN=n910 VDD=VDD VSS=VSS
XU667 mi02d0 $PINS I0=n855 I1=n849 S=beat_idx[0] ZN=n295 VDD=VDD VSS=VSS
Xcopt_h_inst_3653 buffd1 $PINS I=stage[97] Z=copt_net_821 VDD=VDD VSS=VSS
XU669 mx02d0 $PINS I0=n864 I1=n863 S=copt_net_2587 Z=n161 VDD=VDD VSS=VSS
Xcopt_h_inst_3654 dl02d1 $PINS I=stage[3] Z=copt_net_822 VDD=VDD VSS=VSS
Xcopt_h_inst_3655 dl02d1 $PINS I=stage[29] Z=copt_net_823 VDD=VDD VSS=VSS
Xcopt_h_inst_3656 dl02d1 $PINS I=stage[1] Z=copt_net_824 VDD=VDD VSS=VSS
Xcopt_h_inst_3658 dl02d1 $PINS I=stage[26] Z=copt_net_826 VDD=VDD VSS=VSS
XU674 nd02d1 $PINS A1=copt_net_2408 A2=n889 ZN=n107 VDD=VDD VSS=VSS
XU675 inv0d0 $PINS I=kind_lat[1] ZN=n889 VDD=VDD VSS=VSS
Xcopt_h_inst_3660 dl02d1 $PINS I=stage[98] Z=copt_net_828 VDD=VDD VSS=VSS
Xcopt_h_inst_3661 dl02d1 $PINS I=stage[81] Z=copt_net_829 VDD=VDD VSS=VSS
Xcopt_h_inst_3662 dl02d1 $PINS I=stage[59] Z=copt_net_830 VDD=VDD VSS=VSS
XU679 inv0d1 $PINS I=copt_net_2811 ZN=w_load_k[2] VDD=VDD VSS=VSS
XU680 inv0d0 $PINS I=n40 ZN=aps_rename_25_ VDD=VDD VSS=VSS
XU681 inv0d1 $PINS I=copt_net_2269 ZN=w_load_k[1] VDD=VDD VSS=VSS
XU682 mx02d1 $PINS I0=copt_net_1827 I1=job_base_addr[25] S=HFSNET_13 Z=n311
+ VDD=VDD VSS=VSS
XU683 mx02d1 $PINS I0=copt_net_1991 I1=job_base_addr[24] S=HFSNET_13 Z=n312
+ VDD=VDD VSS=VSS
XU684 mx02d0 $PINS I0=copt_net_1916 I1=copt_net_2828 S=HFSNET_13 Z=n313 VDD=VDD
+ VSS=VSS
XU685 mx02d1 $PINS I0=copt_net_1819 I1=job_base_addr[22] S=HFSNET_13 Z=n314
+ VDD=VDD VSS=VSS
XU686 mx02d0 $PINS I0=copt_net_1704 I1=job_base_addr[21] S=HFSNET_13 Z=n315
+ VDD=VDD VSS=VSS
XU687 mx02d1 $PINS I0=copt_net_1560 I1=copt_net_2905 S=HFSNET_12 Z=n316 VDD=VDD
+ VSS=VSS
XU688 mx02d1 $PINS I0=copt_net_1532 I1=copt_net_2617 S=HFSNET_13 Z=n317 VDD=VDD
+ VSS=VSS
XU689 mx02d1 $PINS I0=copt_net_1966 I1=job_base_addr[18] S=HFSNET_13 Z=n318
+ VDD=VDD VSS=VSS
XU690 mx02d1 $PINS I0=copt_net_1697 I1=job_base_addr[17] S=HFSNET_13 Z=n319
+ VDD=VDD VSS=VSS
XU691 mx02d1 $PINS I0=copt_net_1981 I1=copt_net_2766 S=HFSNET_13 Z=n320 VDD=VDD
+ VSS=VSS
XU692 mx02d0 $PINS I0=copt_net_1978 I1=job_base_addr[15] S=HFSNET_13 Z=n321
+ VDD=VDD VSS=VSS
XU693 mx02d1 $PINS I0=copt_net_2010 I1=job_base_addr[14] S=HFSNET_13 Z=n322
+ VDD=VDD VSS=VSS
XU694 mx02d1 $PINS I0=base_lat[13] I1=job_base_addr[13] S=HFSNET_13 Z=n323
+ VDD=VDD VSS=VSS
XU695 mx02d1 $PINS I0=copt_net_2025 I1=job_base_addr[12] S=HFSNET_13 Z=n324
+ VDD=VDD VSS=VSS
XU696 mx02d1 $PINS I0=copt_net_2089 I1=job_base_addr[11] S=HFSNET_13 Z=n325
+ VDD=VDD VSS=VSS
XU697 mx02d1 $PINS I0=copt_net_2037 I1=job_base_addr[10] S=HFSNET_13 Z=n326
+ VDD=VDD VSS=VSS
XU698 mx02d1 $PINS I0=copt_net_1839 I1=job_base_addr[9] S=HFSNET_13 Z=n327
+ VDD=VDD VSS=VSS
XU699 mx02d1 $PINS I0=copt_net_1890 I1=copt_net_2507 S=HFSNET_13 Z=n328 VDD=VDD
+ VSS=VSS
XU700 mx02d1 $PINS I0=copt_net_2552 I1=job_base_addr[7] S=HFSNET_13 Z=n329
+ VDD=VDD VSS=VSS
XU701 mx02d1 $PINS I0=copt_net_2537 I1=job_base_addr[6] S=HFSNET_13 Z=n330
+ VDD=VDD VSS=VSS
XU702 mx02d1 $PINS I0=copt_net_1892 I1=job_base_addr[5] S=HFSNET_13 Z=n331
+ VDD=VDD VSS=VSS
XU703 mx02d1 $PINS I0=copt_net_1744 I1=copt_net_2892 S=HFSNET_13 Z=n332 VDD=VDD
+ VSS=VSS
XU704 mx02d1 $PINS I0=copt_net_2185 I1=job_base_addr[3] S=HFSNET_13 Z=n333
+ VDD=VDD VSS=VSS
XU705 mx02d1 $PINS I0=copt_net_2196 I1=job_base_addr[2] S=HFSNET_12 Z=n334
+ VDD=VDD VSS=VSS
XU706 mx02d1 $PINS I0=copt_net_1705 I1=job_base_addr[1] S=HFSNET_13 Z=n335
+ VDD=VDD VSS=VSS
XU707 mx02d1 $PINS I0=copt_net_1737 I1=job_base_addr[0] S=HFSNET_13 Z=n336
+ VDD=VDD VSS=VSS
XU708 mx02d1 $PINS I0=copt_net_2423 I1=job_kind[1] S=HFSNET_12 Z=n337 VDD=VDD
+ VSS=VSS
XU709 mx02d1 $PINS I0=base_lat[31] I1=job_base_addr[31] S=HFSNET_13 Z=n305
+ VDD=VDD VSS=VSS
XU710 mx02d1 $PINS I0=copt_net_2616 I1=job_base_addr[30] S=HFSNET_13 Z=n306
+ VDD=VDD VSS=VSS
XU711 mx02d1 $PINS I0=copt_net_1923 I1=job_base_addr[29] S=HFSNET_13 Z=n307
+ VDD=VDD VSS=VSS
XU712 mx02d1 $PINS I0=copt_net_2188 I1=job_base_addr[28] S=HFSNET_13 Z=n308
+ VDD=VDD VSS=VSS
XU713 mx02d1 $PINS I0=copt_net_1847 I1=job_base_addr[27] S=HFSNET_13 Z=n309
+ VDD=VDD VSS=VSS
XU714 mx02d1 $PINS I0=copt_net_2002 I1=job_base_addr[26] S=HFSNET_13 Z=n310
+ VDD=VDD VSS=VSS
XU715 mx02d1 $PINS I0=copt_net_2408 I1=job_kind[0] S=HFSNET_13 Z=n338 VDD=VDD
+ VSS=VSS
Xcopt_h_inst_3663 dl02d1 $PINS I=stage[117] Z=copt_net_831 VDD=VDD VSS=VSS
Xcopt_h_inst_3664 dl02d1 $PINS I=stage[99] Z=copt_net_832 VDD=VDD VSS=VSS
XU718 inv0d0 $PINS I=state[1] ZN=n903 VDD=VDD VSS=VSS
Xcopt_h_inst_3666 dl02d1 $PINS I=stage[53] Z=copt_net_834 VDD=VDD VSS=VSS
XU720 nr03d1 $PINS A1=n900 A2=state[1] A3=state[0] ZN=job_done VDD=VDD VSS=VSS
XU721 nr03d0 $PINS A1=state[1] A2=state[2] A3=state[0] ZN=n143 VDD=VDD VSS=VSS
XU722 an03d2 $PINS A1=n61 A2=n878 A3=copt_net_2696 Z=n64 VDD=VDD VSS=VSS
XU723 an03d2 $PINS A1=n61 A2=n877 A3=beat_idx[0] Z=n65 VDD=VDD VSS=VSS
Xcopt_h_inst_3669 dl02d1 $PINS I=stage[83] Z=copt_net_837 VDD=VDD VSS=VSS
Xcopt_h_inst_3670 dl02d1 $PINS I=stage[115] Z=copt_net_838 VDD=VDD VSS=VSS
XU726 xn02d1 $PINS A1=w_load_n[0] A2=copt_net_2688 ZN=n868 VDD=VDD VSS=VSS
Xcopt_h_inst_3671 dl02d1 $PINS I=stage[35] Z=copt_net_839 VDD=VDD VSS=VSS
XU728 an02d1 $PINS A1=copt_net_2696 A2=beat_idx[0] Z=n67 VDD=VDD VSS=VSS
XU729 inv0d0 $PINS I=beat_idx[0] ZN=n878 VDD=VDD VSS=VSS
XU730 inv0d0 $PINS I=copt_net_2696 ZN=n877 VDD=VDD VSS=VSS
XU731 bufbd4 $PINS I=dma_wstrb[1] Z=dma_wstrb[0] VDD=VDD VSS=VSS
XU732 nr02d2 $PINS A1=n35 A2=copt_net_2666 ZN=n533 VDD=VDD VSS=VSS
XU733 aoi22d1 $PINS A1=c_src[256] A2=n533 B1=c_src[384] B2=HFSNET_22 ZN=n73
+ VDD=VDD VSS=VSS
Xcopt_h_inst_3672 dl02d1 $PINS I=stage[70] Z=copt_net_840 VDD=VDD VSS=VSS
XU735 aoi22d1 $PINS A1=c_src[0] A2=n535 B1=c_src[128] B2=HFSNET_32 ZN=n72
+ VDD=VDD VSS=VSS
XU736 aoi22d1 $PINS A1=c_src[257] A2=n533 B1=c_src[385] B2=HFSNET_22 ZN=n75
+ VDD=VDD VSS=VSS
XU737 aoi22d1 $PINS A1=c_src[1] A2=n535 B1=c_src[129] B2=HFSNET_29 ZN=n74
+ VDD=VDD VSS=VSS
XU738 aoi22d1 $PINS A1=c_src[258] A2=n533 B1=c_src[386] B2=HFSNET_22 ZN=n77
+ VDD=VDD VSS=VSS
XU739 aoi22d1 $PINS A1=c_src[2] A2=n535 B1=c_src[130] B2=HFSNET_32 ZN=n76
+ VDD=VDD VSS=VSS
XU740 aoi22d1 $PINS A1=c_src[259] A2=n533 B1=c_src[387] B2=HFSNET_22 ZN=n79
+ VDD=VDD VSS=VSS
XU741 aoi22d1 $PINS A1=c_src[3] A2=n535 B1=c_src[131] B2=HFSNET_32 ZN=n78
+ VDD=VDD VSS=VSS
XU742 aoi22d1 $PINS A1=c_src[260] A2=n533 B1=c_src[388] B2=HFSNET_22 ZN=n81
+ VDD=VDD VSS=VSS
XU743 aoi22d1 $PINS A1=c_src[4] A2=n535 B1=c_src[132] B2=HFSNET_32 ZN=n80
+ VDD=VDD VSS=VSS
XU744 aoi22d1 $PINS A1=c_src[261] A2=n533 B1=c_src[389] B2=HFSNET_22 ZN=n83
+ VDD=VDD VSS=VSS
XU745 aoi22d1 $PINS A1=c_src[5] A2=n535 B1=c_src[133] B2=HFSNET_32 ZN=n82
+ VDD=VDD VSS=VSS
XU746 aoi22d1 $PINS A1=c_src[262] A2=n533 B1=c_src[390] B2=HFSNET_22 ZN=n85
+ VDD=VDD VSS=VSS
XU747 aoi22d1 $PINS A1=c_src[6] A2=HFSNET_36 B1=c_src[134] B2=HFSNET_32 ZN=n84
+ VDD=VDD VSS=VSS
XU748 aoi22d1 $PINS A1=c_src[263] A2=n533 B1=c_src[391] B2=HFSNET_22 ZN=n87
+ VDD=VDD VSS=VSS
XU749 aoi22d1 $PINS A1=c_src[7] A2=HFSNET_36 B1=c_src[135] B2=HFSNET_32 ZN=n86
+ VDD=VDD VSS=VSS
XU750 aoi22d1 $PINS A1=c_src[264] A2=n533 B1=c_src[392] B2=HFSNET_22 ZN=n89
+ VDD=VDD VSS=VSS
XU751 aoi22d1 $PINS A1=c_src[8] A2=HFSNET_36 B1=c_src[136] B2=HFSNET_32 ZN=n88
+ VDD=VDD VSS=VSS
XU752 aoi22d1 $PINS A1=c_src[265] A2=HFSNET_28 B1=c_src[393] B2=HFSNET_18
+ ZN=n91 VDD=VDD VSS=VSS
XU753 aoi22d1 $PINS A1=c_src[9] A2=n535 B1=c_src[137] B2=HFSNET_32 ZN=n90
+ VDD=VDD VSS=VSS
XU754 aoi22d1 $PINS A1=c_src[266] A2=HFSNET_25 B1=c_src[394] B2=HFSNET_19
+ ZN=n93 VDD=VDD VSS=VSS
XU755 aoi22d1 $PINS A1=c_src[10] A2=HFSNET_36 B1=c_src[138] B2=HFSNET_32 ZN=n92
+ VDD=VDD VSS=VSS
XU756 aoi22d1 $PINS A1=c_src[267] A2=n533 B1=c_src[395] B2=HFSNET_22 ZN=n95
+ VDD=VDD VSS=VSS
XU757 aoi22d1 $PINS A1=c_src[11] A2=n535 B1=c_src[139] B2=HFSNET_32 ZN=n94
+ VDD=VDD VSS=VSS
XU758 aoi22d1 $PINS A1=c_src[268] A2=n533 B1=c_src[396] B2=HFSNET_22 ZN=n97
+ VDD=VDD VSS=VSS
XU759 aoi22d1 $PINS A1=c_src[12] A2=n535 B1=c_src[140] B2=HFSNET_32 ZN=n96
+ VDD=VDD VSS=VSS
XU760 aoi22d1 $PINS A1=c_src[269] A2=HFSNET_26 B1=c_src[397] B2=HFSNET_21
+ ZN=n99 VDD=VDD VSS=VSS
XU761 aoi22d1 $PINS A1=c_src[13] A2=HFSNET_36 B1=c_src[141] B2=HFSNET_32 ZN=n98
+ VDD=VDD VSS=VSS
XU762 aoi22d1 $PINS A1=c_src[270] A2=n533 B1=c_src[398] B2=HFSNET_22 ZN=n101
+ VDD=VDD VSS=VSS
XU763 aoi22d1 $PINS A1=c_src[14] A2=n535 B1=c_src[142] B2=HFSNET_32 ZN=n100
+ VDD=VDD VSS=VSS
XU764 aoi22d1 $PINS A1=c_src[271] A2=n533 B1=c_src[399] B2=HFSNET_22 ZN=n103
+ VDD=VDD VSS=VSS
XU765 aoi22d1 $PINS A1=c_src[15] A2=n535 B1=c_src[143] B2=HFSNET_32 ZN=n102
+ VDD=VDD VSS=VSS
XU766 aoi22d1 $PINS A1=c_src[272] A2=n533 B1=c_src[400] B2=HFSNET_22 ZN=n105
+ VDD=VDD VSS=VSS
XU767 aoi22d1 $PINS A1=c_src[16] A2=n535 B1=c_src[144] B2=HFSNET_32 ZN=n104
+ VDD=VDD VSS=VSS
XU768 aoi22d1 $PINS A1=c_src[273] A2=HFSNET_25 B1=c_src[401] B2=HFSNET_19
+ ZN=n112 VDD=VDD VSS=VSS
XU769 aoi22d1 $PINS A1=c_src[17] A2=n535 B1=c_src[145] B2=HFSNET_32 ZN=n111
+ VDD=VDD VSS=VSS
XU770 aoi22d1 $PINS A1=c_src[274] A2=HFSNET_28 B1=c_src[402] B2=HFSNET_18
+ ZN=n115 VDD=VDD VSS=VSS
XU771 aoi22d1 $PINS A1=c_src[18] A2=n535 B1=c_src[146] B2=HFSNET_32 ZN=n114
+ VDD=VDD VSS=VSS
XU772 aoi22d1 $PINS A1=c_src[275] A2=n533 B1=c_src[403] B2=HFSNET_22 ZN=n117
+ VDD=VDD VSS=VSS
XU773 aoi22d1 $PINS A1=c_src[19] A2=n535 B1=c_src[147] B2=HFSNET_32 ZN=n116
+ VDD=VDD VSS=VSS
XU774 aoi22d1 $PINS A1=c_src[276] A2=n533 B1=c_src[404] B2=HFSNET_22 ZN=n120
+ VDD=VDD VSS=VSS
XU775 aoi22d1 $PINS A1=c_src[20] A2=n535 B1=c_src[148] B2=HFSNET_32 ZN=n118
+ VDD=VDD VSS=VSS
XU776 aoi22d1 $PINS A1=c_src[277] A2=n533 B1=c_src[405] B2=HFSNET_22 ZN=n122
+ VDD=VDD VSS=VSS
XU777 aoi22d1 $PINS A1=c_src[21] A2=n535 B1=c_src[149] B2=HFSNET_32 ZN=n121
+ VDD=VDD VSS=VSS
XU778 aoi22d1 $PINS A1=c_src[278] A2=n533 B1=c_src[406] B2=HFSNET_22 ZN=n124
+ VDD=VDD VSS=VSS
XU779 aoi22d1 $PINS A1=c_src[22] A2=n535 B1=c_src[150] B2=HFSNET_32 ZN=n123
+ VDD=VDD VSS=VSS
XU780 aoi22d1 $PINS A1=c_src[279] A2=HFSNET_25 B1=c_src[407] B2=HFSNET_19
+ ZN=n126 VDD=VDD VSS=VSS
XU781 aoi22d1 $PINS A1=c_src[23] A2=HFSNET_36 B1=c_src[151] B2=HFSNET_32
+ ZN=n125 VDD=VDD VSS=VSS
XU782 aoi22d1 $PINS A1=c_src[280] A2=n533 B1=c_src[408] B2=HFSNET_22 ZN=n128
+ VDD=VDD VSS=VSS
XU783 aoi22d1 $PINS A1=c_src[24] A2=HFSNET_36 B1=c_src[152] B2=HFSNET_32
+ ZN=n127 VDD=VDD VSS=VSS
XU784 aoi22d1 $PINS A1=c_src[281] A2=HFSNET_27 B1=c_src[409] B2=HFSNET_20
+ ZN=n130 VDD=VDD VSS=VSS
XU785 aoi22d1 $PINS A1=c_src[25] A2=HFSNET_36 B1=c_src[153] B2=HFSNET_32
+ ZN=n129 VDD=VDD VSS=VSS
XU786 aoi22d1 $PINS A1=c_src[282] A2=HFSNET_27 B1=c_src[410] B2=HFSNET_20
+ ZN=n132 VDD=VDD VSS=VSS
XU787 aoi22d1 $PINS A1=c_src[26] A2=HFSNET_36 B1=c_src[154] B2=HFSNET_32
+ ZN=n131 VDD=VDD VSS=VSS
XU788 aoi22d1 $PINS A1=c_src[283] A2=HFSNET_25 B1=c_src[411] B2=HFSNET_19
+ ZN=n134 VDD=VDD VSS=VSS
XU789 aoi22d1 $PINS A1=c_src[27] A2=HFSNET_36 B1=c_src[155] B2=HFSNET_32
+ ZN=n133 VDD=VDD VSS=VSS
XU790 aoi22d1 $PINS A1=c_src[284] A2=HFSNET_28 B1=c_src[412] B2=HFSNET_18
+ ZN=n136 VDD=VDD VSS=VSS
XU791 aoi22d1 $PINS A1=c_src[28] A2=HFSNET_36 B1=c_src[156] B2=HFSNET_32
+ ZN=n135 VDD=VDD VSS=VSS
XU792 aoi22d1 $PINS A1=c_src[285] A2=n533 B1=c_src[413] B2=HFSNET_22 ZN=n144
+ VDD=VDD VSS=VSS
XU793 aoi22d1 $PINS A1=c_src[29] A2=HFSNET_36 B1=c_src[157] B2=HFSNET_32
+ ZN=n137 VDD=VDD VSS=VSS
XU794 aoi22d1 $PINS A1=c_src[286] A2=HFSNET_27 B1=c_src[414] B2=HFSNET_20
+ ZN=n150 VDD=VDD VSS=VSS
XU795 aoi22d1 $PINS A1=c_src[30] A2=HFSNET_36 B1=c_src[158] B2=HFSNET_32
+ ZN=n148 VDD=VDD VSS=VSS
XU796 aoi22d1 $PINS A1=c_src[287] A2=HFSNET_25 B1=c_src[415] B2=HFSNET_19
+ ZN=n152 VDD=VDD VSS=VSS
XU797 aoi22d1 $PINS A1=c_src[31] A2=HFSNET_36 B1=c_src[159] B2=HFSNET_32
+ ZN=n151 VDD=VDD VSS=VSS
XU798 aoi22d1 $PINS A1=c_src[288] A2=HFSNET_28 B1=c_src[416] B2=HFSNET_18
+ ZN=n154 VDD=VDD VSS=VSS
XU799 aoi22d1 $PINS A1=c_src[32] A2=HFSNET_34 B1=c_src[160] B2=HFSNET_29
+ ZN=n153 VDD=VDD VSS=VSS
XU800 aoi22d1 $PINS A1=c_src[289] A2=HFSNET_25 B1=c_src[417] B2=HFSNET_19
+ ZN=n345 VDD=VDD VSS=VSS
XU801 aoi22d1 $PINS A1=c_src[33] A2=HFSNET_36 B1=c_src[161] B2=HFSNET_31
+ ZN=n155 VDD=VDD VSS=VSS
XU802 aoi22d1 $PINS A1=c_src[290] A2=HFSNET_28 B1=c_src[418] B2=HFSNET_18
+ ZN=n347 VDD=VDD VSS=VSS
XU803 aoi22d1 $PINS A1=c_src[34] A2=HFSNET_36 B1=c_src[162] B2=HFSNET_31
+ ZN=n346 VDD=VDD VSS=VSS
XU804 aoi22d1 $PINS A1=c_src[291] A2=HFSNET_25 B1=c_src[419] B2=HFSNET_19
+ ZN=n349 VDD=VDD VSS=VSS
XU805 aoi22d1 $PINS A1=c_src[35] A2=n535 B1=c_src[163] B2=HFSNET_31 ZN=n348
+ VDD=VDD VSS=VSS
XU806 aoi22d1 $PINS A1=c_src[292] A2=n533 B1=c_src[420] B2=HFSNET_22 ZN=n351
+ VDD=VDD VSS=VSS
XU807 aoi22d1 $PINS A1=c_src[36] A2=HFSNET_36 B1=c_src[164] B2=HFSNET_32
+ ZN=n350 VDD=VDD VSS=VSS
XU808 aoi22d1 $PINS A1=c_src[293] A2=HFSNET_25 B1=c_src[421] B2=HFSNET_19
+ ZN=n353 VDD=VDD VSS=VSS
XU809 aoi22d1 $PINS A1=c_src[37] A2=n535 B1=c_src[165] B2=HFSNET_31 ZN=n352
+ VDD=VDD VSS=VSS
XU810 aoi22d1 $PINS A1=c_src[294] A2=HFSNET_25 B1=c_src[422] B2=HFSNET_19
+ ZN=n355 VDD=VDD VSS=VSS
XU811 aoi22d1 $PINS A1=c_src[38] A2=n535 B1=c_src[166] B2=HFSNET_31 ZN=n354
+ VDD=VDD VSS=VSS
XU812 aoi22d1 $PINS A1=c_src[295] A2=HFSNET_27 B1=c_src[423] B2=HFSNET_20
+ ZN=n357 VDD=VDD VSS=VSS
XU813 aoi22d1 $PINS A1=c_src[39] A2=n535 B1=c_src[167] B2=HFSNET_31 ZN=n356
+ VDD=VDD VSS=VSS
XU814 aoi22d1 $PINS A1=c_src[296] A2=HFSNET_25 B1=c_src[424] B2=HFSNET_19
+ ZN=n359 VDD=VDD VSS=VSS
XU815 aoi22d1 $PINS A1=c_src[40] A2=HFSNET_34 B1=c_src[168] B2=HFSNET_29
+ ZN=n358 VDD=VDD VSS=VSS
XU816 aoi22d1 $PINS A1=c_src[297] A2=HFSNET_25 B1=c_src[425] B2=HFSNET_19
+ ZN=n361 VDD=VDD VSS=VSS
XU817 aoi22d1 $PINS A1=c_src[41] A2=n535 B1=c_src[169] B2=HFSNET_31 ZN=n360
+ VDD=VDD VSS=VSS
XU818 aoi22d1 $PINS A1=c_src[298] A2=n533 B1=c_src[426] B2=HFSNET_22 ZN=n363
+ VDD=VDD VSS=VSS
XU819 aoi22d1 $PINS A1=c_src[42] A2=n535 B1=c_src[170] B2=HFSNET_31 ZN=n362
+ VDD=VDD VSS=VSS
XU820 aoi22d1 $PINS A1=c_src[299] A2=HFSNET_25 B1=c_src[427] B2=HFSNET_19
+ ZN=n365 VDD=VDD VSS=VSS
XU821 aoi22d1 $PINS A1=c_src[43] A2=n535 B1=c_src[171] B2=HFSNET_31 ZN=n364
+ VDD=VDD VSS=VSS
XU822 aoi22d1 $PINS A1=c_src[300] A2=HFSNET_25 B1=c_src[428] B2=HFSNET_19
+ ZN=n367 VDD=VDD VSS=VSS
XU823 aoi22d1 $PINS A1=c_src[44] A2=n535 B1=c_src[172] B2=HFSNET_31 ZN=n366
+ VDD=VDD VSS=VSS
XU824 aoi22d1 $PINS A1=c_src[301] A2=HFSNET_25 B1=c_src[429] B2=HFSNET_19
+ ZN=n369 VDD=VDD VSS=VSS
XU825 aoi22d1 $PINS A1=c_src[45] A2=n535 B1=c_src[173] B2=HFSNET_31 ZN=n368
+ VDD=VDD VSS=VSS
XU826 aoi22d1 $PINS A1=c_src[302] A2=HFSNET_28 B1=c_src[430] B2=HFSNET_18
+ ZN=n371 VDD=VDD VSS=VSS
XU827 aoi22d1 $PINS A1=c_src[46] A2=HFSNET_34 B1=c_src[174] B2=HFSNET_29
+ ZN=n370 VDD=VDD VSS=VSS
XU828 aoi22d1 $PINS A1=c_src[303] A2=HFSNET_25 B1=c_src[431] B2=HFSNET_19
+ ZN=n373 VDD=VDD VSS=VSS
XU829 aoi22d1 $PINS A1=c_src[47] A2=HFSNET_36 B1=c_src[175] B2=HFSNET_31
+ ZN=n372 VDD=VDD VSS=VSS
XU830 aoi22d1 $PINS A1=c_src[304] A2=n533 B1=c_src[432] B2=HFSNET_22 ZN=n375
+ VDD=VDD VSS=VSS
XU831 aoi22d1 $PINS A1=c_src[48] A2=HFSNET_36 B1=c_src[176] B2=HFSNET_32
+ ZN=n374 VDD=VDD VSS=VSS
XU832 aoi22d1 $PINS A1=c_src[305] A2=HFSNET_25 B1=c_src[433] B2=HFSNET_19
+ ZN=n377 VDD=VDD VSS=VSS
XU833 aoi22d1 $PINS A1=c_src[49] A2=HFSNET_36 B1=c_src[177] B2=HFSNET_31
+ ZN=n376 VDD=VDD VSS=VSS
XU834 aoi22d1 $PINS A1=c_src[306] A2=HFSNET_25 B1=c_src[434] B2=HFSNET_19
+ ZN=n379 VDD=VDD VSS=VSS
XU835 aoi22d1 $PINS A1=c_src[50] A2=HFSNET_36 B1=c_src[178] B2=HFSNET_32
+ ZN=n378 VDD=VDD VSS=VSS
XU836 aoi22d1 $PINS A1=c_src[307] A2=HFSNET_25 B1=c_src[435] B2=HFSNET_19
+ ZN=n381 VDD=VDD VSS=VSS
XU837 aoi22d1 $PINS A1=c_src[51] A2=HFSNET_36 B1=c_src[179] B2=HFSNET_32
+ ZN=n380 VDD=VDD VSS=VSS
XU838 aoi22d1 $PINS A1=c_src[308] A2=HFSNET_25 B1=c_src[436] B2=HFSNET_19
+ ZN=n383 VDD=VDD VSS=VSS
XU839 aoi22d1 $PINS A1=c_src[52] A2=n535 B1=c_src[180] B2=HFSNET_32 ZN=n382
+ VDD=VDD VSS=VSS
XU840 aoi22d1 $PINS A1=c_src[309] A2=HFSNET_25 B1=c_src[437] B2=HFSNET_19
+ ZN=n385 VDD=VDD VSS=VSS
XU841 aoi22d1 $PINS A1=c_src[53] A2=HFSNET_36 B1=c_src[181] B2=HFSNET_32
+ ZN=n384 VDD=VDD VSS=VSS
XU842 aoi22d1 $PINS A1=c_src[310] A2=HFSNET_28 B1=c_src[438] B2=HFSNET_18
+ ZN=n387 VDD=VDD VSS=VSS
XU843 aoi22d1 $PINS A1=c_src[54] A2=HFSNET_36 B1=c_src[182] B2=HFSNET_32
+ ZN=n386 VDD=VDD VSS=VSS
XU844 aoi22d1 $PINS A1=c_src[311] A2=n533 B1=c_src[439] B2=HFSNET_22 ZN=n389
+ VDD=VDD VSS=VSS
XU845 aoi22d1 $PINS A1=c_src[55] A2=HFSNET_36 B1=c_src[183] B2=HFSNET_32
+ ZN=n388 VDD=VDD VSS=VSS
XU846 aoi22d1 $PINS A1=c_src[312] A2=HFSNET_28 B1=c_src[440] B2=HFSNET_18
+ ZN=n391 VDD=VDD VSS=VSS
XU847 aoi22d1 $PINS A1=c_src[56] A2=HFSNET_34 B1=c_src[184] B2=HFSNET_29
+ ZN=n390 VDD=VDD VSS=VSS
XU848 aoi22d1 $PINS A1=c_src[313] A2=n533 B1=c_src[441] B2=HFSNET_22 ZN=n393
+ VDD=VDD VSS=VSS
XU849 aoi22d1 $PINS A1=c_src[57] A2=HFSNET_36 B1=c_src[185] B2=HFSNET_32
+ ZN=n392 VDD=VDD VSS=VSS
XU850 aoi22d1 $PINS A1=c_src[314] A2=HFSNET_28 B1=c_src[442] B2=HFSNET_18
+ ZN=n395 VDD=VDD VSS=VSS
XU851 aoi22d1 $PINS A1=c_src[58] A2=HFSNET_34 B1=c_src[186] B2=HFSNET_29
+ ZN=n394 VDD=VDD VSS=VSS
XU852 aoi22d1 $PINS A1=c_src[315] A2=HFSNET_28 B1=c_src[443] B2=HFSNET_18
+ ZN=n397 VDD=VDD VSS=VSS
XU853 aoi22d1 $PINS A1=c_src[59] A2=HFSNET_34 B1=c_src[187] B2=HFSNET_29
+ ZN=n396 VDD=VDD VSS=VSS
XU854 aoi22d1 $PINS A1=c_src[316] A2=HFSNET_28 B1=c_src[444] B2=HFSNET_18
+ ZN=n399 VDD=VDD VSS=VSS
XU855 aoi22d1 $PINS A1=c_src[60] A2=HFSNET_34 B1=c_src[188] B2=HFSNET_29
+ ZN=n398 VDD=VDD VSS=VSS
XU856 aoi22d1 $PINS A1=c_src[317] A2=HFSNET_28 B1=c_src[445] B2=HFSNET_18
+ ZN=n401 VDD=VDD VSS=VSS
XU857 aoi22d1 $PINS A1=c_src[61] A2=HFSNET_34 B1=c_src[189] B2=HFSNET_29
+ ZN=n400 VDD=VDD VSS=VSS
XU858 aoi22d1 $PINS A1=c_src[318] A2=HFSNET_28 B1=c_src[446] B2=HFSNET_18
+ ZN=n403 VDD=VDD VSS=VSS
XU859 aoi22d1 $PINS A1=c_src[62] A2=HFSNET_34 B1=c_src[190] B2=HFSNET_29
+ ZN=n402 VDD=VDD VSS=VSS
XU860 aoi22d1 $PINS A1=c_src[319] A2=n533 B1=c_src[447] B2=HFSNET_22 ZN=n405
+ VDD=VDD VSS=VSS
XU861 aoi22d1 $PINS A1=c_src[63] A2=HFSNET_34 B1=c_src[191] B2=HFSNET_29
+ ZN=n404 VDD=VDD VSS=VSS
XU862 aoi22d1 $PINS A1=c_src[320] A2=HFSNET_28 B1=c_src[448] B2=HFSNET_18
+ ZN=n407 VDD=VDD VSS=VSS
XU863 aoi22d1 $PINS A1=c_src[64] A2=HFSNET_34 B1=c_src[192] B2=HFSNET_29
+ ZN=n406 VDD=VDD VSS=VSS
XU864 aoi22d1 $PINS A1=c_src[321] A2=HFSNET_28 B1=c_src[449] B2=HFSNET_18
+ ZN=n409 VDD=VDD VSS=VSS
XU865 aoi22d1 $PINS A1=c_src[65] A2=HFSNET_34 B1=c_src[193] B2=HFSNET_29
+ ZN=n408 VDD=VDD VSS=VSS
XU866 aoi22d1 $PINS A1=c_src[322] A2=HFSNET_28 B1=c_src[450] B2=HFSNET_18
+ ZN=n411 VDD=VDD VSS=VSS
XU867 aoi22d1 $PINS A1=c_src[66] A2=HFSNET_34 B1=c_src[194] B2=HFSNET_29
+ ZN=n410 VDD=VDD VSS=VSS
XU868 aoi22d1 $PINS A1=c_src[323] A2=HFSNET_28 B1=c_src[451] B2=HFSNET_18
+ ZN=n413 VDD=VDD VSS=VSS
XU869 aoi22d1 $PINS A1=c_src[67] A2=HFSNET_34 B1=c_src[195] B2=HFSNET_29
+ ZN=n412 VDD=VDD VSS=VSS
XU870 aoi22d1 $PINS A1=c_src[324] A2=HFSNET_28 B1=c_src[452] B2=HFSNET_18
+ ZN=n415 VDD=VDD VSS=VSS
XU871 aoi22d1 $PINS A1=c_src[68] A2=HFSNET_34 B1=c_src[196] B2=HFSNET_29
+ ZN=n414 VDD=VDD VSS=VSS
XU872 aoi22d1 $PINS A1=c_src[325] A2=HFSNET_28 B1=c_src[453] B2=HFSNET_18
+ ZN=n417 VDD=VDD VSS=VSS
XU873 aoi22d1 $PINS A1=c_src[69] A2=HFSNET_34 B1=c_src[197] B2=HFSNET_29
+ ZN=n416 VDD=VDD VSS=VSS
XU874 aoi22d1 $PINS A1=c_src[326] A2=HFSNET_28 B1=c_src[454] B2=HFSNET_18
+ ZN=n419 VDD=VDD VSS=VSS
XU875 aoi22d1 $PINS A1=c_src[70] A2=HFSNET_34 B1=c_src[198] B2=HFSNET_29
+ ZN=n418 VDD=VDD VSS=VSS
XU876 aoi22d1 $PINS A1=c_src[327] A2=HFSNET_28 B1=c_src[455] B2=HFSNET_18
+ ZN=n421 VDD=VDD VSS=VSS
XU877 aoi22d1 $PINS A1=c_src[71] A2=HFSNET_34 B1=c_src[199] B2=HFSNET_29
+ ZN=n420 VDD=VDD VSS=VSS
XU878 aoi22d1 $PINS A1=c_src[328] A2=HFSNET_27 B1=c_src[456] B2=HFSNET_20
+ ZN=n423 VDD=VDD VSS=VSS
XU879 aoi22d1 $PINS A1=c_src[72] A2=HFSNET_34 B1=c_src[200] B2=HFSNET_29
+ ZN=n422 VDD=VDD VSS=VSS
XU880 aoi22d1 $PINS A1=c_src[329] A2=HFSNET_27 B1=c_src[457] B2=HFSNET_20
+ ZN=n425 VDD=VDD VSS=VSS
XU881 aoi22d1 $PINS A1=c_src[73] A2=HFSNET_34 B1=c_src[201] B2=HFSNET_29
+ ZN=n424 VDD=VDD VSS=VSS
XU882 aoi22d1 $PINS A1=c_src[330] A2=HFSNET_28 B1=c_src[458] B2=HFSNET_18
+ ZN=n427 VDD=VDD VSS=VSS
XU883 aoi22d1 $PINS A1=c_src[74] A2=HFSNET_34 B1=c_src[202] B2=HFSNET_29
+ ZN=n426 VDD=VDD VSS=VSS
XU884 aoi22d1 $PINS A1=c_src[331] A2=HFSNET_28 B1=c_src[459] B2=HFSNET_18
+ ZN=n429 VDD=VDD VSS=VSS
XU885 aoi22d1 $PINS A1=c_src[75] A2=HFSNET_34 B1=c_src[203] B2=HFSNET_29
+ ZN=n428 VDD=VDD VSS=VSS
XU886 aoi22d1 $PINS A1=c_src[332] A2=HFSNET_28 B1=c_src[460] B2=HFSNET_18
+ ZN=n431 VDD=VDD VSS=VSS
XU887 aoi22d1 $PINS A1=c_src[76] A2=HFSNET_34 B1=c_src[204] B2=HFSNET_29
+ ZN=n430 VDD=VDD VSS=VSS
XU888 aoi22d1 $PINS A1=c_src[333] A2=HFSNET_28 B1=c_src[461] B2=HFSNET_18
+ ZN=n433 VDD=VDD VSS=VSS
XU889 aoi22d1 $PINS A1=c_src[77] A2=HFSNET_34 B1=c_src[205] B2=HFSNET_29
+ ZN=n432 VDD=VDD VSS=VSS
XU890 aoi22d1 $PINS A1=c_src[334] A2=HFSNET_25 B1=c_src[462] B2=HFSNET_19
+ ZN=n435 VDD=VDD VSS=VSS
XU891 aoi22d1 $PINS A1=c_src[78] A2=n535 B1=c_src[206] B2=HFSNET_31 ZN=n434
+ VDD=VDD VSS=VSS
XU892 aoi22d1 $PINS A1=c_src[335] A2=HFSNET_25 B1=c_src[463] B2=HFSNET_19
+ ZN=n437 VDD=VDD VSS=VSS
XU893 aoi22d1 $PINS A1=c_src[79] A2=n535 B1=c_src[207] B2=HFSNET_31 ZN=n436
+ VDD=VDD VSS=VSS
XU894 aoi22d1 $PINS A1=c_src[336] A2=HFSNET_25 B1=c_src[464] B2=HFSNET_19
+ ZN=n439 VDD=VDD VSS=VSS
XU895 aoi22d1 $PINS A1=c_src[80] A2=HFSNET_35 B1=c_src[208] B2=HFSNET_30
+ ZN=n438 VDD=VDD VSS=VSS
XU896 aoi22d1 $PINS A1=c_src[337] A2=HFSNET_28 B1=c_src[465] B2=HFSNET_18
+ ZN=n441 VDD=VDD VSS=VSS
XU897 aoi22d1 $PINS A1=c_src[81] A2=HFSNET_34 B1=c_src[209] B2=HFSNET_29
+ ZN=n440 VDD=VDD VSS=VSS
XU898 aoi22d1 $PINS A1=c_src[338] A2=HFSNET_27 B1=c_src[466] B2=HFSNET_20
+ ZN=n443 VDD=VDD VSS=VSS
XU899 aoi22d1 $PINS A1=c_src[82] A2=HFSNET_35 B1=c_src[210] B2=HFSNET_30
+ ZN=n442 VDD=VDD VSS=VSS
XU900 aoi22d1 $PINS A1=c_src[339] A2=HFSNET_27 B1=c_src[467] B2=HFSNET_20
+ ZN=n445 VDD=VDD VSS=VSS
XU901 aoi22d1 $PINS A1=c_src[83] A2=n535 B1=c_src[211] B2=HFSNET_30 ZN=n444
+ VDD=VDD VSS=VSS
XU902 aoi22d1 $PINS A1=c_src[340] A2=HFSNET_26 B1=c_src[468] B2=HFSNET_21
+ ZN=n447 VDD=VDD VSS=VSS
XU903 aoi22d1 $PINS A1=c_src[84] A2=HFSNET_35 B1=c_src[212] B2=HFSNET_30
+ ZN=n446 VDD=VDD VSS=VSS
XU904 aoi22d1 $PINS A1=c_src[341] A2=HFSNET_25 B1=c_src[469] B2=HFSNET_19
+ ZN=n449 VDD=VDD VSS=VSS
XU905 aoi22d1 $PINS A1=c_src[85] A2=n535 B1=c_src[213] B2=HFSNET_31 ZN=n448
+ VDD=VDD VSS=VSS
XU906 aoi22d1 $PINS A1=c_src[342] A2=HFSNET_25 B1=c_src[470] B2=HFSNET_19
+ ZN=n451 VDD=VDD VSS=VSS
XU907 aoi22d1 $PINS A1=c_src[86] A2=n535 B1=c_src[214] B2=HFSNET_31 ZN=n450
+ VDD=VDD VSS=VSS
XU908 aoi22d1 $PINS A1=c_src[343] A2=HFSNET_25 B1=c_src[471] B2=HFSNET_19
+ ZN=n453 VDD=VDD VSS=VSS
XU909 aoi22d1 $PINS A1=c_src[87] A2=n535 B1=c_src[215] B2=HFSNET_31 ZN=n452
+ VDD=VDD VSS=VSS
XU910 aoi22d1 $PINS A1=c_src[344] A2=HFSNET_26 B1=c_src[472] B2=HFSNET_21
+ ZN=n455 VDD=VDD VSS=VSS
XU911 aoi22d1 $PINS A1=c_src[88] A2=HFSNET_35 B1=c_src[216] B2=HFSNET_30
+ ZN=n454 VDD=VDD VSS=VSS
XU912 aoi22d1 $PINS A1=c_src[345] A2=HFSNET_26 B1=c_src[473] B2=HFSNET_21
+ ZN=n457 VDD=VDD VSS=VSS
XU913 aoi22d1 $PINS A1=c_src[89] A2=HFSNET_35 B1=c_src[217] B2=HFSNET_30
+ ZN=n456 VDD=VDD VSS=VSS
XU914 aoi22d1 $PINS A1=c_src[346] A2=HFSNET_27 B1=c_src[474] B2=HFSNET_20
+ ZN=n459 VDD=VDD VSS=VSS
XU915 aoi22d1 $PINS A1=c_src[90] A2=n535 B1=c_src[218] B2=HFSNET_31 ZN=n458
+ VDD=VDD VSS=VSS
XU916 aoi22d1 $PINS A1=c_src[347] A2=HFSNET_27 B1=c_src[475] B2=HFSNET_20
+ ZN=n461 VDD=VDD VSS=VSS
XU917 aoi22d1 $PINS A1=c_src[91] A2=HFSNET_35 B1=c_src[219] B2=HFSNET_30
+ ZN=n460 VDD=VDD VSS=VSS
XU918 aoi22d1 $PINS A1=c_src[348] A2=HFSNET_26 B1=c_src[476] B2=HFSNET_21
+ ZN=n463 VDD=VDD VSS=VSS
XU919 aoi22d1 $PINS A1=c_src[92] A2=HFSNET_35 B1=c_src[220] B2=HFSNET_30
+ ZN=n462 VDD=VDD VSS=VSS
XU920 aoi22d1 $PINS A1=c_src[349] A2=HFSNET_26 B1=c_src[477] B2=HFSNET_21
+ ZN=n465 VDD=VDD VSS=VSS
XU921 aoi22d1 $PINS A1=c_src[93] A2=HFSNET_35 B1=c_src[221] B2=HFSNET_30
+ ZN=n464 VDD=VDD VSS=VSS
XU922 aoi22d1 $PINS A1=c_src[350] A2=HFSNET_27 B1=c_src[478] B2=HFSNET_20
+ ZN=n467 VDD=VDD VSS=VSS
XU923 aoi22d1 $PINS A1=c_src[94] A2=n535 B1=c_src[222] B2=HFSNET_30 ZN=n466
+ VDD=VDD VSS=VSS
XU924 aoi22d1 $PINS A1=c_src[351] A2=HFSNET_27 B1=c_src[479] B2=HFSNET_20
+ ZN=n469 VDD=VDD VSS=VSS
XU925 aoi22d1 $PINS A1=c_src[95] A2=HFSNET_35 B1=c_src[223] B2=HFSNET_30
+ ZN=n468 VDD=VDD VSS=VSS
XU926 aoi22d1 $PINS A1=c_src[352] A2=HFSNET_27 B1=c_src[480] B2=HFSNET_20
+ ZN=n471 VDD=VDD VSS=VSS
XU927 aoi22d1 $PINS A1=c_src[96] A2=HFSNET_35 B1=c_src[224] B2=HFSNET_30
+ ZN=n470 VDD=VDD VSS=VSS
XU928 aoi22d1 $PINS A1=c_src[353] A2=HFSNET_26 B1=c_src[481] B2=HFSNET_21
+ ZN=n473 VDD=VDD VSS=VSS
XU929 aoi22d1 $PINS A1=c_src[97] A2=HFSNET_35 B1=c_src[225] B2=HFSNET_30
+ ZN=n472 VDD=VDD VSS=VSS
XU930 aoi22d1 $PINS A1=c_src[354] A2=HFSNET_27 B1=c_src[482] B2=HFSNET_20
+ ZN=n475 VDD=VDD VSS=VSS
XU931 aoi22d1 $PINS A1=c_src[98] A2=HFSNET_35 B1=c_src[226] B2=HFSNET_30
+ ZN=n474 VDD=VDD VSS=VSS
XU932 aoi22d1 $PINS A1=c_src[355] A2=HFSNET_26 B1=c_src[483] B2=HFSNET_21
+ ZN=n477 VDD=VDD VSS=VSS
XU933 aoi22d1 $PINS A1=c_src[99] A2=HFSNET_35 B1=c_src[227] B2=HFSNET_30
+ ZN=n476 VDD=VDD VSS=VSS
XU934 aoi22d1 $PINS A1=c_src[356] A2=HFSNET_26 B1=c_src[484] B2=HFSNET_21
+ ZN=n479 VDD=VDD VSS=VSS
XU935 aoi22d1 $PINS A1=c_src[100] A2=HFSNET_35 B1=c_src[228] B2=HFSNET_30
+ ZN=n478 VDD=VDD VSS=VSS
XU936 aoi22d1 $PINS A1=c_src[357] A2=HFSNET_26 B1=c_src[485] B2=HFSNET_21
+ ZN=n481 VDD=VDD VSS=VSS
XU937 aoi22d1 $PINS A1=c_src[101] A2=HFSNET_35 B1=c_src[229] B2=HFSNET_30
+ ZN=n480 VDD=VDD VSS=VSS
XU938 aoi22d1 $PINS A1=c_src[358] A2=HFSNET_26 B1=c_src[486] B2=HFSNET_21
+ ZN=n483 VDD=VDD VSS=VSS
XU939 aoi22d1 $PINS A1=c_src[102] A2=HFSNET_35 B1=c_src[230] B2=HFSNET_30
+ ZN=n482 VDD=VDD VSS=VSS
XU940 aoi22d1 $PINS A1=c_src[359] A2=HFSNET_26 B1=c_src[487] B2=HFSNET_21
+ ZN=n485 VDD=VDD VSS=VSS
XU941 aoi22d1 $PINS A1=c_src[103] A2=HFSNET_35 B1=c_src[231] B2=HFSNET_30
+ ZN=n484 VDD=VDD VSS=VSS
XU942 aoi22d1 $PINS A1=c_src[360] A2=HFSNET_26 B1=c_src[488] B2=HFSNET_21
+ ZN=n487 VDD=VDD VSS=VSS
XU943 aoi22d1 $PINS A1=c_src[104] A2=HFSNET_35 B1=c_src[232] B2=HFSNET_30
+ ZN=n486 VDD=VDD VSS=VSS
XU944 aoi22d1 $PINS A1=c_src[361] A2=HFSNET_26 B1=c_src[489] B2=HFSNET_21
+ ZN=n489 VDD=VDD VSS=VSS
XU945 aoi22d1 $PINS A1=c_src[105] A2=HFSNET_35 B1=c_src[233] B2=HFSNET_30
+ ZN=n488 VDD=VDD VSS=VSS
XU946 aoi22d1 $PINS A1=c_src[362] A2=HFSNET_26 B1=c_src[490] B2=HFSNET_21
+ ZN=n491 VDD=VDD VSS=VSS
XU947 aoi22d1 $PINS A1=c_src[106] A2=HFSNET_35 B1=c_src[234] B2=HFSNET_30
+ ZN=n490 VDD=VDD VSS=VSS
XU948 aoi22d1 $PINS A1=c_src[363] A2=HFSNET_26 B1=c_src[491] B2=HFSNET_21
+ ZN=n493 VDD=VDD VSS=VSS
XU949 aoi22d1 $PINS A1=c_src[107] A2=HFSNET_35 B1=c_src[235] B2=HFSNET_30
+ ZN=n492 VDD=VDD VSS=VSS
XU950 aoi22d1 $PINS A1=c_src[364] A2=HFSNET_26 B1=c_src[492] B2=HFSNET_21
+ ZN=n495 VDD=VDD VSS=VSS
XU951 aoi22d1 $PINS A1=c_src[108] A2=HFSNET_35 B1=c_src[236] B2=HFSNET_30
+ ZN=n494 VDD=VDD VSS=VSS
XU952 aoi22d1 $PINS A1=c_src[365] A2=HFSNET_26 B1=c_src[493] B2=HFSNET_21
+ ZN=n497 VDD=VDD VSS=VSS
XU953 aoi22d1 $PINS A1=c_src[109] A2=HFSNET_35 B1=c_src[237] B2=HFSNET_30
+ ZN=n496 VDD=VDD VSS=VSS
XU954 aoi22d1 $PINS A1=c_src[366] A2=HFSNET_26 B1=c_src[494] B2=HFSNET_21
+ ZN=n499 VDD=VDD VSS=VSS
XU955 aoi22d1 $PINS A1=c_src[110] A2=HFSNET_35 B1=c_src[238] B2=HFSNET_30
+ ZN=n498 VDD=VDD VSS=VSS
XU956 aoi22d1 $PINS A1=c_src[367] A2=HFSNET_26 B1=c_src[495] B2=HFSNET_21
+ ZN=n501 VDD=VDD VSS=VSS
XU957 aoi22d1 $PINS A1=c_src[111] A2=HFSNET_35 B1=c_src[239] B2=HFSNET_30
+ ZN=n500 VDD=VDD VSS=VSS
XU958 aoi22d1 $PINS A1=c_src[368] A2=HFSNET_26 B1=c_src[496] B2=HFSNET_21
+ ZN=n503 VDD=VDD VSS=VSS
XU959 aoi22d1 $PINS A1=c_src[112] A2=HFSNET_35 B1=c_src[240] B2=HFSNET_30
+ ZN=n502 VDD=VDD VSS=VSS
XU960 aoi22d1 $PINS A1=c_src[369] A2=HFSNET_26 B1=c_src[497] B2=HFSNET_21
+ ZN=n505 VDD=VDD VSS=VSS
XU961 aoi22d1 $PINS A1=c_src[113] A2=HFSNET_35 B1=c_src[241] B2=HFSNET_30
+ ZN=n504 VDD=VDD VSS=VSS
XU962 aoi22d1 $PINS A1=c_src[370] A2=HFSNET_26 B1=c_src[498] B2=HFSNET_21
+ ZN=n507 VDD=VDD VSS=VSS
XU963 aoi22d1 $PINS A1=c_src[114] A2=HFSNET_35 B1=c_src[242] B2=HFSNET_30
+ ZN=n506 VDD=VDD VSS=VSS
XU964 aoi22d1 $PINS A1=c_src[371] A2=HFSNET_26 B1=c_src[499] B2=HFSNET_21
+ ZN=n509 VDD=VDD VSS=VSS
XU965 aoi22d1 $PINS A1=c_src[115] A2=HFSNET_35 B1=c_src[243] B2=HFSNET_30
+ ZN=n508 VDD=VDD VSS=VSS
XU966 aoi22d1 $PINS A1=c_src[372] A2=HFSNET_26 B1=c_src[500] B2=HFSNET_21
+ ZN=n511 VDD=VDD VSS=VSS
XU967 aoi22d1 $PINS A1=c_src[116] A2=HFSNET_35 B1=c_src[244] B2=HFSNET_30
+ ZN=n510 VDD=VDD VSS=VSS
XU968 aoi22d1 $PINS A1=c_src[373] A2=HFSNET_26 B1=c_src[501] B2=HFSNET_21
+ ZN=n513 VDD=VDD VSS=VSS
XU969 aoi22d1 $PINS A1=c_src[117] A2=HFSNET_35 B1=c_src[245] B2=HFSNET_30
+ ZN=n512 VDD=VDD VSS=VSS
XU970 aoi22d1 $PINS A1=c_src[374] A2=HFSNET_26 B1=c_src[502] B2=HFSNET_21
+ ZN=n515 VDD=VDD VSS=VSS
XU971 aoi22d1 $PINS A1=c_src[118] A2=HFSNET_35 B1=c_src[246] B2=HFSNET_30
+ ZN=n514 VDD=VDD VSS=VSS
XU972 aoi22d1 $PINS A1=c_src[375] A2=HFSNET_25 B1=c_src[503] B2=HFSNET_19
+ ZN=n517 VDD=VDD VSS=VSS
XU973 aoi22d1 $PINS A1=c_src[119] A2=HFSNET_35 B1=c_src[247] B2=HFSNET_30
+ ZN=n516 VDD=VDD VSS=VSS
XU974 aoi22d1 $PINS A1=c_src[376] A2=HFSNET_26 B1=c_src[504] B2=HFSNET_21
+ ZN=n519 VDD=VDD VSS=VSS
XU975 aoi22d1 $PINS A1=c_src[120] A2=HFSNET_35 B1=c_src[248] B2=HFSNET_30
+ ZN=n518 VDD=VDD VSS=VSS
XU976 aoi22d1 $PINS A1=c_src[377] A2=HFSNET_26 B1=c_src[505] B2=HFSNET_21
+ ZN=n521 VDD=VDD VSS=VSS
XU977 aoi22d1 $PINS A1=c_src[121] A2=HFSNET_35 B1=c_src[249] B2=HFSNET_30
+ ZN=n520 VDD=VDD VSS=VSS
XU978 aoi22d1 $PINS A1=c_src[378] A2=HFSNET_26 B1=c_src[506] B2=HFSNET_21
+ ZN=n523 VDD=VDD VSS=VSS
XU979 aoi22d1 $PINS A1=c_src[122] A2=HFSNET_35 B1=c_src[250] B2=HFSNET_30
+ ZN=n522 VDD=VDD VSS=VSS
XU980 aoi22d1 $PINS A1=c_src[379] A2=HFSNET_27 B1=c_src[507] B2=HFSNET_20
+ ZN=n525 VDD=VDD VSS=VSS
XU981 aoi22d1 $PINS A1=c_src[123] A2=HFSNET_34 B1=c_src[251] B2=HFSNET_29
+ ZN=n524 VDD=VDD VSS=VSS
XU982 aoi22d1 $PINS A1=c_src[380] A2=HFSNET_27 B1=c_src[508] B2=HFSNET_20
+ ZN=n527 VDD=VDD VSS=VSS
XU983 aoi22d1 $PINS A1=c_src[124] A2=HFSNET_34 B1=c_src[252] B2=HFSNET_29
+ ZN=n526 VDD=VDD VSS=VSS
XU984 aoi22d1 $PINS A1=c_src[381] A2=HFSNET_27 B1=c_src[509] B2=HFSNET_20
+ ZN=n529 VDD=VDD VSS=VSS
XU985 aoi22d1 $PINS A1=c_src[125] A2=HFSNET_34 B1=c_src[253] B2=HFSNET_29
+ ZN=n528 VDD=VDD VSS=VSS
XU986 aoi22d1 $PINS A1=c_src[382] A2=HFSNET_28 B1=c_src[510] B2=HFSNET_18
+ ZN=n531 VDD=VDD VSS=VSS
XU987 aoi22d1 $PINS A1=c_src[126] A2=HFSNET_34 B1=c_src[254] B2=HFSNET_29
+ ZN=n530 VDD=VDD VSS=VSS
XU988 nd02d0 $PINS A1=n531 A2=n530 ZN=N_uc_134 VDD=VDD VSS=VSS
XU989 aoi22d1 $PINS A1=c_src[383] A2=HFSNET_27 B1=c_src[511] B2=HFSNET_20
+ ZN=n537 VDD=VDD VSS=VSS
XU990 aoi22d1 $PINS A1=c_src[127] A2=HFSNET_34 B1=c_src[255] B2=HFSNET_29
+ ZN=n536 VDD=VDD VSS=VSS
XU991 nd02d0 $PINS A1=n537 A2=n536 ZN=N_uc_133 VDD=VDD VSS=VSS
XU992 aoi22d1 $PINS A1=N_uc_196 A2=n633 B1=N_uc_164 B2=n632 ZN=n571 VDD=VDD
+ VSS=VSS
XU993 aoi22d1 $PINS A1=N_uc_260 A2=n635 B1=N_uc_228 B2=n634 ZN=n570 VDD=VDD
+ VSS=VSS
XU994 aoi22d1 $PINS A1=N_uc_195 A2=n633 B1=N_uc_163 B2=n632 ZN=n573 VDD=VDD
+ VSS=VSS
XU995 aoi22d1 $PINS A1=N_uc_259 A2=n635 B1=N_uc_227 B2=n634 ZN=n572 VDD=VDD
+ VSS=VSS
XU996 aoi22d1 $PINS A1=N_uc_194 A2=n633 B1=N_uc_162 B2=n632 ZN=n575 VDD=VDD
+ VSS=VSS
XU997 aoi22d1 $PINS A1=N_uc_258 A2=n635 B1=N_uc_226 B2=n634 ZN=n574 VDD=VDD
+ VSS=VSS
XU998 aoi22d1 $PINS A1=N_uc_193 A2=n633 B1=N_uc_161 B2=n632 ZN=n577 VDD=VDD
+ VSS=VSS
XU999 aoi22d1 $PINS A1=N_uc_257 A2=n635 B1=N_uc_225 B2=n634 ZN=n576 VDD=VDD
+ VSS=VSS
XU1000 aoi22d1 $PINS A1=N_uc_192 A2=n633 B1=N_uc_160 B2=n632 ZN=n579 VDD=VDD
+ VSS=VSS
XU1001 aoi22d1 $PINS A1=N_uc_256 A2=n635 B1=N_uc_224 B2=n634 ZN=n578 VDD=VDD
+ VSS=VSS
XU1002 aoi22d1 $PINS A1=N_uc_191 A2=n633 B1=N_uc_159 B2=n632 ZN=n581 VDD=VDD
+ VSS=VSS
XU1003 aoi22d1 $PINS A1=N_uc_255 A2=n635 B1=N_uc_223 B2=n634 ZN=n580 VDD=VDD
+ VSS=VSS
XU1004 aoi22d1 $PINS A1=N_uc_190 A2=n633 B1=N_uc_158 B2=n632 ZN=n583 VDD=VDD
+ VSS=VSS
XU1005 aoi22d1 $PINS A1=N_uc_254 A2=n635 B1=N_uc_222 B2=n634 ZN=n582 VDD=VDD
+ VSS=VSS
XU1006 aoi22d1 $PINS A1=N_uc_189 A2=n633 B1=N_uc_157 B2=n632 ZN=n585 VDD=VDD
+ VSS=VSS
XU1007 aoi22d1 $PINS A1=N_uc_253 A2=n635 B1=N_uc_221 B2=n634 ZN=n584 VDD=VDD
+ VSS=VSS
XU1008 aoi22d1 $PINS A1=N_uc_188 A2=n633 B1=N_uc_156 B2=n632 ZN=n587 VDD=VDD
+ VSS=VSS
XU1009 aoi22d1 $PINS A1=N_uc_252 A2=n635 B1=N_uc_220 B2=n634 ZN=n586 VDD=VDD
+ VSS=VSS
XU1010 aoi22d1 $PINS A1=N_uc_187 A2=n633 B1=N_uc_155 B2=n632 ZN=n589 VDD=VDD
+ VSS=VSS
XU1011 aoi22d1 $PINS A1=N_uc_251 A2=n635 B1=N_uc_219 B2=n634 ZN=n588 VDD=VDD
+ VSS=VSS
XU1012 aoi22d1 $PINS A1=N_uc_186 A2=n633 B1=N_uc_154 B2=n632 ZN=n591 VDD=VDD
+ VSS=VSS
XU1013 aoi22d1 $PINS A1=N_uc_250 A2=n635 B1=N_uc_218 B2=n634 ZN=n590 VDD=VDD
+ VSS=VSS
XU1014 aoi22d1 $PINS A1=N_uc_185 A2=n633 B1=N_uc_153 B2=n632 ZN=n593 VDD=VDD
+ VSS=VSS
XU1015 aoi22d1 $PINS A1=N_uc_184 A2=n633 B1=N_uc_152 B2=n632 ZN=n595 VDD=VDD
+ VSS=VSS
XU1016 aoi22d1 $PINS A1=N_uc_248 A2=n635 B1=N_uc_216 B2=n634 ZN=n594 VDD=VDD
+ VSS=VSS
XU1017 aoi22d1 $PINS A1=N_uc_183 A2=n633 B1=N_uc_151 B2=n632 ZN=n597 VDD=VDD
+ VSS=VSS
XU1018 aoi22d1 $PINS A1=N_uc_247 A2=n635 B1=N_uc_215 B2=n634 ZN=n596 VDD=VDD
+ VSS=VSS
XU1019 aoi22d1 $PINS A1=N_uc_182 A2=n633 B1=N_uc_150 B2=n632 ZN=n599 VDD=VDD
+ VSS=VSS
XU1020 aoi22d1 $PINS A1=N_uc_246 A2=n635 B1=N_uc_214 B2=n634 ZN=n598 VDD=VDD
+ VSS=VSS
XU1021 aoi22d1 $PINS A1=N_uc_181 A2=n633 B1=N_uc_149 B2=n632 ZN=n601 VDD=VDD
+ VSS=VSS
XU1022 aoi22d1 $PINS A1=N_uc_245 A2=n635 B1=N_uc_213 B2=n634 ZN=n600 VDD=VDD
+ VSS=VSS
XU1023 aoi22d1 $PINS A1=N_uc_180 A2=n633 B1=N_uc_148 B2=n632 ZN=n603 VDD=VDD
+ VSS=VSS
XU1024 aoi22d1 $PINS A1=N_uc_244 A2=n635 B1=N_uc_212 B2=n634 ZN=n602 VDD=VDD
+ VSS=VSS
XU1025 aoi22d1 $PINS A1=N_uc_243 A2=n635 B1=N_uc_211 B2=n634 ZN=n604 VDD=VDD
+ VSS=VSS
XU1026 aoi22d1 $PINS A1=N_uc_178 A2=n633 B1=N_uc_146 B2=n632 ZN=n607 VDD=VDD
+ VSS=VSS
XU1027 aoi22d1 $PINS A1=N_uc_242 A2=n635 B1=N_uc_210 B2=n634 ZN=n606 VDD=VDD
+ VSS=VSS
XU1028 aoi22d1 $PINS A1=N_uc_177 A2=n633 B1=N_uc_145 B2=n632 ZN=n609 VDD=VDD
+ VSS=VSS
XU1029 aoi22d1 $PINS A1=N_uc_241 A2=n635 B1=N_uc_209 B2=n634 ZN=n608 VDD=VDD
+ VSS=VSS
XU1030 aoi22d1 $PINS A1=N_uc_176 A2=n633 B1=N_uc_144 B2=n632 ZN=n611 VDD=VDD
+ VSS=VSS
XU1031 aoi22d1 $PINS A1=N_uc_240 A2=n635 B1=N_uc_208 B2=n634 ZN=n610 VDD=VDD
+ VSS=VSS
XU1032 aoi22d1 $PINS A1=N_uc_175 A2=n633 B1=N_uc_143 B2=n632 ZN=n613 VDD=VDD
+ VSS=VSS
XU1033 aoi22d1 $PINS A1=N_uc_239 A2=n635 B1=N_uc_207 B2=n634 ZN=n612 VDD=VDD
+ VSS=VSS
XU1034 aoi22d1 $PINS A1=N_uc_174 A2=n633 B1=N_uc_142 B2=n632 ZN=n615 VDD=VDD
+ VSS=VSS
XU1035 aoi22d1 $PINS A1=N_uc_238 A2=n635 B1=N_uc_206 B2=n634 ZN=n614 VDD=VDD
+ VSS=VSS
XU1036 aoi22d1 $PINS A1=N_uc_173 A2=n633 B1=N_uc_141 B2=n632 ZN=n617 VDD=VDD
+ VSS=VSS
XU1037 aoi22d1 $PINS A1=N_uc_237 A2=n635 B1=N_uc_205 B2=n634 ZN=n616 VDD=VDD
+ VSS=VSS
XU1038 aoi22d1 $PINS A1=N_uc_236 A2=n635 B1=N_uc_204 B2=n634 ZN=n618 VDD=VDD
+ VSS=VSS
XU1039 aoi22d1 $PINS A1=N_uc_171 A2=n633 B1=N_uc_139 B2=n632 ZN=n621 VDD=VDD
+ VSS=VSS
XU1040 aoi22d1 $PINS A1=N_uc_235 A2=n635 B1=N_uc_203 B2=n634 ZN=n620 VDD=VDD
+ VSS=VSS
XU1041 aoi22d1 $PINS A1=N_uc_170 A2=n633 B1=N_uc_138 B2=n632 ZN=n623 VDD=VDD
+ VSS=VSS
XU1042 aoi22d1 $PINS A1=N_uc_234 A2=n635 B1=N_uc_202 B2=n634 ZN=n622 VDD=VDD
+ VSS=VSS
XU1043 aoi22d1 $PINS A1=N_uc_169 A2=n633 B1=N_uc_137 B2=n632 ZN=n625 VDD=VDD
+ VSS=VSS
XU1044 aoi22d1 $PINS A1=N_uc_233 A2=n635 B1=N_uc_201 B2=n634 ZN=n624 VDD=VDD
+ VSS=VSS
XU1045 nd02d0 $PINS A1=n625 A2=n624 ZN=N_uc_265 VDD=VDD VSS=VSS
XU1046 aoi22d1 $PINS A1=N_uc_168 A2=n633 B1=N_uc_136 B2=n632 ZN=n627 VDD=VDD
+ VSS=VSS
XU1047 aoi22d1 $PINS A1=N_uc_232 A2=n635 B1=N_uc_200 B2=n634 ZN=n626 VDD=VDD
+ VSS=VSS
XU1048 nd02d0 $PINS A1=n627 A2=n626 ZN=N_uc_264 VDD=VDD VSS=VSS
XU1049 aoi22d1 $PINS A1=N_uc_167 A2=n633 B1=N_uc_135 B2=n632 ZN=n629 VDD=VDD
+ VSS=VSS
XU1050 aoi22d1 $PINS A1=N_uc_231 A2=n635 B1=N_uc_199 B2=n634 ZN=n628 VDD=VDD
+ VSS=VSS
XU1051 aoi22d1 $PINS A1=N_uc_166 A2=n633 B1=N_uc_134 B2=n632 ZN=n631 VDD=VDD
+ VSS=VSS
XU1052 aoi22d1 $PINS A1=N_uc_230 A2=n635 B1=N_uc_198 B2=n634 ZN=n630 VDD=VDD
+ VSS=VSS
XU1053 aoi22d1 $PINS A1=N_uc_165 A2=n633 B1=N_uc_133 B2=n632 ZN=n637 VDD=VDD
+ VSS=VSS
XU1054 aoi22d1 $PINS A1=N_uc_229 A2=n635 B1=N_uc_197 B2=n634 ZN=n636 VDD=VDD
+ VSS=VSS
XU1055 aoi22d1 $PINS A1=stage[32] A2=n711 B1=stage[0] B2=n710 ZN=n649 VDD=VDD
+ VSS=VSS
XU1056 aoi22d1 $PINS A1=stage[96] A2=n713 B1=stage[64] B2=n712 ZN=n648 VDD=VDD
+ VSS=VSS
XU1057 nd02d0 $PINS A1=n649 A2=n648 ZN=N_uc_422 VDD=VDD VSS=VSS
XU1058 aoi22d1 $PINS A1=copt_net_938 A2=n711 B1=copt_net_824 B2=n710 ZN=n651
+ VDD=VDD VSS=VSS
XU1059 aoi22d1 $PINS A1=stage[97] A2=n713 B1=copt_net_882 B2=n720 ZN=n650
+ VDD=VDD VSS=VSS
XU1060 nd02d0 $PINS A1=n651 A2=n650 ZN=N_uc_421 VDD=VDD VSS=VSS
XU1061 aoi22d1 $PINS A1=stage[34] A2=n711 B1=stage[2] B2=n710 ZN=n653 VDD=VDD
+ VSS=VSS
XU1062 aoi22d1 $PINS A1=stage[98] A2=n713 B1=stage[66] B2=n720 ZN=n652 VDD=VDD
+ VSS=VSS
XU1063 nd02d0 $PINS A1=n653 A2=n652 ZN=N_uc_420 VDD=VDD VSS=VSS
XU1064 aoi22d1 $PINS A1=stage[35] A2=n711 B1=stage[3] B2=n710 ZN=n655 VDD=VDD
+ VSS=VSS
XU1065 aoi22d1 $PINS A1=copt_net_832 A2=n713 B1=stage[67] B2=n720 ZN=n654
+ VDD=VDD VSS=VSS
XU1066 nd02d0 $PINS A1=n655 A2=n654 ZN=N_uc_419 VDD=VDD VSS=VSS
XU1067 aoi22d1 $PINS A1=copt_net_750 A2=n711 B1=copt_net_1019 B2=n710 ZN=n657
+ VDD=VDD VSS=VSS
XU1068 aoi22d1 $PINS A1=copt_net_1025 A2=n713 B1=copt_net_914 B2=n712 ZN=n656
+ VDD=VDD VSS=VSS
XU1069 nd02d0 $PINS A1=n657 A2=n656 ZN=N_uc_418 VDD=VDD VSS=VSS
XU1070 aoi22d1 $PINS A1=copt_net_968 A2=n711 B1=copt_net_810 B2=n710 ZN=n659
+ VDD=VDD VSS=VSS
XU1071 nd02d0 $PINS A1=n659 A2=n658 ZN=N_uc_417 VDD=VDD VSS=VSS
XU1072 aoi22d1 $PINS A1=copt_net_906 A2=n711 B1=copt_net_850 B2=n710 ZN=n661
+ VDD=VDD VSS=VSS
XU1073 aoi22d1 $PINS A1=copt_net_804 A2=n713 B1=copt_net_840 B2=n720 ZN=n660
+ VDD=VDD VSS=VSS
XU1074 nd02d0 $PINS A1=n661 A2=n660 ZN=N_uc_416 VDD=VDD VSS=VSS
XU1075 aoi22d1 $PINS A1=copt_net_965 A2=n711 B1=stage[7] B2=n710 ZN=n663
+ VDD=VDD VSS=VSS
XU1076 aoi22d1 $PINS A1=copt_net_910 A2=n713 B1=stage[71] B2=n720 ZN=n662
+ VDD=VDD VSS=VSS
Xcopt_h_inst_3673 dl02d1 $PINS I=stage[57] Z=copt_net_841 VDD=VDD VSS=VSS
XU1078 aoi22d1 $PINS A1=stage[40] A2=n711 B1=stage[8] B2=n710 ZN=n665 VDD=VDD
+ VSS=VSS
XU1079 aoi22d1 $PINS A1=stage[104] A2=n713 B1=stage[72] B2=n712 ZN=n664 VDD=VDD
+ VSS=VSS
XU1080 nd02d0 $PINS A1=n665 A2=n664 ZN=N_uc_414 VDD=VDD VSS=VSS
XU1081 aoi22d1 $PINS A1=copt_net_1113 A2=n711 B1=copt_net_795 B2=n710 ZN=n667
+ VDD=VDD VSS=VSS
XU1082 aoi22d1 $PINS A1=copt_net_864 A2=n713 B1=copt_net_960 B2=n720 ZN=n666
+ VDD=VDD VSS=VSS
XU1083 nd02d0 $PINS A1=n667 A2=n666 ZN=N_uc_413 VDD=VDD VSS=VSS
XU1084 aoi22d1 $PINS A1=stage[42] A2=n711 B1=stage[10] B2=n710 ZN=n669 VDD=VDD
+ VSS=VSS
XU1085 aoi22d1 $PINS A1=copt_net_980 A2=n713 B1=stage[74] B2=n720 ZN=n668
+ VDD=VDD VSS=VSS
XU1086 nd02d0 $PINS A1=n669 A2=n668 ZN=N_uc_412 VDD=VDD VSS=VSS
XU1087 aoi22d1 $PINS A1=stage[43] A2=n711 B1=stage[11] B2=n710 ZN=n671 VDD=VDD
+ VSS=VSS
XU1088 aoi22d1 $PINS A1=stage[107] A2=n713 B1=stage[75] B2=n720 ZN=n670 VDD=VDD
+ VSS=VSS
XU1089 nd02d0 $PINS A1=n671 A2=n670 ZN=N_uc_411 VDD=VDD VSS=VSS
XU1090 aoi22d1 $PINS A1=stage[44] A2=n711 B1=stage[12] B2=n710 ZN=n673 VDD=VDD
+ VSS=VSS
XU1091 aoi22d1 $PINS A1=stage[108] A2=n713 B1=stage[76] B2=n720 ZN=n672 VDD=VDD
+ VSS=VSS
XU1092 nd02d0 $PINS A1=n673 A2=n672 ZN=N_uc_410 VDD=VDD VSS=VSS
XU1093 aoi22d1 $PINS A1=copt_net_896 A2=n711 B1=copt_net_811 B2=n710 ZN=n675
+ VDD=VDD VSS=VSS
XU1094 aoi22d1 $PINS A1=copt_net_899 A2=n713 B1=copt_net_943 B2=n720 ZN=n674
+ VDD=VDD VSS=VSS
Xcopt_h_inst_3675 dl02d1 $PINS I=stage[8] Z=copt_net_843 VDD=VDD VSS=VSS
XU1096 aoi22d1 $PINS A1=stage[46] A2=n711 B1=stage[14] B2=n710 ZN=n677 VDD=VDD
+ VSS=VSS
XU1097 aoi22d1 $PINS A1=stage[110] A2=n713 B1=stage[78] B2=n720 ZN=n676 VDD=VDD
+ VSS=VSS
XU1098 nd02d0 $PINS A1=n677 A2=n676 ZN=N_uc_408 VDD=VDD VSS=VSS
XU1099 aoi22d1 $PINS A1=copt_net_898 A2=n711 B1=copt_net_863 B2=n710 ZN=n679
+ VDD=VDD VSS=VSS
XU1100 aoi22d1 $PINS A1=copt_net_920 A2=n713 B1=copt_net_967 B2=n720 ZN=n678
+ VDD=VDD VSS=VSS
XU1101 nd02d0 $PINS A1=n679 A2=n678 ZN=N_uc_407 VDD=VDD VSS=VSS
XU1102 aoi22d1 $PINS A1=stage[48] A2=n711 B1=stage[16] B2=n710 ZN=n681 VDD=VDD
+ VSS=VSS
XU1103 aoi22d1 $PINS A1=stage[112] A2=n713 B1=stage[80] B2=n720 ZN=n680 VDD=VDD
+ VSS=VSS
XU1104 nd02d0 $PINS A1=n681 A2=n680 ZN=N_uc_406 VDD=VDD VSS=VSS
XU1105 nd02d0 $PINS A1=n683 A2=n682 ZN=N_uc_405 VDD=VDD VSS=VSS
XU1106 aoi22d1 $PINS A1=copt_net_953 A2=n711 B1=stage[18] B2=n710 ZN=n685
+ VDD=VDD VSS=VSS
XU1107 aoi22d1 $PINS A1=stage[114] A2=n713 B1=stage[82] B2=n712 ZN=n684 VDD=VDD
+ VSS=VSS
Xcopt_h_inst_3678 dl02d1 $PINS I=stage[17] Z=copt_net_846 VDD=VDD VSS=VSS
XU1109 aoi22d1 $PINS A1=stage[51] A2=n711 B1=stage[19] B2=n710 ZN=n687 VDD=VDD
+ VSS=VSS
XU1110 aoi22d1 $PINS A1=stage[115] A2=n713 B1=stage[83] B2=n712 ZN=n686 VDD=VDD
+ VSS=VSS
XU1111 nd02d0 $PINS A1=n687 A2=n686 ZN=N_uc_403 VDD=VDD VSS=VSS
XU1112 aoi22d1 $PINS A1=stage[52] A2=n711 B1=stage[20] B2=n710 ZN=n689 VDD=VDD
+ VSS=VSS
XU1113 aoi22d1 $PINS A1=stage[116] A2=n713 B1=stage[84] B2=n720 ZN=n688 VDD=VDD
+ VSS=VSS
XU1114 nd02d0 $PINS A1=n689 A2=n688 ZN=N_uc_402 VDD=VDD VSS=VSS
XU1115 aoi22d1 $PINS A1=stage[53] A2=n711 B1=stage[21] B2=n710 ZN=n691 VDD=VDD
+ VSS=VSS
XU1116 aoi22d1 $PINS A1=stage[117] A2=n713 B1=stage[85] B2=n720 ZN=n690 VDD=VDD
+ VSS=VSS
Xcopt_h_inst_3679 dl02d1 $PINS I=stage[61] Z=copt_net_847 VDD=VDD VSS=VSS
XU1118 aoi22d1 $PINS A1=stage[54] A2=n711 B1=stage[22] B2=n710 ZN=n693 VDD=VDD
+ VSS=VSS
XU1119 aoi22d1 $PINS A1=stage[118] A2=n713 B1=stage[86] B2=n712 ZN=n692 VDD=VDD
+ VSS=VSS
XU1120 aoi22d1 $PINS A1=stage[55] A2=n711 B1=stage[23] B2=n710 ZN=n695 VDD=VDD
+ VSS=VSS
XU1121 aoi22d1 $PINS A1=stage[119] A2=n713 B1=stage[87] B2=n712 ZN=n694 VDD=VDD
+ VSS=VSS
Xcopt_h_inst_3681 dl02d1 $PINS I=stage[66] Z=copt_net_849 VDD=VDD VSS=VSS
XU1123 aoi22d1 $PINS A1=stage[56] A2=n711 B1=stage[24] B2=n710 ZN=n697 VDD=VDD
+ VSS=VSS
XU1124 aoi22d1 $PINS A1=stage[120] A2=n713 B1=stage[88] B2=n720 ZN=n696 VDD=VDD
+ VSS=VSS
XU1125 nd02d0 $PINS A1=n697 A2=n696 ZN=N_uc_398 VDD=VDD VSS=VSS
XU1126 aoi22d1 $PINS A1=copt_net_841 A2=n711 B1=copt_net_924 B2=n710 ZN=n699
+ VDD=VDD VSS=VSS
XU1127 aoi22d1 $PINS A1=copt_net_934 A2=n713 B1=copt_net_933 B2=n720 ZN=n698
+ VDD=VDD VSS=VSS
Xcopt_h_inst_3682 dl02d1 $PINS I=stage[6] Z=copt_net_850 VDD=VDD VSS=VSS
XU1129 aoi22d1 $PINS A1=stage[58] A2=n711 B1=stage[26] B2=n710 ZN=n701 VDD=VDD
+ VSS=VSS
XU1130 aoi22d1 $PINS A1=stage[122] A2=n713 B1=stage[90] B2=n720 ZN=n700 VDD=VDD
+ VSS=VSS
XU1131 nd02d0 $PINS A1=n701 A2=n700 ZN=N_uc_396 VDD=VDD VSS=VSS
XU1132 aoi22d1 $PINS A1=copt_net_830 A2=n711 B1=copt_net_805 B2=n710 ZN=n703
+ VDD=VDD VSS=VSS
XU1133 aoi22d1 $PINS A1=copt_net_873 A2=n713 B1=copt_net_879 B2=n720 ZN=n702
+ VDD=VDD VSS=VSS
Xcopt_h_inst_3684 dl02d1 $PINS I=stage[7] Z=copt_net_852 VDD=VDD VSS=VSS
XU1135 aoi22d1 $PINS A1=stage[60] A2=n711 B1=stage[28] B2=n710 ZN=n705 VDD=VDD
+ VSS=VSS
XU1136 aoi22d1 $PINS A1=stage[124] A2=n713 B1=stage[92] B2=n712 ZN=n704 VDD=VDD
+ VSS=VSS
XU1137 nd02d0 $PINS A1=n705 A2=n704 ZN=N_uc_394 VDD=VDD VSS=VSS
XU1138 aoi22d1 $PINS A1=stage[61] A2=n711 B1=stage[29] B2=n710 ZN=n707 VDD=VDD
+ VSS=VSS
Xcopt_h_inst_3686 dl02d1 $PINS I=stage[21] Z=copt_net_854 VDD=VDD VSS=VSS
XU1140 aoi22d1 $PINS A1=copt_net_978 A2=n711 B1=copt_net_1015 B2=n710 ZN=n709
+ VDD=VDD VSS=VSS
XU1141 aoi22d1 $PINS A1=copt_net_992 A2=n713 B1=copt_net_986 B2=n720 ZN=n708
+ VDD=VDD VSS=VSS
XU1142 aoi22d1 $PINS A1=stage[63] A2=n711 B1=copt_net_926 B2=n710 ZN=n715
+ VDD=VDD VSS=VSS
XU1143 aoi22d1 $PINS A1=copt_net_891 A2=n713 B1=stage[95] B2=n720 ZN=n714
+ VDD=VDD VSS=VSS
XU1144 aoi22d1 $PINS A1=stage[32] A2=n787 B1=stage[0] B2=n786 ZN=n725 VDD=VDD
+ VSS=VSS
XU1145 aoi22d1 $PINS A1=stage[96] A2=n789 B1=stage[64] B2=n797 ZN=n724 VDD=VDD
+ VSS=VSS
XU1146 nd02d0 $PINS A1=n725 A2=n724 ZN=N_uc_456 VDD=VDD VSS=VSS
XU1147 aoi22d1 $PINS A1=copt_net_938 A2=n787 B1=copt_net_824 B2=n786 ZN=n727
+ VDD=VDD VSS=VSS
XU1148 aoi22d1 $PINS A1=copt_net_821 A2=n789 B1=copt_net_882 B2=n788 ZN=n726
+ VDD=VDD VSS=VSS
XU1149 aoi22d1 $PINS A1=stage[34] A2=n787 B1=stage[2] B2=n786 ZN=n729 VDD=VDD
+ VSS=VSS
XU1150 aoi22d1 $PINS A1=stage[98] A2=n789 B1=stage[66] B2=n797 ZN=n728 VDD=VDD
+ VSS=VSS
XU1151 nd02d4 $PINS A1=n729 A2=n728 ZN=N_uc_454 VDD=VDD VSS=VSS
XU1152 aoi22d1 $PINS A1=stage[35] A2=n787 B1=stage[3] B2=n786 ZN=n731 VDD=VDD
+ VSS=VSS
XU1153 aoi22d1 $PINS A1=copt_net_832 A2=n789 B1=stage[67] B2=n797 ZN=n730
+ VDD=VDD VSS=VSS
XU1154 nd02d0 $PINS A1=n731 A2=n730 ZN=N_uc_453 VDD=VDD VSS=VSS
XU1155 aoi22d1 $PINS A1=copt_net_750 A2=n787 B1=copt_net_1019 B2=n786 ZN=n733
+ VDD=VDD VSS=VSS
XU1156 aoi22d1 $PINS A1=copt_net_1025 A2=n789 B1=copt_net_914 B2=n788 ZN=n732
+ VDD=VDD VSS=VSS
XU1157 aoi22d1 $PINS A1=copt_net_968 A2=n787 B1=copt_net_810 B2=n786 ZN=n735
+ VDD=VDD VSS=VSS
XU1158 aoi22d1 $PINS A1=copt_net_1031 A2=n789 B1=copt_net_816 B2=n797 ZN=n734
+ VDD=VDD VSS=VSS
XU1159 aoi22d1 $PINS A1=copt_net_906 A2=n787 B1=copt_net_850 B2=n786 ZN=n737
+ VDD=VDD VSS=VSS
XU1160 aoi22d1 $PINS A1=copt_net_804 A2=n789 B1=copt_net_840 B2=n797 ZN=n736
+ VDD=VDD VSS=VSS
XU1161 aoi22d1 $PINS A1=copt_net_965 A2=n787 B1=stage[7] B2=n786 ZN=n739
+ VDD=VDD VSS=VSS
XU1162 aoi22d1 $PINS A1=copt_net_910 A2=n789 B1=stage[71] B2=n788 ZN=n738
+ VDD=VDD VSS=VSS
XU1163 nd02d0 $PINS A1=n739 A2=n738 ZN=N_uc_449 VDD=VDD VSS=VSS
XU1164 aoi22d1 $PINS A1=stage[40] A2=n787 B1=stage[8] B2=n786 ZN=n741 VDD=VDD
+ VSS=VSS
XU1165 aoi22d1 $PINS A1=stage[104] A2=n789 B1=stage[72] B2=n797 ZN=n740 VDD=VDD
+ VSS=VSS
XU1166 nd02d0 $PINS A1=n740 A2=n741 ZN=N_uc_448 VDD=VDD VSS=VSS
XU1167 aoi22d1 $PINS A1=copt_net_1113 A2=n787 B1=copt_net_795 B2=n786 ZN=n743
+ VDD=VDD VSS=VSS
XU1168 aoi22d1 $PINS A1=copt_net_864 A2=n789 B1=copt_net_960 B2=n788 ZN=n742
+ VDD=VDD VSS=VSS
Xcopt_h_inst_3690 dl02d1 $PINS I=stage[2] Z=copt_net_858 VDD=VDD VSS=VSS
XU1170 aoi22d1 $PINS A1=stage[42] A2=n787 B1=stage[10] B2=n786 ZN=n745 VDD=VDD
+ VSS=VSS
XU1171 aoi22d1 $PINS A1=copt_net_980 A2=n789 B1=stage[74] B2=n797 ZN=n744
+ VDD=VDD VSS=VSS
Xcopt_h_inst_3693 dl02d1 $PINS I=stage[96] Z=copt_net_861 VDD=VDD VSS=VSS
XU1173 aoi22d1 $PINS A1=stage[43] A2=n787 B1=stage[11] B2=n786 ZN=n747 VDD=VDD
+ VSS=VSS
XU1174 aoi22d1 $PINS A1=stage[107] A2=n789 B1=stage[75] B2=n788 ZN=n746 VDD=VDD
+ VSS=VSS
Xcopt_h_inst_3694 dl02d1 $PINS I=stage[40] Z=copt_net_862 VDD=VDD VSS=VSS
XU1176 aoi22d1 $PINS A1=stage[44] A2=n787 B1=stage[12] B2=n786 ZN=n749 VDD=VDD
+ VSS=VSS
XU1177 aoi22d1 $PINS A1=stage[108] A2=n789 B1=stage[76] B2=n797 ZN=n748 VDD=VDD
+ VSS=VSS
XU1178 nd02d0 $PINS A1=n749 A2=n748 ZN=N_uc_444 VDD=VDD VSS=VSS
XU1179 aoi22d1 $PINS A1=copt_net_896 A2=n787 B1=copt_net_811 B2=n786 ZN=n751
+ VDD=VDD VSS=VSS
XU1180 aoi22d1 $PINS A1=copt_net_899 A2=n789 B1=copt_net_943 B2=n797 ZN=n750
+ VDD=VDD VSS=VSS
Xcopt_h_inst_3695 dl02d1 $PINS I=stage[15] Z=copt_net_863 VDD=VDD VSS=VSS
XU1182 aoi22d1 $PINS A1=stage[46] A2=n787 B1=stage[14] B2=n786 ZN=n753 VDD=VDD
+ VSS=VSS
XU1183 aoi22d1 $PINS A1=stage[110] A2=n789 B1=stage[78] B2=n797 ZN=n752 VDD=VDD
+ VSS=VSS
XU1184 nd02d0 $PINS A1=n753 A2=n752 ZN=N_uc_442 VDD=VDD VSS=VSS
XU1185 aoi22d1 $PINS A1=copt_net_898 A2=n787 B1=copt_net_863 B2=n786 ZN=n755
+ VDD=VDD VSS=VSS
XU1186 aoi22d1 $PINS A1=copt_net_920 A2=n789 B1=copt_net_967 B2=n797 ZN=n754
+ VDD=VDD VSS=VSS
XU1187 nd02d0 $PINS A1=n755 A2=n754 ZN=N_uc_441 VDD=VDD VSS=VSS
XU1188 aoi22d1 $PINS A1=stage[48] A2=n787 B1=stage[16] B2=n786 ZN=n757 VDD=VDD
+ VSS=VSS
XU1189 aoi22d1 $PINS A1=stage[112] A2=n789 B1=stage[80] B2=n797 ZN=n756 VDD=VDD
+ VSS=VSS
XU1190 nd02d4 $PINS A1=n757 A2=n756 ZN=N_uc_440 VDD=VDD VSS=VSS
XU1191 aoi22d1 $PINS A1=stage[49] A2=n787 B1=stage[17] B2=n786 ZN=n759 VDD=VDD
+ VSS=VSS
XU1192 aoi22d1 $PINS A1=copt_net_928 A2=n789 B1=stage[81] B2=n797 ZN=n758
+ VDD=VDD VSS=VSS
XU1193 nd02d4 $PINS A1=n759 A2=n758 ZN=N_uc_439 VDD=VDD VSS=VSS
XU1194 aoi22d2 $PINS A1=copt_net_953 A2=n787 B1=stage[18] B2=n786 ZN=n761
+ VDD=VDD VSS=VSS
XU1195 aoi22d1 $PINS A1=stage[114] A2=n789 B1=stage[82] B2=n797 ZN=n760 VDD=VDD
+ VSS=VSS
XU1196 nd02d7 $PINS A1=n761 A2=n760 ZN=N_uc_438 VDD=VDD VSS=VSS
XU1197 aoi22d1 $PINS A1=stage[51] A2=n787 B1=stage[19] B2=n786 ZN=n763 VDD=VDD
+ VSS=VSS
XU1198 aoi22d1 $PINS A1=stage[115] A2=n789 B1=stage[83] B2=n797 ZN=n762 VDD=VDD
+ VSS=VSS
XU1199 nd02d0 $PINS A1=n763 A2=n762 ZN=N_uc_437 VDD=VDD VSS=VSS
XU1200 aoi22d1 $PINS A1=stage[116] A2=n789 B1=stage[84] B2=n797 ZN=n764 VDD=VDD
+ VSS=VSS
XU1201 nd02da $PINS A1=n765 A2=n764 ZN=N_uc_436 VDD=VDD VSS=VSS
XU1202 aoi22d1 $PINS A1=stage[53] A2=n787 B1=stage[21] B2=n786 ZN=n767 VDD=VDD
+ VSS=VSS
XU1203 aoi22d1 $PINS A1=stage[117] A2=n789 B1=stage[85] B2=n797 ZN=n766 VDD=VDD
+ VSS=VSS
XU1204 nd02d0 $PINS A1=n767 A2=n766 ZN=N_uc_435 VDD=VDD VSS=VSS
XU1205 aoi22d1 $PINS A1=stage[54] A2=n787 B1=stage[22] B2=n786 ZN=n769 VDD=VDD
+ VSS=VSS
XU1206 aoi22d1 $PINS A1=stage[118] A2=n789 B1=stage[86] B2=n797 ZN=n768 VDD=VDD
+ VSS=VSS
XU1207 nd02d0 $PINS A1=n769 A2=n768 ZN=N_uc_434 VDD=VDD VSS=VSS
XU1208 aoi22d1 $PINS A1=stage[55] A2=n787 B1=stage[23] B2=n786 ZN=n771 VDD=VDD
+ VSS=VSS
XU1209 aoi22d1 $PINS A1=stage[119] A2=n789 B1=stage[87] B2=n797 ZN=n770 VDD=VDD
+ VSS=VSS
XU1210 nd02da $PINS A1=n771 A2=n770 ZN=N_uc_433 VDD=VDD VSS=VSS
XU1211 aoi22d1 $PINS A1=stage[120] A2=n789 B1=stage[88] B2=n797 ZN=n772 VDD=VDD
+ VSS=VSS
XU1212 nd02d0 $PINS A1=n773 A2=n772 ZN=N_uc_432 VDD=VDD VSS=VSS
XU1213 aoi22d1 $PINS A1=stage[121] A2=n789 B1=copt_net_933 B2=n797 ZN=n774
+ VDD=VDD VSS=VSS
XU1214 nd02d0 $PINS A1=n775 A2=n774 ZN=N_uc_431 VDD=VDD VSS=VSS
XU1215 aoi22d1 $PINS A1=stage[58] A2=n787 B1=stage[26] B2=n786 ZN=n777 VDD=VDD
+ VSS=VSS
XU1216 aoi22d1 $PINS A1=stage[122] A2=n789 B1=stage[90] B2=n797 ZN=n776 VDD=VDD
+ VSS=VSS
XU1217 nd02d0 $PINS A1=n777 A2=n776 ZN=N_uc_430 VDD=VDD VSS=VSS
XU1218 aoi22d1 $PINS A1=copt_net_830 A2=n787 B1=copt_net_805 B2=n786 ZN=n779
+ VDD=VDD VSS=VSS
XU1219 aoi22d1 $PINS A1=copt_net_873 A2=n789 B1=copt_net_879 B2=n788 ZN=n778
+ VDD=VDD VSS=VSS
XU1220 nd02d0 $PINS A1=n779 A2=n778 ZN=N_uc_429 VDD=VDD VSS=VSS
XU1221 aoi22d1 $PINS A1=stage[60] A2=n787 B1=stage[28] B2=n786 ZN=n781 VDD=VDD
+ VSS=VSS
XU1222 aoi22d1 $PINS A1=stage[124] A2=n789 B1=stage[92] B2=n788 ZN=n780 VDD=VDD
+ VSS=VSS
XU1223 nd02d4 $PINS A1=n781 A2=n780 ZN=N_uc_428 VDD=VDD VSS=VSS
XU1224 aoi22d1 $PINS A1=stage[61] A2=n787 B1=stage[29] B2=n786 ZN=n783 VDD=VDD
+ VSS=VSS
XU1225 aoi22d1 $PINS A1=copt_net_874 A2=n789 B1=stage[93] B2=n788 ZN=n782
+ VDD=VDD VSS=VSS
XU1226 nd02d0 $PINS A1=n783 A2=n782 ZN=N_uc_427 VDD=VDD VSS=VSS
XU1227 aoi22d1 $PINS A1=copt_net_992 A2=n789 B1=copt_net_986 B2=n797 ZN=n784
+ VDD=VDD VSS=VSS
XU1228 nd02d0 $PINS A1=n785 A2=n784 ZN=N_uc_426 VDD=VDD VSS=VSS
XU1229 aoi22d1 $PINS A1=stage[63] A2=n787 B1=copt_net_926 B2=n786 ZN=n791
+ VDD=VDD VSS=VSS
XU1230 aoi22d1 $PINS A1=copt_net_891 A2=n789 B1=stage[95] B2=n788 ZN=n790
+ VDD=VDD VSS=VSS
XU1231 nd02d0 $PINS A1=n791 A2=n790 ZN=N_uc_425 VDD=VDD VSS=VSS
XU1232 oai222d1 $PINS A1=n43 A2=n110 B1=n63 B2=n889 C1=n40 C2=n107
+ ZN=total_beats[0] VDD=VDD VSS=VSS
XU1233 nd02d0 $PINS A1=kind_lat[1] A2=n836 ZN=n904 VDD=VDD VSS=VSS
Xcopt_h_inst_3696 dl02d1 $PINS I=stage[105] Z=copt_net_864 VDD=VDD VSS=VSS
Xcopt_h_inst_3697 dl02d1 $PINS I=stage[90] Z=copt_net_865 VDD=VDD VSS=VSS
Xcopt_h_inst_3700 dl02d1 $PINS I=stage[42] Z=copt_net_868 VDD=VDD VSS=VSS
XU1237 nd03d1 $PINS A1=n840 A2=n841 A3=n842 ZN=n888 VDD=VDD VSS=VSS
XU1238 nd02d1 $PINS A1=n888 A2=copt_net_2732 ZN=n857 VDD=VDD VSS=VSS
XU1239 nd02d1 $PINS A1=n857 A2=n119 ZN=n849 VDD=VDD VSS=VSS
XU1240 nd02d1 $PINS A1=n849 A2=copt_net_2732 ZN=n855 VDD=VDD VSS=VSS
Xcopt_h_inst_3701 dl02d1 $PINS I=stage[93] Z=copt_net_869 VDD=VDD VSS=VSS
XU1242 oai21d1 $PINS B1=beat_idx[0] B2=n855 A=n849 ZN=n846 VDD=VDD VSS=VSS
XU1243 oaim22d1 $PINS A1=n847 A2=n855 B1=n846 B2=copt_net_2719 ZN=n293 VDD=VDD
+ VSS=VSS
XU1244 nd02d1 $PINS A1=copt_net_2719 A2=n67 ZN=n848 VDD=VDD VSS=VSS
Xcopt_h_inst_3703 dl02d1 $PINS I=stage[44] Z=copt_net_871 VDD=VDD VSS=VSS
XU1246 oai21d1 $PINS B1=n851 B2=n855 A=n849 ZN=n854 VDD=VDD VSS=VSS
XU1247 oaim22d1 $PINS A1=copt_net_2804 A2=n855 B1=n854 B2=copt_net_2728 ZN=n341
+ VDD=VDD VSS=VSS
XU1248 xr03d1 $PINS A1=w_load_n[1] A2=w_load_n[0] A3=n639 Z=n870 VDD=VDD
+ VSS=VSS
XU1249 oai31d1 $PINS B1=n871 B2=n868 B3=n870 A=copt_net_2732 ZN=n861 VDD=VDD
+ VSS=VSS
XU1250 nd02d1 $PINS A1=n869 A2=n119 ZN=n866 VDD=VDD VSS=VSS
XU1251 nd03d1 $PINS A1=copt_net_2688 A2=n858 A3=n866 ZN=n862 VDD=VDD VSS=VSS
XU1252 nd02d1 $PINS A1=n858 A2=n638 ZN=n865 VDD=VDD VSS=VSS
XU1253 nd02d1 $PINS A1=n866 A2=n865 ZN=n860 VDD=VDD VSS=VSS
XU1254 nr02d1 $PINS A1=n862 A2=n639 ZN=n863 VDD=VDD VSS=VSS
XU1255 nd02d1 $PINS A1=n875 A2=n874 ZN=n880 VDD=VDD VSS=VSS
XU1256 nd03d1 $PINS A1=copt_net_2666 A2=copt_net_2732 A3=n875 ZN=n879 VDD=VDD
+ VSS=VSS
XU1257 nd03d1 $PINS A1=copt_net_2666 A2=N_uc_25 A3=n885 ZN=n884 VDD=VDD VSS=VSS
XU1258 nr02d1 $PINS A1=n884 A2=n883 ZN=N_uc_300 VDD=VDD VSS=VSS
XU1259 nd02d1 $PINS A1=n885 A2=copt_net_2666 ZN=n886 VDD=VDD VSS=VSS
Xcopt_h_inst_3705 dl02d1 $PINS I=stage[123] Z=copt_net_873 VDD=VDD VSS=VSS
XU1261 xr02d1 $PINS A1=n36 A2=n887 Z=N_uc_297 VDD=VDD VSS=VSS
XU1262 nr02d0 $PINS A1=n41 A2=n893 ZN=mult_117_n10 VDD=VDD VSS=VSS
XU1263 nr02d0 $PINS A1=n41 A2=n894 ZN=mult_117_n11 VDD=VDD VSS=VSS
XU1264 nr02d0 $PINS A1=w_load_n[2] A2=n42 ZN=mult_117_n12 VDD=VDD VSS=VSS
XU1265 nr02d0 $PINS A1=n893 A2=n42 ZN=mult_117_n13 VDD=VDD VSS=VSS
XU1266 nr02d0 $PINS A1=n894 A2=n42 ZN=mult_117_n14 VDD=VDD VSS=VSS
XU1267 nr02d0 $PINS A1=w_load_n[2] A2=n43 ZN=mult_117_n15 VDD=VDD VSS=VSS
XU1268 nr02d0 $PINS A1=n43 A2=n893 ZN=mult_117_n16 VDD=VDD VSS=VSS
XU1269 nr02d0 $PINS A1=n41 A2=w_load_n[2] ZN=n891 VDD=VDD VSS=VSS
Xcopt_h_inst_3706 dl02d1 $PINS I=stage[125] Z=copt_net_874 VDD=VDD VSS=VSS
XU1271 nr02d0 $PINS A1=total_beats[1] A2=total_beats[0] ZN=n895 VDD=VDD VSS=VSS
Xcopt_h_inst_3711 dl02d1 $PINS I=stage[91] Z=copt_net_879 VDD=VDD VSS=VSS
XU1273 nd02d0 $PINS A1=n895 A2=n890 ZN=n896 VDD=VDD VSS=VSS
XU1274 oai21d1 $PINS B1=n890 B2=n895 A=n896 ZN=N_uc_68 VDD=VDD VSS=VSS
XU1275 nr02d0 $PINS A1=total_beats[3] A2=n896 ZN=n897 VDD=VDD VSS=VSS
Xcopt_h_inst_3714 dl02d1 $PINS I=stage[65] Z=copt_net_882 VDD=VDD VSS=VSS
Xcopt_h_inst_3715 dl02d1 $PINS I=stage[32] Z=copt_net_883 VDD=VDD VSS=VSS
Xcopt_h_inst_3721 dl02d1 $PINS I=stage[76] Z=copt_net_889 VDD=VDD VSS=VSS
Xcopt_h_inst_3722 dl02d1 $PINS I=stage[58] Z=copt_net_890 VDD=VDD VSS=VSS
Xcopt_h_inst_3723 dl02d1 $PINS I=stage[127] Z=copt_net_891 VDD=VDD VSS=VSS
Xcopt_h_inst_3724 dl02d1 $PINS I=stage[88] Z=copt_net_892 VDD=VDD VSS=VSS
Xcopt_h_inst_3725 dl02d1 $PINS I=stage[49] Z=copt_net_893 VDD=VDD VSS=VSS
Xcopt_h_inst_3728 dl02d1 $PINS I=stage[45] Z=copt_net_896 VDD=VDD VSS=VSS
Xcopt_h_inst_3729 dl02d1 $PINS I=stage[51] Z=copt_net_897 VDD=VDD VSS=VSS
Xcopt_h_inst_3730 dl02d1 $PINS I=stage[47] Z=copt_net_898 VDD=VDD VSS=VSS
Xcopt_h_inst_3731 dl02d1 $PINS I=stage[109] Z=copt_net_899 VDD=VDD VSS=VSS
Xcopt_h_inst_3732 dl02d1 $PINS I=stage[34] Z=copt_net_900 VDD=VDD VSS=VSS
Xcopt_h_inst_3735 dl02d1 $PINS I=stage[78] Z=copt_net_903 VDD=VDD VSS=VSS
Xcopt_h_inst_3736 dl02d1 $PINS I=stage[48] Z=copt_net_904 VDD=VDD VSS=VSS
Xcopt_h_inst_3738 dl02d1 $PINS I=stage[38] Z=copt_net_906 VDD=VDD VSS=VSS
Xcopt_h_inst_3740 dl02d1 $PINS I=stage[16] Z=copt_net_908 VDD=VDD VSS=VSS
Xcopt_h_inst_3741 dl02d1 $PINS I=stage[23] Z=copt_net_909 VDD=VDD VSS=VSS
Xcopt_h_inst_3742 dl02d1 $PINS I=stage[103] Z=copt_net_910 VDD=VDD VSS=VSS
Xcopt_h_inst_3744 dl02d1 $PINS I=stage[72] Z=copt_net_912 VDD=VDD VSS=VSS
Xcopt_h_inst_3745 dl02d1 $PINS I=stage[64] Z=copt_net_913 VDD=VDD VSS=VSS
Xcopt_h_inst_3746 dl02d1 $PINS I=stage[68] Z=copt_net_914 VDD=VDD VSS=VSS
Xcopt_h_inst_3749 dl02d1 $PINS I=stage[80] Z=copt_net_917 VDD=VDD VSS=VSS
Xcopt_h_inst_3750 dl02d1 $PINS I=stage[19] Z=copt_net_918 VDD=VDD VSS=VSS
Xcopt_h_inst_3752 dl02d1 $PINS I=stage[111] Z=copt_net_920 VDD=VDD VSS=VSS
Xcopt_h_inst_3754 dl02d1 $PINS I=stage[24] Z=copt_net_922 VDD=VDD VSS=VSS
Xcopt_h_inst_3756 dl02d1 $PINS I=stage[25] Z=copt_net_924 VDD=VDD VSS=VSS
Xcopt_h_inst_3757 dl02d1 $PINS I=stage[28] Z=copt_net_925 VDD=VDD VSS=VSS
Xcopt_h_inst_3758 dl02d1 $PINS I=stage[31] Z=copt_net_926 VDD=VDD VSS=VSS
Xcopt_h_inst_3760 dl02d1 $PINS I=stage[113] Z=copt_net_928 VDD=VDD VSS=VSS
Xcopt_h_inst_3761 dl02d1 $PINS I=stage[85] Z=copt_net_929 VDD=VDD VSS=VSS
Xcopt_h_inst_3763 dl02d1 $PINS I=stage[20] Z=copt_net_931 VDD=VDD VSS=VSS
Xcopt_h_inst_3765 dl02d1 $PINS I=stage[89] Z=copt_net_933 VDD=VDD VSS=VSS
Xcopt_h_inst_3766 dl02d1 $PINS I=stage[121] Z=copt_net_934 VDD=VDD VSS=VSS
Xcopt_h_inst_3768 dl02d1 $PINS I=stage[95] Z=copt_net_936 VDD=VDD VSS=VSS
Xcopt_h_inst_3769 dl02d1 $PINS I=stage[74] Z=copt_net_937 VDD=VDD VSS=VSS
Xcopt_h_inst_3770 dl02d1 $PINS I=stage[33] Z=copt_net_938 VDD=VDD VSS=VSS
Xcopt_h_inst_3771 dl02d1 $PINS I=stage[116] Z=copt_net_939 VDD=VDD VSS=VSS
Xcopt_h_inst_3772 dl02d1 $PINS I=stage[0] Z=copt_net_940 VDD=VDD VSS=VSS
Xcopt_h_inst_3775 dl02d1 $PINS I=stage[77] Z=copt_net_943 VDD=VDD VSS=VSS
Xcopt_h_inst_3780 dl02d1 $PINS I=stage[119] Z=copt_net_948 VDD=VDD VSS=VSS
Xcopt_h_inst_3782 dl02d1 $PINS I=stage[108] Z=copt_net_950 VDD=VDD VSS=VSS
Xcopt_h_inst_3784 dl02d1 $PINS I=stage[112] Z=copt_net_952 VDD=VDD VSS=VSS
Xcopt_h_inst_3785 dl02d1 $PINS I=stage[50] Z=copt_net_953 VDD=VDD VSS=VSS
Xcopt_h_inst_3790 dl02d1 $PINS I=stage[46] Z=copt_net_958 VDD=VDD VSS=VSS
Xcopt_h_inst_3791 dl02d1 $PINS I=stage[10] Z=copt_net_959 VDD=VDD VSS=VSS
Xcopt_h_inst_3792 dl02d1 $PINS I=stage[73] Z=copt_net_960 VDD=VDD VSS=VSS
Xcopt_h_inst_3793 dl02d1 $PINS I=stage[82] Z=copt_net_961 VDD=VDD VSS=VSS
Xcopt_h_inst_3795 dl02d1 $PINS I=stage[84] Z=copt_net_963 VDD=VDD VSS=VSS
Xcopt_h_inst_3797 dl02d1 $PINS I=stage[39] Z=copt_net_965 VDD=VDD VSS=VSS
Xcopt_h_inst_3798 dl02d1 $PINS I=stage[124] Z=copt_net_966 VDD=VDD VSS=VSS
Xcopt_h_inst_3799 dl02d1 $PINS I=stage[79] Z=copt_net_967 VDD=VDD VSS=VSS
Xcopt_h_inst_3800 dl02d1 $PINS I=stage[37] Z=copt_net_968 VDD=VDD VSS=VSS
Xcopt_h_inst_3805 dl02d1 $PINS I=stage[92] Z=copt_net_973 VDD=VDD VSS=VSS
Xcopt_h_inst_3808 dl02d1 $PINS I=stage[107] Z=copt_net_976 VDD=VDD VSS=VSS
Xcopt_h_inst_3809 dl02d1 $PINS I=stage[12] Z=copt_net_977 VDD=VDD VSS=VSS
Xcopt_h_inst_3810 dl01d1 $PINS I=stage[62] Z=copt_net_978 VDD=VDD VSS=VSS
Xcopt_h_inst_3812 dl02d1 $PINS I=stage[106] Z=copt_net_980 VDD=VDD VSS=VSS
Xcopt_h_inst_3813 dl02d1 $PINS I=stage[114] Z=copt_net_981 VDD=VDD VSS=VSS
Xcopt_h_inst_3814 dl02d1 $PINS I=stage[110] Z=copt_net_982 VDD=VDD VSS=VSS
Xcopt_h_inst_3816 dl02d1 $PINS I=stage[18] Z=copt_net_984 VDD=VDD VSS=VSS
Xcopt_h_inst_3818 dl01d1 $PINS I=stage[94] Z=copt_net_986 VDD=VDD VSS=VSS
Xcopt_h_inst_3820 dl02d1 $PINS I=stage[14] Z=copt_net_988 VDD=VDD VSS=VSS
Xcopt_h_inst_3824 dl01d1 $PINS I=stage[126] Z=copt_net_992 VDD=VDD VSS=VSS
Xcopt_h_inst_3825 dl02d1 $PINS I=stage[52] Z=copt_net_993 VDD=VDD VSS=VSS
Xcopt_h_inst_3827 dl02d1 $PINS I=stage[75] Z=copt_net_995 VDD=VDD VSS=VSS
Xcopt_h_inst_3829 dl02d1 $PINS I=stage[60] Z=copt_net_997 VDD=VDD VSS=VSS
Xcopt_h_inst_3831 dl02d1 $PINS I=stage[56] Z=copt_net_999 VDD=VDD VSS=VSS
Xcopt_h_inst_3834 dl02d1 $PINS I=stage[118] Z=copt_net_1002 VDD=VDD VSS=VSS
Xcopt_h_inst_3835 dl02d1 $PINS I=stage[54] Z=copt_net_1003 VDD=VDD VSS=VSS
Xcopt_h_inst_3844 dl02d1 $PINS I=stage[22] Z=copt_net_1012 VDD=VDD VSS=VSS
Xcopt_h_inst_3845 dl02d1 $PINS I=stage[87] Z=copt_net_1013 VDD=VDD VSS=VSS
Xcopt_h_inst_3847 dl01d1 $PINS I=stage[30] Z=copt_net_1015 VDD=VDD VSS=VSS
Xcopt_h_inst_3851 dl02d1 $PINS I=stage[4] Z=copt_net_1019 VDD=VDD VSS=VSS
Xcopt_h_inst_3857 dl01d1 $PINS I=stage[100] Z=copt_net_1025 VDD=VDD VSS=VSS
Xcopt_h_inst_3859 dl02d1 $PINS I=stage[120] Z=copt_net_1027 VDD=VDD VSS=VSS
Xcopt_h_inst_3861 dl02d1 $PINS I=stage[86] Z=copt_net_1029 VDD=VDD VSS=VSS
Xcopt_h_inst_3863 dl02d1 $PINS I=stage[101] Z=copt_net_1031 VDD=VDD VSS=VSS
Xcopt_h_inst_3864 dl02d1 $PINS I=stage[11] Z=copt_net_1032 VDD=VDD VSS=VSS
Xcopt_h_inst_3870 dl02d1 $PINS I=stage[122] Z=copt_net_1038 VDD=VDD VSS=VSS
Xcopt_h_inst_3878 dl01d1 $PINS I=job_k[0] Z=copt_net_1046 VDD=VDD VSS=VSS
Xcopt_h_inst_3900 dl01d1 $PINS I=stage[104] Z=copt_net_1068 VDD=VDD VSS=VSS
Xcopt_h_inst_3904 dl01d1 $PINS I=stage[43] Z=copt_net_1072 VDD=VDD VSS=VSS
Xcopt_h_inst_3945 dl01d1 $PINS I=stage[41] Z=copt_net_1113 VDD=VDD VSS=VSS
Xcopt_h_inst_4041 dl01d1 $PINS I=stage[55] Z=copt_net_1209 VDD=VDD VSS=VSS
Xcopt_h_inst_4087 dl01d1 $PINS I=stage[63] Z=copt_net_1255 VDD=VDD VSS=VSS
Xcopt_h_inst_4126 dl01d1 $PINS I=job_n[0] Z=copt_net_1294 VDD=VDD VSS=VSS
Xcopt_h_inst_4281 dl01d1 $PINS I=job_k[1] Z=copt_net_1449 VDD=VDD VSS=VSS
Xcopt_h_inst_4364 dl02d1 $PINS I=base_lat[19] Z=copt_net_1532 VDD=VDD VSS=VSS
Xcopt_h_inst_4392 dl02d1 $PINS I=base_lat[20] Z=copt_net_1560 VDD=VDD VSS=VSS
Xcopt_h_inst_4529 dl02d1 $PINS I=base_lat[17] Z=copt_net_1697 VDD=VDD VSS=VSS
Xcopt_h_inst_4536 dl01d1 $PINS I=base_lat[21] Z=copt_net_1704 VDD=VDD VSS=VSS
Xcopt_h_inst_4537 dl01d1 $PINS I=base_lat[1] Z=copt_net_1705 VDD=VDD VSS=VSS
Xcopt_h_inst_4569 dl02d1 $PINS I=base_lat[0] Z=copt_net_1737 VDD=VDD VSS=VSS
Xcopt_h_inst_4576 dl02d1 $PINS I=base_lat[4] Z=copt_net_1744 VDD=VDD VSS=VSS
Xcopt_h_inst_4651 dl01d1 $PINS I=base_lat[22] Z=copt_net_1819 VDD=VDD VSS=VSS
Xcopt_h_inst_4659 dl02d1 $PINS I=base_lat[25] Z=copt_net_1827 VDD=VDD VSS=VSS
Xcopt_h_inst_4671 dl02d1 $PINS I=base_lat[9] Z=copt_net_1839 VDD=VDD VSS=VSS
Xcopt_h_inst_4679 dl02d1 $PINS I=base_lat[27] Z=copt_net_1847 VDD=VDD VSS=VSS
Xcopt_h_inst_4722 dl02d1 $PINS I=base_lat[8] Z=copt_net_1890 VDD=VDD VSS=VSS
Xcopt_h_inst_4724 dl02d1 $PINS I=base_lat[5] Z=copt_net_1892 VDD=VDD VSS=VSS
Xcopt_h_inst_4748 dl02d1 $PINS I=base_lat[23] Z=copt_net_1916 VDD=VDD VSS=VSS
Xcopt_h_inst_4755 dl02d1 $PINS I=base_lat[29] Z=copt_net_1923 VDD=VDD VSS=VSS
Xcopt_h_inst_4799 dl02d1 $PINS I=base_lat[18] Z=copt_net_1966 VDD=VDD VSS=VSS
Xcopt_h_inst_4811 dl02d1 $PINS I=base_lat[15] Z=copt_net_1978 VDD=VDD VSS=VSS
Xcopt_h_inst_4814 dl02d1 $PINS I=base_lat[16] Z=copt_net_1981 VDD=VDD VSS=VSS
Xcopt_h_inst_4824 dl02d1 $PINS I=base_lat[24] Z=copt_net_1991 VDD=VDD VSS=VSS
Xcopt_h_inst_4835 dl02d1 $PINS I=base_lat[26] Z=copt_net_2002 VDD=VDD VSS=VSS
Xcopt_h_inst_4843 dl02d1 $PINS I=base_lat[14] Z=copt_net_2010 VDD=VDD VSS=VSS
Xcopt_h_inst_4858 dl02d1 $PINS I=base_lat[12] Z=copt_net_2025 VDD=VDD VSS=VSS
Xcopt_h_inst_4870 dl02d1 $PINS I=base_lat[10] Z=copt_net_2037 VDD=VDD VSS=VSS
Xcopt_h_inst_4916 dl01d1 $PINS I=cur_m_2_ Z=copt_net_2083 VDD=VDD VSS=VSS
Xcopt_h_inst_4922 dl01d1 $PINS I=base_lat[11] Z=copt_net_2089 VDD=VDD VSS=VSS
Xcopt_h_inst_5018 dl01d1 $PINS I=base_lat[3] Z=copt_net_2185 VDD=VDD VSS=VSS
Xcopt_h_inst_5021 dl01d1 $PINS I=base_lat[28] Z=copt_net_2188 VDD=VDD VSS=VSS
Xcopt_h_inst_5029 dl01d1 $PINS I=base_lat[2] Z=copt_net_2196 VDD=VDD VSS=VSS
Xcopt_h_inst_5040 dl01d1 $PINS I=a_load_m[2] Z=copt_net_2207 VDD=VDD VSS=VSS
Xcopt_h_inst_5102 dl01d1 $PINS I=n39 Z=copt_net_2269 VDD=VDD VSS=VSS
Xcopt_h_inst_5164 dl01d1 $PINS I=aps_rename_27_ Z=w_load_n[0] VDD=VDD VSS=VSS
Xcopt_h_inst_5227 dl02d1 $PINS I=n305 Z=copt_net_2394 VDD=VDD VSS=VSS
Xcopt_h_inst_5241 dl01d1 $PINS I=kind_lat[0] Z=copt_net_2408 VDD=VDD VSS=VSS
Xcopt_h_inst_5242 dl02d1 $PINS I=n44 Z=copt_net_2409 VDD=VDD VSS=VSS
Xcopt_h_inst_5250 dl01d1 $PINS I=aps_rename_25_ Z=a_load_k[0] VDD=VDD VSS=VSS
Xcopt_h_inst_5256 dl02d1 $PINS I=kind_lat[1] Z=copt_net_2423 VDD=VDD VSS=VSS
Xcopt_h_inst_5322 dl01d1 $PINS I=aps_rename_1_ Z=copt_net_2489 VDD=VDD VSS=VSS
Xcopt_h_inst_5340 dl01d1 $PINS I=job_base_addr[8] Z=copt_net_2507 VDD=VDD
+ VSS=VSS
Xcopt_h_inst_5345 dl01d1 $PINS I=aps_rename_26_ Z=w_load_n[1] VDD=VDD VSS=VSS
Xcopt_h_inst_5370 dl01d1 $PINS I=base_lat[6] Z=copt_net_2537 VDD=VDD VSS=VSS
Xcopt_h_inst_5385 dl02d1 $PINS I=base_lat[7] Z=copt_net_2552 VDD=VDD VSS=VSS
Xgre_a_INV_88_inst_5819 inv0d0 $PINS I=n156 ZN=gre_a_INV_88_3 VDD=VDD VSS=VSS
Xcopt_h_inst_5420 buffd1 $PINS I=n36 Z=copt_net_2587 VDD=VDD VSS=VSS
Xcopt_h_inst_5449 dl02d1 $PINS I=base_lat[30] Z=copt_net_2616 VDD=VDD VSS=VSS
Xcopt_h_inst_5450 dl01d1 $PINS I=job_base_addr[19] Z=copt_net_2617 VDD=VDD
+ VSS=VSS
Xgre_a_INV_364_inst_5820 inv0d0 $PINS I=n156 ZN=gre_a_INV_364_3 VDD=VDD VSS=VSS
Xgre_a_INV_177_inst_5821 inv0d0 $PINS I=n156 ZN=gre_a_INV_177_3 VDD=VDD VSS=VSS
Xgre_a_INV_150_inst_5822 inv0d0 $PINS I=n156 ZN=gre_a_INV_150_3 VDD=VDD VSS=VSS
Xcopt_h_inst_5494 dl02d1 $PINS I=job_n[1] Z=copt_net_2661 VDD=VDD VSS=VSS
Xgre_a_INV_772_inst_5823 inv0d0 $PINS I=n156 ZN=gre_a_INV_772_3 VDD=VDD VSS=VSS
Xcopt_h_inst_5499 dl01d1 $PINS I=N_uc_24 Z=copt_net_2666 VDD=VDD VSS=VSS
Xcopt_h_inst_5521 dl01d1 $PINS I=N_uc_295 Z=copt_net_2688 VDD=VDD VSS=VSS
Xcopt_h_inst_5529 buffd1 $PINS I=beat_idx[1] Z=copt_net_2696 VDD=VDD VSS=VSS
Xcopt_h_inst_5538 dl01d2 $PINS I=N_uc_296 Z=copt_net_2705 VDD=VDD VSS=VSS
Xcopt_h_inst_5552 buffd1 $PINS I=beat_idx[2] Z=copt_net_2719 VDD=VDD VSS=VSS
Xcopt_h_inst_5561 dl01d1 $PINS I=beat_idx[4] Z=copt_net_2728 VDD=VDD VSS=VSS
Xcopt_h_inst_5565 dl01d1 $PINS I=n113 Z=copt_net_2732 VDD=VDD VSS=VSS
Xcopt_h_inst_5595 dl01d1 $PINS I=n37 Z=copt_net_2762 VDD=VDD VSS=VSS
Xcopt_h_inst_5599 dl01d1 $PINS I=job_base_addr[16] Z=copt_net_2766 VDD=VDD
+ VSS=VSS
Xcopt_h_inst_5637 dl01d1 $PINS I=n856 Z=copt_net_2804 VDD=VDD VSS=VSS
Xcopt_h_inst_5645 buffd1 $PINS I=n38 Z=copt_net_2811 VDD=VDD VSS=VSS
Xcopt_h_inst_5662 dl01d1 $PINS I=job_base_addr[23] Z=copt_net_2828 VDD=VDD
+ VSS=VSS
Xcopt_h_inst_5665 dl01d1 $PINS I=n42 Z=copt_net_2831 VDD=VDD VSS=VSS
Xgre_a_INV_1535_inst_5824 inv0d0 $PINS I=n156 ZN=gre_a_INV_1535_3 VDD=VDD
+ VSS=VSS
Xgre_a_INV_1704_inst_5825 inv0d0 $PINS I=n156 ZN=gre_a_INV_1704_3 VDD=VDD
+ VSS=VSS
Xgre_a_INV_2111_inst_5826 inv0d0 $PINS I=n156 ZN=gre_a_INV_2111_3 VDD=VDD
+ VSS=VSS
Xcopt_h_inst_5676 buffd1 $PINS I=a_load_m[0] Z=copt_net_2842 VDD=VDD VSS=VSS
Xcopt_h_inst_5689 dl01d1 $PINS I=n340 Z=copt_net_2855 VDD=VDD VSS=VSS
Xcopt_h_inst_5690 dl01d1 $PINS I=n294 Z=copt_net_2856 VDD=VDD VSS=VSS
Xcopt_h_inst_5691 dl01d1 $PINS I=n335 Z=copt_net_2857 VDD=VDD VSS=VSS
Xcopt_h_inst_5711 dl01d1 $PINS I=n339 Z=copt_net_2877 VDD=VDD VSS=VSS
Xcopt_h_inst_5712 dl01d1 $PINS I=n330 Z=copt_net_2878 VDD=VDD VSS=VSS
Xcopt_h_inst_5720 dl01d1 $PINS I=n293 Z=copt_net_2886 VDD=VDD VSS=VSS
Xcopt_h_inst_5723 dl01d1 $PINS I=n314 Z=copt_net_2889 VDD=VDD VSS=VSS
Xcopt_h_inst_5726 dl01d1 $PINS I=job_base_addr[4] Z=copt_net_2892 VDD=VDD
+ VSS=VSS
Xcopt_h_inst_5732 dl01d1 $PINS I=n295 Z=copt_net_2898 VDD=VDD VSS=VSS
Xcopt_h_inst_5735 buffd1 $PINS I=n315 Z=copt_net_2901 VDD=VDD VSS=VSS
Xcopt_h_inst_5739 buffd1 $PINS I=job_base_addr[20] Z=copt_net_2905 VDD=VDD
+ VSS=VSS
Xcopt_h_inst_5742 dl01d1 $PINS I=n161 Z=copt_net_2908 VDD=VDD VSS=VSS
Xcopt_h_inst_5743 buffd1 $PINS I=n308 Z=copt_net_2909 VDD=VDD VSS=VSS
Xgre_a_INV_32_inst_5827 inv0d0 $PINS I=n156 ZN=gre_a_INV_32_3 VDD=VDD VSS=VSS
Xcopt_h_inst_5754 buffd1 $PINS I=n333 Z=copt_net_2920 VDD=VDD VSS=VSS
Xcopt_h_inst_5758 buffd1 $PINS I=n334 Z=copt_net_2924 VDD=VDD VSS=VSS
Xcopt_h_inst_5776 buffd1 $PINS I=aps_rename_24_ Z=dma_valid VDD=VDD VSS=VSS
Xgre_a_INV_14_inst_5828 inv0d0 $PINS I=n156 ZN=gre_a_INV_14_3 VDD=VDD VSS=VSS
Xgre_a_INV_3758_inst_5829 inv0d0 $PINS I=n156 ZN=gre_a_INV_3758_3 VDD=VDD
+ VSS=VSS
.ENDS

.SUBCKT unpu_seq ZCTSNET_202 rst_n start dim_m[2] dim_m[1] dim_m[0] dim_n[2]
+ dim_n[1] dim_n[0] dim_k[2] dim_k[1] dim_k[0] mode_unsigned src_a[31]
+ src_a[30] src_a[29] src_a[28] src_a[27] src_a[26] src_a[25] src_a[24]
+ src_a[23] src_a[22] src_a[21] src_a[20] src_a[19] src_a[18] src_a[17]
+ src_a[16] src_a[15] src_a[14] src_a[13] src_a[12] src_a[11] src_a[10]
+ src_a[9] src_a[8] src_a[7] src_a[6] src_a[5] src_a[4] src_a[3] src_a[2]
+ src_a[1] src_a[0] src_b[31] src_b[30] src_b[29] src_b[28] src_b[27] src_b[26]
+ src_b[25] src_b[24] src_b[23] src_b[22] src_b[21] src_b[20] src_b[19]
+ src_b[18] src_b[17] src_b[16] src_b[15] src_b[14] src_b[13] src_b[12]
+ src_b[11] src_b[10] src_b[9] src_b[8] src_b[7] src_b[6] src_b[5] src_b[4]
+ src_b[3] src_b[2] src_b[1] src_b[0] dest_c[31] dest_c[30] dest_c[29]
+ dest_c[28] dest_c[27] dest_c[26] dest_c[25] dest_c[24] dest_c[23] dest_c[22]
+ dest_c[21] dest_c[20] dest_c[19] dest_c[18] dest_c[17] dest_c[16] dest_c[15]
+ dest_c[14] dest_c[13] dest_c[12] dest_c[11] dest_c[10] dest_c[9] dest_c[8]
+ dest_c[7] dest_c[6] dest_c[5] dest_c[4] dest_c[3] dest_c[2] dest_c[1]
+ dest_c[0] c_dst[511] c_dst[510] c_dst[509] c_dst[508] c_dst[507] c_dst[506]
+ c_dst[505] c_dst[504] c_dst[503] c_dst[502] c_dst[501] c_dst[500] c_dst[499]
+ c_dst[498] c_dst[497] c_dst[496] c_dst[495] c_dst[494] c_dst[493] c_dst[492]
+ c_dst[491] c_dst[490] c_dst[489] c_dst[488] c_dst[487] c_dst[486] c_dst[485]
+ c_dst[484] c_dst[483] c_dst[482] c_dst[481] c_dst[480] c_dst[479] c_dst[478]
+ c_dst[477] c_dst[476] c_dst[475] c_dst[474] c_dst[473] c_dst[472] c_dst[471]
+ c_dst[470] c_dst[469] c_dst[468] c_dst[467] c_dst[466] c_dst[465] c_dst[464]
+ c_dst[463] c_dst[462] c_dst[461] c_dst[460] c_dst[459] c_dst[458] c_dst[457]
+ c_dst[456] c_dst[455] c_dst[454] c_dst[453] c_dst[452] c_dst[451] c_dst[450]
+ c_dst[449] c_dst[448] c_dst[447] c_dst[446] c_dst[445] c_dst[444] c_dst[443]
+ c_dst[442] c_dst[441] c_dst[440] c_dst[439] c_dst[438] c_dst[437] c_dst[436]
+ c_dst[435] c_dst[434] c_dst[433] c_dst[432] c_dst[431] c_dst[430] c_dst[429]
+ c_dst[428] c_dst[427] c_dst[426] c_dst[425] c_dst[424] c_dst[423] c_dst[422]
+ c_dst[421] c_dst[420] c_dst[419] c_dst[418] c_dst[417] c_dst[416] c_dst[415]
+ c_dst[414] c_dst[413] c_dst[412] c_dst[411] c_dst[410] c_dst[409] c_dst[408]
+ c_dst[407] c_dst[406] c_dst[405] c_dst[404] c_dst[403] c_dst[402] c_dst[401]
+ c_dst[400] c_dst[399] c_dst[398] c_dst[397] c_dst[396] c_dst[395] c_dst[394]
+ c_dst[393] c_dst[392] c_dst[391] c_dst[390] c_dst[389] c_dst[388] c_dst[387]
+ c_dst[386] c_dst[385] c_dst[384] c_dst[383] c_dst[382] c_dst[381] c_dst[380]
+ c_dst[379] c_dst[378] c_dst[377] c_dst[376] c_dst[375] c_dst[374] c_dst[373]
+ c_dst[372] c_dst[371] c_dst[370] c_dst[369] c_dst[368] c_dst[367] c_dst[366]
+ c_dst[365] c_dst[364] c_dst[363] c_dst[362] c_dst[361] c_dst[360] c_dst[359]
+ c_dst[358] c_dst[357] c_dst[356] c_dst[355] c_dst[354] c_dst[353] c_dst[352]
+ c_dst[351] c_dst[350] c_dst[349] c_dst[348] c_dst[347] c_dst[346] c_dst[345]
+ c_dst[344] c_dst[343] c_dst[342] c_dst[341] c_dst[340] c_dst[339] c_dst[338]
+ c_dst[337] c_dst[336] c_dst[335] c_dst[334] c_dst[333] c_dst[332] c_dst[331]
+ c_dst[330] c_dst[329] c_dst[328] c_dst[327] c_dst[326] c_dst[325] c_dst[324]
+ c_dst[323] c_dst[322] c_dst[321] c_dst[320] c_dst[319] c_dst[318] c_dst[317]
+ c_dst[316] c_dst[315] c_dst[314] c_dst[313] c_dst[312] c_dst[311] c_dst[310]
+ c_dst[309] c_dst[308] c_dst[307] c_dst[306] c_dst[305] c_dst[304] c_dst[303]
+ c_dst[302] c_dst[301] c_dst[300] c_dst[299] c_dst[298] c_dst[297] c_dst[296]
+ c_dst[295] c_dst[294] c_dst[293] c_dst[292] c_dst[291] c_dst[290] c_dst[289]
+ c_dst[288] c_dst[287] c_dst[286] c_dst[285] c_dst[284] c_dst[283] c_dst[282]
+ c_dst[281] c_dst[280] c_dst[279] c_dst[278] c_dst[277] c_dst[276] c_dst[275]
+ c_dst[274] c_dst[273] c_dst[272] c_dst[271] c_dst[270] c_dst[269] c_dst[268]
+ c_dst[267] c_dst[266] c_dst[265] c_dst[264] c_dst[263] c_dst[262] c_dst[261]
+ c_dst[260] c_dst[259] c_dst[258] c_dst[257] c_dst[256] c_dst[255] c_dst[254]
+ c_dst[253] c_dst[252] c_dst[251] c_dst[250] c_dst[249] c_dst[248] c_dst[247]
+ c_dst[246] c_dst[245] c_dst[244] c_dst[243] c_dst[242] c_dst[241] c_dst[240]
+ c_dst[239] c_dst[238] c_dst[237] c_dst[236] c_dst[235] c_dst[234] c_dst[233]
+ c_dst[232] c_dst[231] c_dst[230] c_dst[229] c_dst[228] c_dst[227] c_dst[226]
+ c_dst[225] c_dst[224] c_dst[223] c_dst[222] c_dst[221] c_dst[220] c_dst[219]
+ c_dst[218] c_dst[217] c_dst[216] c_dst[215] c_dst[214] c_dst[213] c_dst[212]
+ c_dst[211] c_dst[210] c_dst[209] c_dst[208] c_dst[207] c_dst[206] c_dst[205]
+ c_dst[204] c_dst[203] c_dst[202] c_dst[201] c_dst[200] c_dst[199] c_dst[198]
+ c_dst[197] c_dst[196] c_dst[195] c_dst[194] c_dst[193] c_dst[192] c_dst[191]
+ c_dst[190] c_dst[189] c_dst[188] c_dst[187] c_dst[186] c_dst[185] c_dst[184]
+ c_dst[183] c_dst[182] c_dst[181] c_dst[180] c_dst[179] c_dst[178] c_dst[177]
+ c_dst[176] c_dst[175] c_dst[174] c_dst[173] c_dst[172] c_dst[171] c_dst[170]
+ c_dst[169] c_dst[168] c_dst[167] c_dst[166] c_dst[165] c_dst[164] c_dst[163]
+ c_dst[162] c_dst[161] c_dst[160] c_dst[159] c_dst[158] c_dst[157] c_dst[156]
+ c_dst[155] c_dst[154] c_dst[153] c_dst[152] c_dst[151] c_dst[150] c_dst[149]
+ c_dst[148] c_dst[147] c_dst[146] c_dst[145] c_dst[144] c_dst[143] c_dst[142]
+ c_dst[141] c_dst[140] c_dst[139] c_dst[138] c_dst[137] c_dst[136] c_dst[135]
+ c_dst[134] c_dst[133] c_dst[132] c_dst[131] c_dst[130] c_dst[129] c_dst[128]
+ c_dst[127] c_dst[126] c_dst[125] c_dst[124] c_dst[123] c_dst[122] c_dst[121]
+ c_dst[120] c_dst[119] c_dst[118] c_dst[117] c_dst[116] c_dst[115] c_dst[114]
+ c_dst[113] c_dst[112] c_dst[111] c_dst[110] c_dst[109] c_dst[108] c_dst[107]
+ c_dst[106] c_dst[105] c_dst[104] c_dst[103] c_dst[102] c_dst[101] c_dst[100]
+ c_dst[99] c_dst[98] c_dst[97] c_dst[96] c_dst[95] c_dst[94] c_dst[93]
+ c_dst[92] c_dst[91] c_dst[90] c_dst[89] c_dst[88] c_dst[87] c_dst[86]
+ c_dst[85] c_dst[84] c_dst[83] c_dst[82] c_dst[81] c_dst[80] c_dst[79]
+ c_dst[78] c_dst[77] c_dst[76] c_dst[75] c_dst[74] c_dst[73] c_dst[72]
+ c_dst[71] c_dst[70] c_dst[69] c_dst[68] c_dst[67] c_dst[66] c_dst[65]
+ c_dst[64] c_dst[63] c_dst[62] c_dst[61] c_dst[60] c_dst[59] c_dst[58]
+ c_dst[57] c_dst[56] c_dst[55] c_dst[54] c_dst[53] c_dst[52] c_dst[51]
+ c_dst[50] c_dst[49] c_dst[48] c_dst[47] c_dst[46] c_dst[45] c_dst[44]
+ c_dst[43] c_dst[42] c_dst[41] c_dst[40] c_dst[39] c_dst[38] c_dst[37]
+ c_dst[36] c_dst[35] c_dst[34] c_dst[33] c_dst[32] c_dst[31] c_dst[30]
+ c_dst[29] c_dst[28] c_dst[27] c_dst[26] c_dst[25] c_dst[24] c_dst[23]
+ c_dst[22] c_dst[21] c_dst[20] c_dst[19] c_dst[18] c_dst[17] c_dst[16]
+ c_dst[15] c_dst[14] c_dst[13] c_dst[12] c_dst[11] c_dst[10] c_dst[9] c_dst[8]
+ c_dst[7] c_dst[6] c_dst[5] c_dst[4] c_dst[3] c_dst[2] c_dst[1] c_dst[0] done
+ busy error error_code[2] error_code[1] error_code[0] array_en mode_unsigned_o
+ job_start job_kind[1] job_kind[0] job_base_addr[31] job_base_addr[30]
+ job_base_addr[29] job_base_addr[28] job_base_addr[27] job_base_addr[26]
+ job_base_addr[25] job_base_addr[24] job_base_addr[23] job_base_addr[22]
+ job_base_addr[21] job_base_addr[20] job_base_addr[19] job_base_addr[18]
+ job_base_addr[17] job_base_addr[16] job_base_addr[15] job_base_addr[14]
+ job_base_addr[13] job_base_addr[12] job_base_addr[11] job_base_addr[10]
+ job_base_addr[9] job_base_addr[8] job_base_addr[7] job_base_addr[6]
+ job_base_addr[5] job_base_addr[4] job_base_addr[3] job_base_addr[2]
+ job_base_addr[1] job_base_addr[0] job_m[2] job_m[1] job_m[0] job_n[2]
+ job_n[1] job_n[0] job_k[2] job_k[1] job_k[0] job_done w_swap a_swap rd_row[1]
+ rd_row[0] c_in[127] c_in[126] c_in[125] c_in[124] c_in[123] c_in[122]
+ c_in[121] c_in[120] c_in[119] c_in[118] c_in[117] c_in[116] c_in[115]
+ c_in[114] c_in[113] c_in[112] c_in[111] c_in[110] c_in[109] c_in[108]
+ c_in[107] c_in[106] c_in[105] c_in[104] c_in[103] c_in[102] c_in[101]
+ c_in[100] c_in[99] c_in[98] c_in[97] c_in[96] c_in[95] c_in[94] c_in[93]
+ c_in[92] c_in[91] c_in[90] c_in[89] c_in[88] c_in[87] c_in[86] c_in[85]
+ c_in[84] c_in[83] c_in[82] c_in[81] c_in[80] c_in[79] c_in[78] c_in[77]
+ c_in[76] c_in[75] c_in[74] c_in[73] c_in[72] c_in[71] c_in[70] c_in[69]
+ c_in[68] c_in[67] c_in[66] c_in[65] c_in[64] c_in[63] c_in[62] c_in[61]
+ c_in[60] c_in[59] c_in[58] c_in[57] c_in[56] c_in[55] c_in[54] c_in[53]
+ c_in[52] c_in[51] c_in[50] c_in[49] c_in[48] c_in[47] c_in[46] c_in[45]
+ c_in[44] c_in[43] c_in[42] c_in[41] c_in[40] c_in[39] c_in[38] c_in[37]
+ c_in[36] c_in[35] c_in[34] c_in[33] c_in[32] c_in[31] c_in[30] c_in[29]
+ c_in[28] c_in[27] c_in[26] c_in[25] c_in[24] c_in[23] c_in[22] c_in[21]
+ c_in[20] c_in[19] c_in[18] c_in[17] c_in[16] c_in[15] c_in[14] c_in[13]
+ c_in[12] c_in[11] c_in[10] c_in[9] c_in[8] c_in[7] c_in[6] c_in[5] c_in[4]
+ c_in[3] c_in[2] c_in[1] c_in[0] VDD VSS ZCTSNET_204 ZCTSNET_206 ZCTSNET_207
+ ZCTSNET_208 ZCTSNET_8 ZCTSNET_210 ZCTSNET_211 ZCTSNET_212 ZCTSNET_216
+ ZCTSNET_217 ZCTSNET_218 ZCTSNET_219 ZCTSNET_220 ZCTSNET_221 HFSNET_171
+ HFSNET_174 HFSNET_176 HFSNET_177 HFSNET_178 HFSNET_180 HFSNET_183 HFSNET_184
+ HFSNET_185 HFSNET_186 HFSNET_188 HFSNET_191 HFSNET_194 HFSNET_195 HFSNET_196
+ HFSNET_199 HFSNET_200 HFSNET_201 ZCTSNET_4 ZCTSNET_6 ZCTSNET_11 ZCTSNET_12
+ ZCTSNET_13 ZCTSNET_17 ZCTSNET_18
*.CONNECT mode_unsigned_o HFSNET_171
Xcycle_reg_1_ dfcrn2 $PINS D=copt_net_610 CP=ZCTSNET_219 CDN=HFSNET_186 QN=n221
+ VDD=VDD VSS=VSS
XU5 oaim211d1 $PINS C1=n33 C2=cycle[2] A=n34 B=n945 ZN=n31 VDD=VDD VSS=VSS
XU6 oai21d1 $PINS B1=cycle[2] B2=n33 A=n952 ZN=n34 VDD=VDD VSS=VSS
XU7 aon211d1 $PINS C1=aps_rename_22_ C2=n941 B=n37 A=job_m[1] ZN=n33 VDD=VDD
+ VSS=VSS
XU8 or02d0 $PINS A1=copt_net_1063 A2=n38 Z=n220 VDD=VDD VSS=VSS
XU10 oaim22d1 $PINS A1=n40 A2=HFSNET_53 B1=copt_net_782 B2=n40 ZN=n223 VDD=VDD
+ VSS=VSS
XU11 oaim22d1 $PINS A1=HFSNET_153 A2=HFSNET_64 B1=copt_net_1168 B2=HFSNET_153
+ ZN=n224 VDD=VDD VSS=VSS
XU12 oaim22d1 $PINS A1=HFSNET_153 A2=n937 B1=copt_net_855 B2=HFSNET_153 ZN=n225
+ VDD=VDD VSS=VSS
XU13 oaim22d1 $PINS A1=HFSNET_153 A2=HFSNET_72 B1=copt_net_760 B2=HFSNET_153
+ ZN=n226 VDD=VDD VSS=VSS
XU14 oaim22d1 $PINS A1=HFSNET_153 A2=n935 B1=copt_net_951 B2=HFSNET_153 ZN=n227
+ VDD=VDD VSS=VSS
XU17 oaim22d1 $PINS A1=HFSNET_156 A2=HFSNET_73 B1=copt_net_1507 B2=HFSNET_156
+ ZN=n230 VDD=VDD VSS=VSS
XU18 oaim22d1 $PINS A1=HFSNET_156 A2=copt_net_2565 B1=copt_net_1199
+ B2=HFSNET_156 ZN=n231 VDD=VDD VSS=VSS
XU19 oaim22d1 $PINS A1=HFSNET_156 A2=HFSNET_74 B1=copt_net_1517 B2=HFSNET_156
+ ZN=n232 VDD=VDD VSS=VSS
XU20 oaim22d1 $PINS A1=HFSNET_156 A2=HFSNET_54 B1=copt_net_1616 B2=HFSNET_156
+ ZN=n233 VDD=VDD VSS=VSS
XU21 oaim22d1 $PINS A1=HFSNET_156 A2=n928 B1=copt_net_1139 B2=HFSNET_156
+ ZN=n234 VDD=VDD VSS=VSS
XU22 oaim22d1 $PINS A1=HFSNET_156 A2=HFSNET_55 B1=copt_net_1461 B2=HFSNET_156
+ ZN=n235 VDD=VDD VSS=VSS
XU23 oaim22d1 $PINS A1=HFSNET_156 A2=HFSNET_56 B1=copt_net_1312 B2=HFSNET_156
+ ZN=n236 VDD=VDD VSS=VSS
XU24 oaim22d1 $PINS A1=HFSNET_156 A2=n925 B1=copt_net_1062 B2=HFSNET_156
+ ZN=n237 VDD=VDD VSS=VSS
XU25 oaim22d1 $PINS A1=HFSNET_156 A2=HFSNET_57 B1=copt_net_1099 B2=HFSNET_156
+ ZN=n238 VDD=VDD VSS=VSS
XU26 oaim22d1 $PINS A1=HFSNET_153 A2=HFSNET_58 B1=copt_net_1712 B2=HFSNET_153
+ ZN=n239 VDD=VDD VSS=VSS
XU27 oaim22d1 $PINS A1=HFSNET_156 A2=n922 B1=copt_net_768 B2=HFSNET_156 ZN=n240
+ VDD=VDD VSS=VSS
XctmTdsLR_1_1306 mx02d1 $PINS I0=c_in[18] I1=copt_net_1210 S=HFSNET_136 Z=n497
+ VDD=VDD VSS=VSS
XU29 oaim22d1 $PINS A1=HFSNET_153 A2=HFSNET_63 B1=copt_net_1743 B2=HFSNET_153
+ ZN=n242 VDD=VDD VSS=VSS
XU30 oaim22d1 $PINS A1=HFSNET_153 A2=copt_gre_net_2956 B1=copt_net_790
+ B2=HFSNET_153 ZN=n243 VDD=VDD VSS=VSS
XU31 oaim22d1 $PINS A1=HFSNET_153 A2=copt_gre_net_2954 B1=copt_net_787
+ B2=HFSNET_153 ZN=n244 VDD=VDD VSS=VSS
XU32 oaim22d1 $PINS A1=HFSNET_153 A2=n917 B1=copt_net_974 B2=HFSNET_153 ZN=n245
+ VDD=VDD VSS=VSS
XU33 oaim22d1 $PINS A1=HFSNET_156 A2=HFSNET_65 B1=copt_net_1207 B2=HFSNET_156
+ ZN=n246 VDD=VDD VSS=VSS
XU34 oaim22d1 $PINS A1=HFSNET_154 A2=n915 B1=copt_net_1044 B2=HFSNET_154
+ ZN=n247 VDD=VDD VSS=VSS
XU35 oaim22d1 $PINS A1=HFSNET_154 A2=HFSNET_66 B1=copt_net_2698 B2=HFSNET_154
+ ZN=n248 VDD=VDD VSS=VSS
XU36 oaim22d1 $PINS A1=HFSNET_154 A2=HFSNET_67 B1=copt_net_1589 B2=HFSNET_154
+ ZN=n249 VDD=VDD VSS=VSS
XU37 oaim22d1 $PINS A1=HFSNET_154 A2=HFSNET_68 B1=copt_net_1770 B2=HFSNET_154
+ ZN=n250 VDD=VDD VSS=VSS
XU38 oaim22d1 $PINS A1=HFSNET_154 A2=HFSNET_69 B1=copt_net_2248 B2=HFSNET_154
+ ZN=n251 VDD=VDD VSS=VSS
XU39 oaim22d1 $PINS A1=HFSNET_154 A2=HFSNET_70 B1=copt_net_1577 B2=HFSNET_154
+ ZN=n252 VDD=VDD VSS=VSS
XU40 oaim22d1 $PINS A1=HFSNET_154 A2=HFSNET_71 B1=copt_net_1078 B2=HFSNET_154
+ ZN=n253 VDD=VDD VSS=VSS
XU41 oaim22d1 $PINS A1=HFSNET_154 A2=HFSNET_47 B1=copt_net_2741 B2=HFSNET_154
+ ZN=n254 VDD=VDD VSS=VSS
XU42 oaim22d1 $PINS A1=HFSNET_154 A2=HFSNET_75 B1=copt_net_1213 B2=HFSNET_154
+ ZN=n255 VDD=VDD VSS=VSS
XU43 oaim22d1 $PINS A1=HFSNET_155 A2=n906 B1=copt_net_1198 B2=HFSNET_155
+ ZN=n256 VDD=VDD VSS=VSS
XU44 oaim22d1 $PINS A1=HFSNET_154 A2=HFSNET_95 B1=copt_net_1702 B2=HFSNET_154
+ ZN=n257 VDD=VDD VSS=VSS
XU46 oaim22d1 $PINS A1=HFSNET_154 A2=HFSNET_98 B1=copt_net_1859 B2=HFSNET_154
+ ZN=n259 VDD=VDD VSS=VSS
XU47 oaim22d1 $PINS A1=HFSNET_155 A2=n902 B1=copt_net_1105 B2=HFSNET_155
+ ZN=n260 VDD=VDD VSS=VSS
XU48 oaim22d1 $PINS A1=HFSNET_155 A2=n901 B1=copt_net_2372 B2=HFSNET_155
+ ZN=n261 VDD=VDD VSS=VSS
XU49 oaim22d1 $PINS A1=HFSNET_155 A2=HFSNET_99 B1=c_dst[39] B2=HFSNET_155
+ ZN=n262 VDD=VDD VSS=VSS
XU50 oaim22d1 $PINS A1=HFSNET_154 A2=HFSNET_100 B1=c_dst[40] B2=HFSNET_154
+ ZN=n263 VDD=VDD VSS=VSS
XU51 oaim22d1 $PINS A1=HFSNET_155 A2=HFSNET_101 B1=copt_net_2389 B2=HFSNET_155
+ ZN=n264 VDD=VDD VSS=VSS
XU52 oaim22d1 $PINS A1=HFSNET_158 A2=HFSNET_76 B1=copt_net_1987 B2=HFSNET_158
+ ZN=n265 VDD=VDD VSS=VSS
XU53 oaim22d1 $PINS A1=HFSNET_155 A2=HFSNET_77 B1=copt_net_1235 B2=HFSNET_155
+ ZN=n266 VDD=VDD VSS=VSS
XU54 oaim22d1 $PINS A1=HFSNET_155 A2=HFSNET_78 B1=copt_net_1239 B2=HFSNET_155
+ ZN=n267 VDD=VDD VSS=VSS
XU55 oaim22d1 $PINS A1=HFSNET_155 A2=HFSNET_79 B1=copt_net_1179 B2=HFSNET_155
+ ZN=n268 VDD=VDD VSS=VSS
XU56 oaim22d1 $PINS A1=HFSNET_155 A2=HFSNET_80 B1=copt_net_1925 B2=HFSNET_155
+ ZN=n269 VDD=VDD VSS=VSS
XU57 oaim22d1 $PINS A1=HFSNET_155 A2=HFSNET_81 B1=copt_net_1848 B2=HFSNET_155
+ ZN=n270 VDD=VDD VSS=VSS
XU58 oaim22d1 $PINS A1=HFSNET_155 A2=HFSNET_82 B1=copt_net_1153 B2=HFSNET_155
+ ZN=n271 VDD=VDD VSS=VSS
XU59 oaim22d1 $PINS A1=HFSNET_158 A2=HFSNET_83 B1=copt_net_2373 B2=HFSNET_158
+ ZN=n272 VDD=VDD VSS=VSS
XU60 oaim22d1 $PINS A1=HFSNET_158 A2=HFSNET_84 B1=copt_net_2416 B2=HFSNET_158
+ ZN=n273 VDD=VDD VSS=VSS
XU61 oaim22d1 $PINS A1=HFSNET_153 A2=HFSNET_85 B1=copt_net_2744 B2=HFSNET_153
+ ZN=n274 VDD=VDD VSS=VSS
XU62 oaim22d1 $PINS A1=n40 A2=HFSNET_86 B1=copt_net_2390 B2=n40 ZN=n275 VDD=VDD
+ VSS=VSS
XU63 oaim22d1 $PINS A1=HFSNET_156 A2=HFSNET_87 B1=copt_net_2433 B2=HFSNET_156
+ ZN=n276 VDD=VDD VSS=VSS
XU64 oaim22d1 $PINS A1=HFSNET_153 A2=HFSNET_88 B1=copt_net_2407 B2=HFSNET_153
+ ZN=n277 VDD=VDD VSS=VSS
XU65 oaim22d1 $PINS A1=n40 A2=copt_net_1399 B1=copt_net_2411 B2=n40 ZN=n278
+ VDD=VDD VSS=VSS
XU66 oaim22d1 $PINS A1=n40 A2=copt_net_2174 B1=copt_net_1456 B2=n40 ZN=n279
+ VDD=VDD VSS=VSS
XU67 oaim22d1 $PINS A1=n40 A2=HFSNET_91 B1=copt_net_2395 B2=n40 ZN=n280 VDD=VDD
+ VSS=VSS
XU68 oaim22d1 $PINS A1=n40 A2=HFSNET_92 B1=copt_net_1349 B2=n40 ZN=n281 VDD=VDD
+ VSS=VSS
XU69 oaim22d1 $PINS A1=n40 A2=HFSNET_93 B1=copt_net_815 B2=n40 ZN=n282 VDD=VDD
+ VSS=VSS
XU70 oaim22d1 $PINS A1=n40 A2=HFSNET_94 B1=copt_net_796 B2=n40 ZN=n283 VDD=VDD
+ VSS=VSS
XU71 oaim22d1 $PINS A1=n40 A2=n878 B1=copt_net_1004 B2=n40 ZN=n284 VDD=VDD
+ VSS=VSS
XU72 oaim22d1 $PINS A1=HFSNET_152 A2=HFSNET_96 B1=copt_net_1362 B2=HFSNET_152
+ ZN=n285 VDD=VDD VSS=VSS
XU73 oaim22d1 $PINS A1=n40 A2=HFSNET_97 B1=copt_net_1196 B2=n40 ZN=n286 VDD=VDD
+ VSS=VSS
XU74 oaim22d1 $PINS A1=HFSNET_152 A2=HFSNET_102 B1=copt_net_1489 B2=HFSNET_152
+ ZN=n287 VDD=VDD VSS=VSS
XU75 oaim22d1 $PINS A1=HFSNET_152 A2=n874 B1=copt_net_1042 B2=HFSNET_152
+ ZN=n288 VDD=VDD VSS=VSS
XU76 oaim22d1 $PINS A1=HFSNET_152 A2=HFSNET_118 B1=copt_net_780 B2=HFSNET_152
+ ZN=n289 VDD=VDD VSS=VSS
XU77 oaim22d1 $PINS A1=n40 A2=HFSNET_121 B1=copt_net_1410 B2=n40 ZN=n290
+ VDD=VDD VSS=VSS
XU78 oaim22d1 $PINS A1=HFSNET_152 A2=HFSNET_122 B1=copt_net_1463 B2=HFSNET_152
+ ZN=n291 VDD=VDD VSS=VSS
XU79 oaim22d1 $PINS A1=HFSNET_152 A2=n870 B1=copt_net_1144 B2=HFSNET_152
+ ZN=n292 VDD=VDD VSS=VSS
XU80 oaim22d1 $PINS A1=HFSNET_152 A2=HFSNET_123 B1=copt_net_919 B2=HFSNET_152
+ ZN=n293 VDD=VDD VSS=VSS
XU81 oaim22d1 $PINS A1=HFSNET_152 A2=HFSNET_124 B1=copt_net_1354 B2=HFSNET_152
+ ZN=n294 VDD=VDD VSS=VSS
XU82 oaim22d1 $PINS A1=HFSNET_152 A2=HFSNET_51 B1=copt_net_1321 B2=HFSNET_152
+ ZN=n295 VDD=VDD VSS=VSS
XU83 oaim22d1 $PINS A1=HFSNET_152 A2=HFSNET_52 B1=copt_net_1318 B2=HFSNET_152
+ ZN=n296 VDD=VDD VSS=VSS
XU84 oaim22d1 $PINS A1=HFSNET_152 A2=HFSNET_103 B1=copt_net_1317 B2=HFSNET_152
+ ZN=n297 VDD=VDD VSS=VSS
XU85 oaim22d1 $PINS A1=HFSNET_152 A2=HFSNET_104 B1=copt_net_1520 B2=HFSNET_152
+ ZN=n298 VDD=VDD VSS=VSS
XU86 oaim22d1 $PINS A1=HFSNET_152 A2=n863 B1=copt_net_1135 B2=HFSNET_152
+ ZN=n299 VDD=VDD VSS=VSS
XU87 oaim22d1 $PINS A1=HFSNET_152 A2=HFSNET_105 B1=copt_net_1451 B2=HFSNET_152
+ ZN=n300 VDD=VDD VSS=VSS
XU88 oaim22d1 $PINS A1=HFSNET_158 A2=HFSNET_106 B1=copt_net_2103 B2=HFSNET_158
+ ZN=n301 VDD=VDD VSS=VSS
XU89 oaim22d1 $PINS A1=HFSNET_158 A2=HFSNET_107 B1=copt_net_2114 B2=HFSNET_158
+ ZN=n302 VDD=VDD VSS=VSS
XU90 oaim22d1 $PINS A1=HFSNET_158 A2=HFSNET_108 B1=copt_net_2085 B2=HFSNET_158
+ ZN=n303 VDD=VDD VSS=VSS
XU91 oaim22d1 $PINS A1=HFSNET_159 A2=HFSNET_109 B1=copt_net_1953 B2=HFSNET_159
+ ZN=n304 VDD=VDD VSS=VSS
XU92 oaim22d1 $PINS A1=HFSNET_159 A2=HFSNET_110 B1=copt_net_1973 B2=HFSNET_159
+ ZN=n305 VDD=VDD VSS=VSS
XU93 oaim22d1 $PINS A1=HFSNET_158 A2=HFSNET_111 B1=copt_net_1935 B2=HFSNET_158
+ ZN=n306 VDD=VDD VSS=VSS
XU94 oaim22d1 $PINS A1=HFSNET_158 A2=HFSNET_112 B1=copt_net_2046 B2=HFSNET_158
+ ZN=n307 VDD=VDD VSS=VSS
XU95 oaim22d1 $PINS A1=HFSNET_158 A2=HFSNET_113 B1=copt_net_2015 B2=HFSNET_158
+ ZN=n308 VDD=VDD VSS=VSS
XU96 oaim22d1 $PINS A1=HFSNET_158 A2=HFSNET_114 B1=copt_net_1779 B2=HFSNET_158
+ ZN=n309 VDD=VDD VSS=VSS
XU100 oaim22d1 $PINS A1=HFSNET_159 A2=HFSNET_116 B1=copt_net_1934 B2=HFSNET_159
+ ZN=n313 VDD=VDD VSS=VSS
XU101 oaim22d1 $PINS A1=HFSNET_159 A2=HFSNET_117 B1=copt_net_1786 B2=HFSNET_159
+ ZN=n314 VDD=VDD VSS=VSS
XU102 oaim22d1 $PINS A1=HFSNET_159 A2=n210 B1=copt_net_1167 B2=HFSNET_159
+ ZN=n315 VDD=VDD VSS=VSS
XU103 oaim22d1 $PINS A1=HFSNET_159 A2=n209 B1=copt_net_990 B2=HFSNET_159
+ ZN=n316 VDD=VDD VSS=VSS
XU104 oaim22d1 $PINS A1=HFSNET_159 A2=HFSNET_119 B1=copt_net_1841 B2=HFSNET_159
+ ZN=n317 VDD=VDD VSS=VSS
XU106 oaim22d1 $PINS A1=HFSNET_159 A2=copt_net_2288 B1=copt_net_2048
+ B2=HFSNET_159 ZN=n319 VDD=VDD VSS=VSS
XU107 oaim22d1 $PINS A1=HFSNET_159 A2=copt_net_2279 B1=copt_net_1474
+ B2=HFSNET_159 ZN=n320 VDD=VDD VSS=VSS
XU108 oaim22d1 $PINS A1=HFSNET_159 A2=copt_net_2280 B1=copt_net_1678
+ B2=HFSNET_159 ZN=n321 VDD=VDD VSS=VSS
XU109 oaim22d1 $PINS A1=HFSNET_159 A2=copt_net_2678 B1=copt_net_1053
+ B2=HFSNET_159 ZN=n322 VDD=VDD VSS=VSS
XU110 oaim22d1 $PINS A1=HFSNET_157 A2=copt_net_2316 B1=copt_net_1749
+ B2=HFSNET_157 ZN=n323 VDD=VDD VSS=VSS
XU111 oaim22d1 $PINS A1=HFSNET_157 A2=copt_net_2575 B1=copt_net_2026
+ B2=HFSNET_157 ZN=n324 VDD=VDD VSS=VSS
XU112 oaim22d1 $PINS A1=HFSNET_159 A2=n185 B1=copt_net_1215 B2=HFSNET_159
+ ZN=n325 VDD=VDD VSS=VSS
XU113 oaim22d1 $PINS A1=HFSNET_157 A2=copt_net_2436 B1=copt_net_2091
+ B2=HFSNET_157 ZN=n326 VDD=VDD VSS=VSS
XU114 oaim22d1 $PINS A1=HFSNET_157 A2=copt_net_2727 B1=copt_net_1000
+ B2=HFSNET_157 ZN=n327 VDD=VDD VSS=VSS
XU115 oaim22d1 $PINS A1=HFSNET_157 A2=copt_net_2272 B1=copt_net_1822
+ B2=HFSNET_157 ZN=n328 VDD=VDD VSS=VSS
XU116 oaim22d1 $PINS A1=HFSNET_157 A2=n168 B1=copt_net_1005 B2=HFSNET_157
+ ZN=n329 VDD=VDD VSS=VSS
XU117 oaim22d2 $PINS A1=HFSNET_157 A2=n167 B1=copt_net_1035 B2=HFSNET_157
+ ZN=n330 VDD=VDD VSS=VSS
XU118 oaim22d1 $PINS A1=HFSNET_157 A2=n166 B1=copt_net_1190 B2=HFSNET_157
+ ZN=n331 VDD=VDD VSS=VSS
XU119 oaim22d1 $PINS A1=HFSNET_157 A2=copt_net_2594 B1=copt_net_1277
+ B2=HFSNET_157 ZN=n332 VDD=VDD VSS=VSS
XU120 oaim22d1 $PINS A1=n40 A2=copt_net_2362 B1=copt_net_1370 B2=n40 ZN=n333
+ VDD=VDD VSS=VSS
XU121 oaim22d1 $PINS A1=HFSNET_157 A2=copt_net_2282 B1=copt_net_1918
+ B2=HFSNET_157 ZN=n334 VDD=VDD VSS=VSS
XU122 oaim22d1 $PINS A1=n40 A2=copt_net_2673 B1=copt_net_1194 B2=n40 ZN=n335
+ VDD=VDD VSS=VSS
XU123 oaim22d1 $PINS A1=HFSNET_157 A2=copt_net_2487 B1=copt_net_1774
+ B2=HFSNET_157 ZN=n336 VDD=VDD VSS=VSS
XU124 oaim22d1 $PINS A1=HFSNET_157 A2=copt_net_2335 B1=copt_net_1949
+ B2=HFSNET_157 ZN=n337 VDD=VDD VSS=VSS
XU126 oaim22d1 $PINS A1=HFSNET_157 A2=copt_net_2303 B1=copt_net_1829
+ B2=HFSNET_157 ZN=n339 VDD=VDD VSS=VSS
XU127 oaim22d1 $PINS A1=n40 A2=n157 B1=copt_net_1282 B2=n40 ZN=n340 VDD=VDD
+ VSS=VSS
XU129 oaim22d1 $PINS A1=HFSNET_157 A2=HFSNET_33 B1=copt_net_1633 B2=HFSNET_157
+ ZN=n342 VDD=VDD VSS=VSS
XU130 oaim22d1 $PINS A1=HFSNET_157 A2=copt_net_2646 B1=copt_net_1364
+ B2=HFSNET_157 ZN=n343 VDD=VDD VSS=VSS
XU131 oaim22d1 $PINS A1=HFSNET_157 A2=copt_net_2716 B1=copt_net_1175
+ B2=HFSNET_157 ZN=n344 VDD=VDD VSS=VSS
XU132 oaim22d1 $PINS A1=HFSNET_157 A2=copt_net_2329 B1=copt_net_1984
+ B2=HFSNET_157 ZN=n345 VDD=VDD VSS=VSS
XU133 oaim22d1 $PINS A1=HFSNET_152 A2=copt_net_2274 B1=copt_net_1885
+ B2=HFSNET_152 ZN=n346 VDD=VDD VSS=VSS
XU134 oaim22d1 $PINS A1=HFSNET_152 A2=copt_net_2311 B1=copt_net_1504
+ B2=HFSNET_152 ZN=n347 VDD=VDD VSS=VSS
XU136 oaim22d1 $PINS A1=HFSNET_152 A2=n148 B1=copt_net_803 B2=HFSNET_152
+ ZN=n349 VDD=VDD VSS=VSS
XU137 oaim22d1 $PINS A1=HFSNET_152 A2=n147 B1=copt_net_845 B2=HFSNET_152
+ ZN=n350 VDD=VDD VSS=VSS
XU139 oaim22d1 $PINS A1=HFSNET_53 A2=HFSNET_150 B1=copt_net_809 B2=HFSNET_150
+ ZN=n351 VDD=VDD VSS=VSS
XU140 oaim22d1 $PINS A1=HFSNET_64 A2=HFSNET_150 B1=copt_net_886 B2=HFSNET_150
+ ZN=n352 VDD=VDD VSS=VSS
XU141 oaim22d1 $PINS A1=n937 A2=HFSNET_150 B1=copt_net_817 B2=HFSNET_150
+ ZN=n353 VDD=VDD VSS=VSS
XU142 oaim22d1 $PINS A1=HFSNET_72 A2=HFSNET_150 B1=copt_net_844 B2=HFSNET_150
+ ZN=n354 VDD=VDD VSS=VSS
XU143 oaim22d1 $PINS A1=n935 A2=HFSNET_148 B1=copt_net_860 B2=HFSNET_148
+ ZN=n355 VDD=VDD VSS=VSS
XU144 oaim22d1 $PINS A1=n934 A2=HFSNET_148 B1=copt_net_1101 B2=HFSNET_148
+ ZN=n356 VDD=VDD VSS=VSS
XU145 oaim22d1 $PINS A1=n933 A2=HFSNET_149 B1=copt_net_759 B2=HFSNET_149
+ ZN=n357 VDD=VDD VSS=VSS
XU146 oaim22d1 $PINS A1=HFSNET_73 A2=HFSNET_148 B1=copt_net_1510 B2=HFSNET_148
+ ZN=n358 VDD=VDD VSS=VSS
XU147 oaim22d1 $PINS A1=copt_net_2565 A2=HFSNET_149 B1=copt_net_1164
+ B2=HFSNET_149 ZN=n359 VDD=VDD VSS=VSS
XU148 oaim22d1 $PINS A1=HFSNET_74 A2=HFSNET_148 B1=copt_net_1434 B2=HFSNET_148
+ ZN=n360 VDD=VDD VSS=VSS
XU149 oaim22d1 $PINS A1=HFSNET_54 A2=HFSNET_148 B1=copt_net_1569 B2=HFSNET_148
+ ZN=n361 VDD=VDD VSS=VSS
XU150 oaim22d1 $PINS A1=n928 A2=HFSNET_148 B1=copt_net_1084 B2=HFSNET_148
+ ZN=n362 VDD=VDD VSS=VSS
XU151 oaim22d1 $PINS A1=HFSNET_55 A2=HFSNET_148 B1=copt_net_1433 B2=HFSNET_148
+ ZN=n363 VDD=VDD VSS=VSS
XU152 oaim22d1 $PINS A1=HFSNET_56 A2=HFSNET_148 B1=copt_net_1270 B2=HFSNET_148
+ ZN=n364 VDD=VDD VSS=VSS
XU153 oaim22d1 $PINS A1=n925 A2=HFSNET_148 B1=copt_net_996 B2=HFSNET_148
+ ZN=n365 VDD=VDD VSS=VSS
XU154 oaim22d1 $PINS A1=HFSNET_57 A2=HFSNET_148 B1=copt_net_1066 B2=HFSNET_148
+ ZN=n366 VDD=VDD VSS=VSS
XU155 oaim22d1 $PINS A1=HFSNET_58 A2=HFSNET_148 B1=copt_net_1719 B2=HFSNET_148
+ ZN=n367 VDD=VDD VSS=VSS
XU156 oaim22d1 $PINS A1=n922 A2=HFSNET_148 B1=copt_net_877 B2=HFSNET_148
+ ZN=n368 VDD=VDD VSS=VSS
XctmTdsLR_1_1283 mx02d1 $PINS I0=c_in[18] I1=copt_net_1883 S=HFSNET_153 Z=n241
+ VDD=VDD VSS=VSS
XU158 oaim22d1 $PINS A1=HFSNET_63 A2=HFSNET_148 B1=copt_net_1778 B2=HFSNET_148
+ ZN=n370 VDD=VDD VSS=VSS
XU159 oaim22d1 $PINS A1=copt_gre_net_2956 A2=HFSNET_148 B1=copt_net_764
+ B2=HFSNET_148 ZN=n371 VDD=VDD VSS=VSS
XU160 oaim22d1 $PINS A1=copt_gre_net_2954 A2=HFSNET_148 B1=copt_net_784
+ B2=HFSNET_148 ZN=n372 VDD=VDD VSS=VSS
XU161 oaim22d1 $PINS A1=n917 A2=HFSNET_148 B1=copt_net_848 B2=HFSNET_148
+ ZN=n373 VDD=VDD VSS=VSS
XU162 oaim22d1 $PINS A1=HFSNET_65 A2=HFSNET_148 B1=copt_net_1216 B2=HFSNET_148
+ ZN=n374 VDD=VDD VSS=VSS
XU164 oaim22d1 $PINS A1=HFSNET_66 A2=HFSNET_149 B1=copt_net_1615 B2=HFSNET_149
+ ZN=n376 VDD=VDD VSS=VSS
XU165 oaim22d1 $PINS A1=HFSNET_67 A2=HFSNET_149 B1=copt_net_1554 B2=HFSNET_149
+ ZN=n377 VDD=VDD VSS=VSS
XU166 oaim22d1 $PINS A1=HFSNET_68 A2=HFSNET_149 B1=copt_net_1783 B2=HFSNET_149
+ ZN=n378 VDD=VDD VSS=VSS
XU167 oaim22d1 $PINS A1=HFSNET_69 A2=HFSNET_148 B1=copt_net_1485 B2=HFSNET_148
+ ZN=n379 VDD=VDD VSS=VSS
XU168 oaim22d1 $PINS A1=HFSNET_70 A2=HFSNET_149 B1=copt_net_1484 B2=HFSNET_149
+ ZN=n380 VDD=VDD VSS=VSS
XU169 oaim22d1 $PINS A1=HFSNET_71 A2=HFSNET_149 B1=copt_net_1071 B2=HFSNET_149
+ ZN=n381 VDD=VDD VSS=VSS
XU170 oaim22d1 $PINS A1=HFSNET_47 A2=HFSNET_149 B1=c_dst[159] B2=HFSNET_149
+ ZN=n382 VDD=VDD VSS=VSS
XU171 oaim22d1 $PINS A1=HFSNET_75 A2=n171 B1=copt_net_1059 B2=n171 ZN=n383
+ VDD=VDD VSS=VSS
XU172 oaim22d1 $PINS A1=n906 A2=HFSNET_146 B1=copt_net_1120 B2=HFSNET_146
+ ZN=n384 VDD=VDD VSS=VSS
XU173 oaim22d1 $PINS A1=HFSNET_95 A2=HFSNET_149 B1=copt_net_1637 B2=HFSNET_149
+ ZN=n385 VDD=VDD VSS=VSS
XctmTdsLR_1_1284 mx02d1 $PINS I0=copt_net_2256 I1=copt_net_1920 S=HFSNET_144
+ Z=n466 VDD=VDD VSS=VSS
XU175 oaim22d1 $PINS A1=HFSNET_98 A2=HFSNET_150 B1=copt_net_1165 B2=HFSNET_150
+ ZN=n387 VDD=VDD VSS=VSS
XU176 oaim22d1 $PINS A1=n902 A2=HFSNET_146 B1=copt_net_1058 B2=HFSNET_146
+ ZN=n388 VDD=VDD VSS=VSS
XU177 oaim22d1 $PINS A1=n901 A2=HFSNET_146 B1=copt_net_1878 B2=HFSNET_146
+ ZN=n389 VDD=VDD VSS=VSS
XU178 oaim22d1 $PINS A1=HFSNET_99 A2=HFSNET_150 B1=copt_net_1777 B2=HFSNET_150
+ ZN=n390 VDD=VDD VSS=VSS
XU179 oaim22d1 $PINS A1=HFSNET_100 A2=HFSNET_150 B1=copt_net_1708 B2=HFSNET_150
+ ZN=n391 VDD=VDD VSS=VSS
XU180 oaim22d1 $PINS A1=HFSNET_101 A2=HFSNET_147 B1=copt_net_1069 B2=HFSNET_147
+ ZN=n392 VDD=VDD VSS=VSS
XU181 oaim22d1 $PINS A1=HFSNET_76 A2=HFSNET_146 B1=copt_net_1899 B2=HFSNET_146
+ ZN=n393 VDD=VDD VSS=VSS
XU182 oaim22d1 $PINS A1=HFSNET_77 A2=HFSNET_147 B1=copt_net_1287 B2=HFSNET_147
+ ZN=n394 VDD=VDD VSS=VSS
XU183 oaim22d1 $PINS A1=HFSNET_78 A2=HFSNET_147 B1=copt_net_954 B2=HFSNET_147
+ ZN=n395 VDD=VDD VSS=VSS
XU184 oaim22d1 $PINS A1=HFSNET_79 A2=HFSNET_146 B1=copt_net_1193 B2=HFSNET_146
+ ZN=n396 VDD=VDD VSS=VSS
XU185 oaim22d1 $PINS A1=HFSNET_80 A2=n171 B1=copt_net_1597 B2=n171 ZN=n397
+ VDD=VDD VSS=VSS
XU186 oaim22d1 $PINS A1=HFSNET_81 A2=HFSNET_146 B1=copt_net_1801 B2=HFSNET_146
+ ZN=n398 VDD=VDD VSS=VSS
XU187 oaim22d1 $PINS A1=HFSNET_82 A2=HFSNET_149 B1=copt_net_1141 B2=HFSNET_149
+ ZN=n399 VDD=VDD VSS=VSS
XU188 oaim22d1 $PINS A1=HFSNET_83 A2=HFSNET_146 B1=copt_net_2364 B2=HFSNET_146
+ ZN=n400 VDD=VDD VSS=VSS
XU189 oaim22d1 $PINS A1=HFSNET_84 A2=HFSNET_148 B1=copt_net_2379 B2=HFSNET_148
+ ZN=n401 VDD=VDD VSS=VSS
XU190 oaim22d1 $PINS A1=HFSNET_85 A2=HFSNET_149 B1=c_dst[179] B2=HFSNET_149
+ ZN=n402 VDD=VDD VSS=VSS
XU191 oaim22d1 $PINS A1=HFSNET_86 A2=HFSNET_150 B1=copt_net_2363 B2=HFSNET_150
+ ZN=n403 VDD=VDD VSS=VSS
XU192 oaim22d1 $PINS A1=HFSNET_87 A2=HFSNET_149 B1=copt_net_2637 B2=HFSNET_149
+ ZN=n404 VDD=VDD VSS=VSS
XU193 oaim22d1 $PINS A1=HFSNET_88 A2=HFSNET_149 B1=copt_net_2610 B2=HFSNET_149
+ ZN=n405 VDD=VDD VSS=VSS
XU194 oaim22d1 $PINS A1=copt_net_1399 A2=HFSNET_149 B1=copt_net_2549
+ B2=HFSNET_149 ZN=n406 VDD=VDD VSS=VSS
XU195 oaim22d1 $PINS A1=copt_net_2174 A2=HFSNET_146 B1=copt_net_2710
+ B2=HFSNET_146 ZN=n407 VDD=VDD VSS=VSS
XU196 oaim22d1 $PINS A1=HFSNET_91 A2=HFSNET_149 B1=copt_net_2392 B2=HFSNET_149
+ ZN=n408 VDD=VDD VSS=VSS
XU197 oaim22d1 $PINS A1=HFSNET_92 A2=n171 B1=copt_net_1309 B2=n171 ZN=n409
+ VDD=VDD VSS=VSS
XU198 oaim22d1 $PINS A1=HFSNET_93 A2=n171 B1=copt_net_825 B2=n171 ZN=n410
+ VDD=VDD VSS=VSS
XU199 oaim22d1 $PINS A1=HFSNET_94 A2=n171 B1=copt_net_789 B2=n171 ZN=n411
+ VDD=VDD VSS=VSS
XU200 oaim22d1 $PINS A1=n878 A2=n171 B1=copt_net_941 B2=n171 ZN=n412 VDD=VDD
+ VSS=VSS
XU201 oaim22d1 $PINS A1=HFSNET_96 A2=n171 B1=copt_net_1443 B2=n171 ZN=n413
+ VDD=VDD VSS=VSS
XU202 oaim22d1 $PINS A1=HFSNET_97 A2=n171 B1=copt_net_1172 B2=n171 ZN=n414
+ VDD=VDD VSS=VSS
XU203 oaim22d1 $PINS A1=HFSNET_102 A2=n171 B1=copt_net_1470 B2=n171 ZN=n415
+ VDD=VDD VSS=VSS
XU205 oaim22d1 $PINS A1=HFSNET_118 A2=n171 B1=copt_net_799 B2=n171 ZN=n417
+ VDD=VDD VSS=VSS
XU206 oaim22d1 $PINS A1=HFSNET_121 A2=HFSNET_150 B1=copt_net_1548 B2=HFSNET_150
+ ZN=n418 VDD=VDD VSS=VSS
XU207 oaim22d1 $PINS A1=HFSNET_122 A2=n171 B1=copt_net_1427 B2=n171 ZN=n419
+ VDD=VDD VSS=VSS
XU209 oaim22d1 $PINS A1=HFSNET_123 A2=n171 B1=copt_net_902 B2=n171 ZN=n421
+ VDD=VDD VSS=VSS
XU210 oaim22d1 $PINS A1=HFSNET_124 A2=HFSNET_150 B1=copt_net_1022 B2=HFSNET_150
+ ZN=n422 VDD=VDD VSS=VSS
XU211 oaim22d1 $PINS A1=HFSNET_51 A2=n171 B1=copt_net_1448 B2=n171 ZN=n423
+ VDD=VDD VSS=VSS
XU212 oaim22d1 $PINS A1=HFSNET_52 A2=HFSNET_150 B1=copt_net_1438 B2=HFSNET_150
+ ZN=n424 VDD=VDD VSS=VSS
XU213 oaim22d1 $PINS A1=HFSNET_103 A2=n171 B1=copt_net_1300 B2=n171 ZN=n425
+ VDD=VDD VSS=VSS
XU214 oaim22d1 $PINS A1=HFSNET_104 A2=HFSNET_150 B1=copt_net_1043 B2=HFSNET_150
+ ZN=n426 VDD=VDD VSS=VSS
XU215 oaim22d1 $PINS A1=n863 A2=HFSNET_150 B1=copt_net_1091 B2=HFSNET_150
+ ZN=n427 VDD=VDD VSS=VSS
XU216 oaim22d1 $PINS A1=HFSNET_105 A2=n171 B1=copt_net_1447 B2=n171 ZN=n428
+ VDD=VDD VSS=VSS
XU217 oaim22d1 $PINS A1=HFSNET_106 A2=HFSNET_150 B1=copt_net_1870 B2=HFSNET_150
+ ZN=n429 VDD=VDD VSS=VSS
XU218 oaim22d1 $PINS A1=HFSNET_107 A2=HFSNET_147 B1=copt_net_1910 B2=HFSNET_147
+ ZN=n430 VDD=VDD VSS=VSS
XU219 oaim22d1 $PINS A1=HFSNET_108 A2=HFSNET_145 B1=copt_net_1240 B2=HFSNET_145
+ ZN=n431 VDD=VDD VSS=VSS
XU220 oaim22d1 $PINS A1=HFSNET_109 A2=HFSNET_150 B1=copt_net_1340 B2=HFSNET_150
+ ZN=n432 VDD=VDD VSS=VSS
XU221 oaim22d1 $PINS A1=HFSNET_110 A2=HFSNET_144 B1=copt_net_1119 B2=HFSNET_144
+ ZN=n433 VDD=VDD VSS=VSS
XU222 oaim22d1 $PINS A1=HFSNET_111 A2=HFSNET_145 B1=copt_net_1790 B2=HFSNET_145
+ ZN=n434 VDD=VDD VSS=VSS
XU223 oaim22d1 $PINS A1=HFSNET_112 A2=HFSNET_145 B1=copt_net_1205 B2=HFSNET_145
+ ZN=n435 VDD=VDD VSS=VSS
XU225 oaim22d1 $PINS A1=HFSNET_114 A2=n171 B1=copt_net_1673 B2=n171 ZN=n437
+ VDD=VDD VSS=VSS
XU226 oaim22d1 $PINS A1=n852 A2=HFSNET_145 B1=copt_net_1333 B2=HFSNET_145
+ ZN=n438 VDD=VDD VSS=VSS
XU227 oaim22d1 $PINS A1=HFSNET_115 A2=HFSNET_147 B1=copt_net_1246 B2=HFSNET_147
+ ZN=n439 VDD=VDD VSS=VSS
XU228 oaim22d1 $PINS A1=n850 A2=HFSNET_147 B1=copt_net_771 B2=HFSNET_147
+ ZN=n440 VDD=VDD VSS=VSS
XU229 oaim22d1 $PINS A1=HFSNET_116 A2=HFSNET_145 B1=copt_net_1876 B2=HFSNET_145
+ ZN=n441 VDD=VDD VSS=VSS
XU230 oaim22d1 $PINS A1=HFSNET_117 A2=HFSNET_147 B1=copt_net_1089 B2=HFSNET_147
+ ZN=n442 VDD=VDD VSS=VSS
XU233 oaim22d1 $PINS A1=HFSNET_119 A2=HFSNET_144 B1=copt_net_1457 B2=HFSNET_144
+ ZN=n445 VDD=VDD VSS=VSS
XU234 oaim22d1 $PINS A1=HFSNET_120 A2=HFSNET_144 B1=copt_net_1888 B2=HFSNET_144
+ ZN=n446 VDD=VDD VSS=VSS
XU235 oaim22d1 $PINS A1=copt_net_2288 A2=HFSNET_145 B1=copt_net_1952
+ B2=HFSNET_145 ZN=n447 VDD=VDD VSS=VSS
XU236 oaim22d1 $PINS A1=copt_net_2279 A2=HFSNET_145 B1=copt_net_1734
+ B2=HFSNET_145 ZN=n448 VDD=VDD VSS=VSS
XU237 oaim22d1 $PINS A1=copt_net_2280 A2=HFSNET_146 B1=copt_net_1887
+ B2=HFSNET_146 ZN=n449 VDD=VDD VSS=VSS
XU238 oaim22d1 $PINS A1=n194 A2=HFSNET_145 B1=copt_net_777 B2=HFSNET_145
+ ZN=n450 VDD=VDD VSS=VSS
XU239 oaim22d1 $PINS A1=copt_net_2316 A2=HFSNET_145 B1=copt_net_1266
+ B2=HFSNET_145 ZN=n451 VDD=VDD VSS=VSS
XU240 oaim22d1 $PINS A1=copt_net_2575 A2=HFSNET_145 B1=copt_net_2162
+ B2=HFSNET_145 ZN=n452 VDD=VDD VSS=VSS
XU241 oaim22d1 $PINS A1=n185 A2=HFSNET_145 B1=copt_net_1243 B2=HFSNET_145
+ ZN=n453 VDD=VDD VSS=VSS
XU242 oaim22d1 $PINS A1=copt_net_2436 A2=HFSNET_144 B1=copt_net_1325
+ B2=HFSNET_144 ZN=n454 VDD=VDD VSS=VSS
XU243 oaim22d1 $PINS A1=copt_net_2727 A2=HFSNET_144 B1=copt_net_818
+ B2=HFSNET_144 ZN=n455 VDD=VDD VSS=VSS
XU244 oaim22d1 $PINS A1=copt_net_2272 A2=HFSNET_145 B1=copt_net_1951
+ B2=HFSNET_145 ZN=n456 VDD=VDD VSS=VSS
XU245 oaim22d1 $PINS A1=ropt_net_3204 A2=HFSNET_147 B1=copt_net_975
+ B2=HFSNET_147 ZN=n457 VDD=VDD VSS=VSS
XU246 oaim22d1 $PINS A1=n167 A2=HFSNET_144 B1=copt_net_794 B2=HFSNET_144
+ ZN=n458 VDD=VDD VSS=VSS
XU248 oaim22d1 $PINS A1=copt_net_2595 A2=HFSNET_144 B1=copt_net_1182
+ B2=HFSNET_144 ZN=n460 VDD=VDD VSS=VSS
XU249 oaim22d1 $PINS A1=copt_net_2362 A2=HFSNET_144 B1=copt_net_1341
+ B2=HFSNET_144 ZN=n461 VDD=VDD VSS=VSS
XU250 oaim22d1 $PINS A1=copt_net_2282 A2=HFSNET_147 B1=copt_net_1304
+ B2=HFSNET_147 ZN=n462 VDD=VDD VSS=VSS
XU251 oaim22d1 $PINS A1=copt_net_2673 A2=HFSNET_144 B1=copt_net_857
+ B2=HFSNET_144 ZN=n463 VDD=VDD VSS=VSS
XU252 oaim22d1 $PINS A1=copt_net_2487 A2=HFSNET_144 B1=copt_net_1150
+ B2=HFSNET_144 ZN=n464 VDD=VDD VSS=VSS
XU253 oaim22d1 $PINS A1=copt_net_2335 A2=HFSNET_144 B1=copt_net_1313
+ B2=HFSNET_144 ZN=n465 VDD=VDD VSS=VSS
XctmTdsLR_1_1307 mx02d1 $PINS I0=c_in[35] I1=copt_net_2106 S=HFSNET_141 Z=n514
+ VDD=VDD VSS=VSS
XU255 oaim22d1 $PINS A1=copt_net_2303 A2=HFSNET_144 B1=copt_net_1250
+ B2=HFSNET_144 ZN=n467 VDD=VDD VSS=VSS
XU256 oaim22d1 $PINS A1=n157 A2=HFSNET_144 B1=copt_net_987 B2=HFSNET_144
+ ZN=n468 VDD=VDD VSS=VSS
XU257 oaim22d1 $PINS A1=copt_net_2474 A2=HFSNET_144 B1=copt_net_1147
+ B2=HFSNET_144 ZN=n469 VDD=VDD VSS=VSS
XU258 oaim22d1 $PINS A1=HFSNET_33 A2=HFSNET_145 B1=copt_net_1825 B2=HFSNET_145
+ ZN=n470 VDD=VDD VSS=VSS
XU259 oaim22d1 $PINS A1=copt_net_2646 A2=HFSNET_144 B1=copt_net_775
+ B2=HFSNET_144 ZN=n471 VDD=VDD VSS=VSS
XU260 oaim22d1 $PINS A1=n153 A2=HFSNET_147 B1=copt_net_1033 B2=HFSNET_147
+ ZN=n472 VDD=VDD VSS=VSS
XU261 oaim22d1 $PINS A1=copt_net_2329 A2=HFSNET_146 B1=copt_net_2098
+ B2=HFSNET_146 ZN=n473 VDD=VDD VSS=VSS
XU262 oaim22d1 $PINS A1=copt_net_2274 A2=HFSNET_150 B1=copt_net_1880
+ B2=HFSNET_150 ZN=n474 VDD=VDD VSS=VSS
XU263 oaim22d1 $PINS A1=copt_net_2311 A2=n171 B1=copt_net_1657 B2=n171 ZN=n475
+ VDD=VDD VSS=VSS
XU264 oaim22d1 $PINS A1=n149 A2=HFSNET_150 B1=copt_net_1148 B2=HFSNET_150
+ ZN=n476 VDD=VDD VSS=VSS
XU265 oaim22d1 $PINS A1=n148 A2=n171 B1=copt_net_793 B2=n171 ZN=n477 VDD=VDD
+ VSS=VSS
XU268 oaim22d1 $PINS A1=HFSNET_53 A2=HFSNET_141 B1=copt_net_1026 B2=HFSNET_141
+ ZN=n479 VDD=VDD VSS=VSS
XU269 oaim22d1 $PINS A1=HFSNET_64 A2=HFSNET_142 B1=copt_net_1094 B2=HFSNET_142
+ ZN=n480 VDD=VDD VSS=VSS
XU270 oaim22d1 $PINS A1=n937 A2=HFSNET_142 B1=copt_net_766 B2=HFSNET_142
+ ZN=n481 VDD=VDD VSS=VSS
XU271 oaim22d1 $PINS A1=HFSNET_72 A2=HFSNET_142 B1=copt_net_788 B2=HFSNET_142
+ ZN=n482 VDD=VDD VSS=VSS
XU272 oaim22d1 $PINS A1=n935 A2=HFSNET_142 B1=copt_net_835 B2=HFSNET_142
+ ZN=n483 VDD=VDD VSS=VSS
XU273 oaim22d1 $PINS A1=n934 A2=HFSNET_142 B1=copt_net_1100 B2=HFSNET_142
+ ZN=n484 VDD=VDD VSS=VSS
XU274 oaim22d1 $PINS A1=n933 A2=HFSNET_140 B1=copt_net_783 B2=HFSNET_140
+ ZN=n485 VDD=VDD VSS=VSS
XU275 oaim22d1 $PINS A1=HFSNET_73 A2=HFSNET_140 B1=copt_net_1581 B2=HFSNET_140
+ ZN=n486 VDD=VDD VSS=VSS
XU276 oaim22d1 $PINS A1=copt_net_2565 A2=HFSNET_140 B1=copt_net_1151
+ B2=HFSNET_140 ZN=n487 VDD=VDD VSS=VSS
XU277 oaim22d1 $PINS A1=HFSNET_74 A2=HFSNET_135 B1=copt_net_1382 B2=HFSNET_135
+ ZN=n488 VDD=VDD VSS=VSS
XU278 oaim22d1 $PINS A1=HFSNET_54 A2=HFSNET_141 B1=copt_net_1469 B2=HFSNET_141
+ ZN=n489 VDD=VDD VSS=VSS
XU279 oaim22d1 $PINS A1=n928 A2=HFSNET_140 B1=copt_net_1050 B2=HFSNET_140
+ ZN=n490 VDD=VDD VSS=VSS
XU280 oaim22d1 $PINS A1=HFSNET_55 A2=HFSNET_142 B1=copt_net_1431 B2=HFSNET_142
+ ZN=n491 VDD=VDD VSS=VSS
XU281 oaim22d1 $PINS A1=HFSNET_56 A2=HFSNET_137 B1=copt_net_1176 B2=HFSNET_137
+ ZN=n492 VDD=VDD VSS=VSS
XU282 oaim22d1 $PINS A1=n925 A2=HFSNET_140 B1=copt_net_1017 B2=HFSNET_140
+ ZN=n493 VDD=VDD VSS=VSS
XU283 oaim22d1 $PINS A1=HFSNET_57 A2=HFSNET_142 B1=copt_net_1057 B2=HFSNET_142
+ ZN=n494 VDD=VDD VSS=VSS
XU284 oaim22d1 $PINS A1=HFSNET_58 A2=HFSNET_140 B1=copt_net_1735 B2=HFSNET_140
+ ZN=n495 VDD=VDD VSS=VSS
XctmTdsLR_1_1355 aoim22d1 $PINS A1=cycle[3] A2=n216 B1=cycle[3] B2=n216 Z=n215
+ VDD=VDD VSS=VSS
XU287 oaim22d1 $PINS A1=HFSNET_63 A2=HFSNET_140 B1=copt_net_1867 B2=HFSNET_140
+ ZN=n498 VDD=VDD VSS=VSS
XU288 oaim22d1 $PINS A1=copt_gre_net_2956 A2=HFSNET_140 B1=copt_net_872
+ B2=HFSNET_140 ZN=n499 VDD=VDD VSS=VSS
XU289 oaim22d1 $PINS A1=copt_gre_net_2954 A2=HFSNET_142 B1=copt_net_881
+ B2=HFSNET_142 ZN=n500 VDD=VDD VSS=VSS
XU290 oaim22d1 $PINS A1=n917 A2=HFSNET_140 B1=copt_net_901 B2=HFSNET_140
+ ZN=n501 VDD=VDD VSS=VSS
XU291 oaim22d1 $PINS A1=HFSNET_65 A2=HFSNET_141 B1=copt_net_1180 B2=HFSNET_141
+ ZN=n502 VDD=VDD VSS=VSS
XU292 oaim22d1 $PINS A1=n915 A2=HFSNET_142 B1=copt_net_833 B2=HFSNET_142
+ ZN=n503 VDD=VDD VSS=VSS
XU293 oaim22d1 $PINS A1=HFSNET_66 A2=HFSNET_138 B1=copt_net_1324 B2=HFSNET_138
+ ZN=n504 VDD=VDD VSS=VSS
XU294 oaim22d1 $PINS A1=HFSNET_67 A2=HFSNET_138 B1=copt_net_1298 B2=HFSNET_138
+ ZN=n505 VDD=VDD VSS=VSS
XU295 oaim22d1 $PINS A1=HFSNET_68 A2=HFSNET_140 B1=copt_net_1824 B2=HFSNET_140
+ ZN=n506 VDD=VDD VSS=VSS
XU296 oaim22d1 $PINS A1=HFSNET_69 A2=HFSNET_135 B1=copt_net_1034 B2=HFSNET_135
+ ZN=n507 VDD=VDD VSS=VSS
XU297 oaim22d1 $PINS A1=HFSNET_70 A2=HFSNET_136 B1=copt_net_1088 B2=HFSNET_136
+ ZN=n508 VDD=VDD VSS=VSS
XU298 oaim22d1 $PINS A1=HFSNET_71 A2=HFSNET_136 B1=copt_net_985 B2=HFSNET_136
+ ZN=n509 VDD=VDD VSS=VSS
XU300 oaim22d1 $PINS A1=HFSNET_75 A2=HFSNET_142 B1=copt_net_927 B2=HFSNET_142
+ ZN=n511 VDD=VDD VSS=VSS
XU301 oaim22d1 $PINS A1=n906 A2=HFSNET_139 B1=copt_net_778 B2=HFSNET_139
+ ZN=n512 VDD=VDD VSS=VSS
XU302 oaim22d1 $PINS A1=HFSNET_95 A2=HFSNET_136 B1=copt_net_1067 B2=HFSNET_136
+ ZN=n513 VDD=VDD VSS=VSS
XctmTdsLR_1_1370 aoim22d1 $PINS A1=n945 A2=n184 B1=n945 B2=n184 Z=n176 VDD=VDD
+ VSS=VSS
XU304 oaim22d1 $PINS A1=HFSNET_98 A2=HFSNET_140 B1=copt_net_1136 B2=HFSNET_140
+ ZN=n515 VDD=VDD VSS=VSS
XU305 oaim22d1 $PINS A1=n902 A2=HFSNET_141 B1=copt_net_1093 B2=HFSNET_141
+ ZN=n516 VDD=VDD VSS=VSS
XU306 oaim22d1 $PINS A1=n901 A2=HFSNET_141 B1=copt_net_1850 B2=HFSNET_141
+ ZN=n517 VDD=VDD VSS=VSS
XU307 oaim22d1 $PINS A1=HFSNET_99 A2=HFSNET_136 B1=c_dst[295] B2=HFSNET_136
+ ZN=n518 VDD=VDD VSS=VSS
XU308 oaim22d1 $PINS A1=HFSNET_100 A2=HFSNET_141 B1=copt_net_1745 B2=HFSNET_141
+ ZN=n519 VDD=VDD VSS=VSS
XU309 oaim22d1 $PINS A1=HFSNET_101 A2=HFSNET_139 B1=copt_net_1571 B2=HFSNET_139
+ ZN=n520 VDD=VDD VSS=VSS
XU310 oaim22d1 $PINS A1=HFSNET_76 A2=HFSNET_140 B1=copt_net_1931 B2=HFSNET_140
+ ZN=n521 VDD=VDD VSS=VSS
XU311 oaim22d1 $PINS A1=HFSNET_77 A2=HFSNET_139 B1=copt_net_1278 B2=HFSNET_139
+ ZN=n522 VDD=VDD VSS=VSS
XU312 oaim22d1 $PINS A1=HFSNET_78 A2=HFSNET_139 B1=copt_net_1267 B2=HFSNET_139
+ ZN=n523 VDD=VDD VSS=VSS
XU313 oaim22d1 $PINS A1=HFSNET_79 A2=HFSNET_138 B1=copt_net_866 B2=HFSNET_138
+ ZN=n524 VDD=VDD VSS=VSS
XU314 oaim22d1 $PINS A1=HFSNET_80 A2=HFSNET_141 B1=copt_net_1558 B2=HFSNET_141
+ ZN=n525 VDD=VDD VSS=VSS
XU315 oaim22d1 $PINS A1=HFSNET_81 A2=HFSNET_136 B1=copt_net_962 B2=HFSNET_136
+ ZN=n526 VDD=VDD VSS=VSS
XU316 oaim22d1 $PINS A1=HFSNET_82 A2=HFSNET_141 B1=copt_net_1098 B2=HFSNET_141
+ ZN=n527 VDD=VDD VSS=VSS
XU317 oaim22d1 $PINS A1=HFSNET_83 A2=HFSNET_139 B1=copt_net_2371 B2=HFSNET_139
+ ZN=n528 VDD=VDD VSS=VSS
XU318 oaim22d1 $PINS A1=HFSNET_84 A2=HFSNET_141 B1=copt_net_2382 B2=HFSNET_141
+ ZN=n529 VDD=VDD VSS=VSS
XU319 oaim22d1 $PINS A1=HFSNET_85 A2=HFSNET_141 B1=copt_net_2743 B2=HFSNET_141
+ ZN=n530 VDD=VDD VSS=VSS
XU320 oaim22d1 $PINS A1=HFSNET_86 A2=HFSNET_141 B1=copt_net_2384 B2=HFSNET_141
+ ZN=n531 VDD=VDD VSS=VSS
XU321 oaim22d1 $PINS A1=HFSNET_87 A2=HFSNET_141 B1=copt_net_2431 B2=HFSNET_141
+ ZN=n532 VDD=VDD VSS=VSS
XU322 oaim22d1 $PINS A1=HFSNET_88 A2=HFSNET_142 B1=copt_net_1670 B2=HFSNET_142
+ ZN=n533 VDD=VDD VSS=VSS
XU323 oaim22d1 $PINS A1=copt_net_1399 A2=HFSNET_140 B1=copt_net_2210
+ B2=HFSNET_140 ZN=n534 VDD=VDD VSS=VSS
XU324 oaim22d1 $PINS A1=copt_net_2174 A2=HFSNET_135 B1=copt_net_1944
+ B2=HFSNET_135 ZN=n535 VDD=VDD VSS=VSS
XU325 oaim22d1 $PINS A1=HFSNET_91 A2=HFSNET_140 B1=copt_net_2380 B2=HFSNET_140
+ ZN=n536 VDD=VDD VSS=VSS
XU327 oaim22d1 $PINS A1=HFSNET_93 A2=HFSNET_140 B1=copt_net_1037 B2=HFSNET_140
+ ZN=n538 VDD=VDD VSS=VSS
XU328 oaim22d1 $PINS A1=HFSNET_94 A2=HFSNET_142 B1=copt_net_1030 B2=HFSNET_142
+ ZN=n539 VDD=VDD VSS=VSS
XU330 oaim22d1 $PINS A1=HFSNET_96 A2=HFSNET_142 B1=copt_net_1546 B2=HFSNET_142
+ ZN=n541 VDD=VDD VSS=VSS
XU331 oaim22d1 $PINS A1=HFSNET_97 A2=HFSNET_140 B1=copt_net_1782 B2=HFSNET_140
+ ZN=n542 VDD=VDD VSS=VSS
XU332 oaim22d1 $PINS A1=HFSNET_102 A2=HFSNET_139 B1=copt_net_1381 B2=HFSNET_139
+ ZN=n543 VDD=VDD VSS=VSS
XU333 oaim22d1 $PINS A1=n874 A2=HFSNET_136 B1=copt_net_1077 B2=HFSNET_136
+ ZN=n544 VDD=VDD VSS=VSS
XU334 oaim22d1 $PINS A1=HFSNET_118 A2=HFSNET_135 B1=copt_net_819 B2=HFSNET_135
+ ZN=n545 VDD=VDD VSS=VSS
XU335 oaim22d1 $PINS A1=HFSNET_121 A2=HFSNET_142 B1=copt_net_1537 B2=HFSNET_142
+ ZN=n546 VDD=VDD VSS=VSS
XU336 oaim22d1 $PINS A1=HFSNET_122 A2=HFSNET_141 B1=copt_net_1453 B2=HFSNET_141
+ ZN=n547 VDD=VDD VSS=VSS
XU337 oaim22d1 $PINS A1=n870 A2=HFSNET_135 B1=copt_net_1286 B2=HFSNET_135
+ ZN=n548 VDD=VDD VSS=VSS
XU338 oaim22d2 $PINS A1=HFSNET_123 A2=HFSNET_135 B1=copt_net_856 B2=HFSNET_135
+ ZN=n549 VDD=VDD VSS=VSS
XU339 oaim22d1 $PINS A1=HFSNET_124 A2=HFSNET_135 B1=copt_net_1353 B2=HFSNET_135
+ ZN=n550 VDD=VDD VSS=VSS
XU342 oaim22d1 $PINS A1=HFSNET_103 A2=HFSNET_136 B1=copt_net_998 B2=HFSNET_136
+ ZN=n553 VDD=VDD VSS=VSS
XU343 oaim22d1 $PINS A1=HFSNET_104 A2=HFSNET_136 B1=copt_net_1275 B2=HFSNET_136
+ ZN=n554 VDD=VDD VSS=VSS
XU345 oaim22d1 $PINS A1=HFSNET_105 A2=HFSNET_135 B1=copt_net_1424 B2=HFSNET_135
+ ZN=n556 VDD=VDD VSS=VSS
XU346 oaim22d1 $PINS A1=HFSNET_106 A2=HFSNET_139 B1=copt_net_2053 B2=HFSNET_139
+ ZN=n557 VDD=VDD VSS=VSS
XU347 oaim22d1 $PINS A1=HFSNET_107 A2=HFSNET_139 B1=copt_net_2111 B2=HFSNET_139
+ ZN=n558 VDD=VDD VSS=VSS
XU348 oaim22d1 $PINS A1=HFSNET_108 A2=HFSNET_139 B1=copt_net_1894 B2=HFSNET_139
+ ZN=n559 VDD=VDD VSS=VSS
XU349 oaim22d1 $PINS A1=HFSNET_109 A2=HFSNET_141 B1=copt_net_1648 B2=HFSNET_141
+ ZN=n560 VDD=VDD VSS=VSS
XU350 oaim22d1 $PINS A1=HFSNET_110 A2=HFSNET_138 B1=copt_net_1367 B2=HFSNET_138
+ ZN=n561 VDD=VDD VSS=VSS
XU351 oaim22d2 $PINS A1=HFSNET_111 A2=HFSNET_138 B1=copt_net_1397 B2=HFSNET_138
+ ZN=n562 VDD=VDD VSS=VSS
XU352 oaim22d1 $PINS A1=HFSNET_112 A2=HFSNET_138 B1=copt_net_1202 B2=HFSNET_138
+ ZN=n563 VDD=VDD VSS=VSS
XU353 oaim22d1 $PINS A1=HFSNET_113 A2=HFSNET_139 B1=copt_net_2040 B2=HFSNET_139
+ ZN=n564 VDD=VDD VSS=VSS
XU354 oaim22d1 $PINS A1=HFSNET_114 A2=HFSNET_141 B1=copt_net_1444 B2=HFSNET_141
+ ZN=n565 VDD=VDD VSS=VSS
XU356 oaim22d1 $PINS A1=HFSNET_115 A2=HFSNET_138 B1=copt_net_1262 B2=HFSNET_138
+ ZN=n567 VDD=VDD VSS=VSS
XU357 oaim22d1 $PINS A1=n850 A2=HFSNET_139 B1=copt_net_875 B2=HFSNET_139
+ ZN=n568 VDD=VDD VSS=VSS
XU358 oaim22d1 $PINS A1=HFSNET_116 A2=HFSNET_139 B1=copt_net_1799 B2=HFSNET_139
+ ZN=n569 VDD=VDD VSS=VSS
XU359 oaim22d1 $PINS A1=HFSNET_117 A2=HFSNET_138 B1=copt_net_1384 B2=HFSNET_138
+ ZN=n570 VDD=VDD VSS=VSS
XU360 oaim22d1 $PINS A1=n210 A2=HFSNET_139 B1=copt_net_1134 B2=HFSNET_139
+ ZN=n571 VDD=VDD VSS=VSS
XU361 oaim22d1 $PINS A1=n209 A2=HFSNET_138 B1=copt_net_762 B2=HFSNET_138
+ ZN=n572 VDD=VDD VSS=VSS
XU362 oaim22d1 $PINS A1=HFSNET_119 A2=HFSNET_138 B1=copt_net_1342 B2=HFSNET_138
+ ZN=n573 VDD=VDD VSS=VSS
XU363 oaim22d1 $PINS A1=HFSNET_120 A2=HFSNET_138 B1=copt_net_1169 B2=HFSNET_138
+ ZN=n574 VDD=VDD VSS=VSS
XU364 oaim22d1 $PINS A1=copt_net_2288 A2=HFSNET_136 B1=copt_net_1795
+ B2=HFSNET_136 ZN=n575 VDD=VDD VSS=VSS
XU365 oaim22d1 $PINS A1=copt_net_2279 A2=HFSNET_139 B1=copt_net_1828
+ B2=HFSNET_139 ZN=n576 VDD=VDD VSS=VSS
XU366 oaim22d1 $PINS A1=copt_net_2280 A2=HFSNET_138 B1=copt_net_1400
+ B2=HFSNET_138 ZN=n577 VDD=VDD VSS=VSS
XU367 oaim22d1 $PINS A1=n194 A2=HFSNET_137 B1=copt_net_806 B2=HFSNET_137
+ ZN=n578 VDD=VDD VSS=VSS
XU368 oaim22d1 $PINS A1=copt_net_2316 A2=HFSNET_137 B1=copt_net_1817
+ B2=HFSNET_137 ZN=n579 VDD=VDD VSS=VSS
XU369 oaim22d1 $PINS A1=copt_net_2575 A2=HFSNET_137 B1=c_dst[357] B2=HFSNET_137
+ ZN=n580 VDD=VDD VSS=VSS
XU370 oaim22d1 $PINS A1=n185 A2=HFSNET_137 B1=copt_net_842 B2=HFSNET_137
+ ZN=n581 VDD=VDD VSS=VSS
XU371 oaim22d1 $PINS A1=copt_net_2436 A2=HFSNET_137 B1=copt_net_1330
+ B2=HFSNET_137 ZN=n582 VDD=VDD VSS=VSS
XU372 oaim22d1 $PINS A1=copt_net_2727 A2=HFSNET_137 B1=copt_net_765
+ B2=HFSNET_137 ZN=n583 VDD=VDD VSS=VSS
XU373 oaim22d1 $PINS A1=copt_net_2272 A2=HFSNET_137 B1=copt_net_1421
+ B2=HFSNET_137 ZN=n584 VDD=VDD VSS=VSS
XU374 oaim22d1 $PINS A1=ropt_net_3204 A2=HFSNET_137 B1=copt_net_786
+ B2=HFSNET_137 ZN=n585 VDD=VDD VSS=VSS
XU375 oaim22d1 $PINS A1=n167 A2=HFSNET_137 B1=copt_net_785 B2=HFSNET_137
+ ZN=n586 VDD=VDD VSS=VSS
XU376 oaim22d1 $PINS A1=n166 A2=HFSNET_139 B1=copt_net_1322 B2=HFSNET_139
+ ZN=n587 VDD=VDD VSS=VSS
XU377 oaim22d1 $PINS A1=n165 A2=HFSNET_137 B1=copt_net_888 B2=HFSNET_137
+ ZN=n588 VDD=VDD VSS=VSS
XU378 oaim22d1 $PINS A1=copt_net_2362 A2=HFSNET_137 B1=copt_net_1347
+ B2=HFSNET_137 ZN=n589 VDD=VDD VSS=VSS
XU379 oaim22d1 $PINS A1=copt_net_2282 A2=HFSNET_137 B1=copt_net_1310
+ B2=HFSNET_137 ZN=n590 VDD=VDD VSS=VSS
XU380 oaim22d1 $PINS A1=copt_net_2673 A2=HFSNET_137 B1=copt_net_1166
+ B2=HFSNET_137 ZN=n591 VDD=VDD VSS=VSS
XU381 oaim22d1 $PINS A1=copt_net_2487 A2=HFSNET_137 B1=copt_net_1160
+ B2=HFSNET_137 ZN=n592 VDD=VDD VSS=VSS
XU382 oaim22d1 $PINS A1=copt_net_2335 A2=HFSNET_141 B1=copt_net_2181
+ B2=HFSNET_141 ZN=n593 VDD=VDD VSS=VSS
XU384 oaim22d1 $PINS A1=copt_net_2303 A2=HFSNET_135 B1=copt_net_1314
+ B2=HFSNET_135 ZN=n595 VDD=VDD VSS=VSS
XU386 oaim22d1 $PINS A1=copt_net_2474 A2=HFSNET_137 B1=copt_net_1710
+ B2=HFSNET_137 ZN=n597 VDD=VDD VSS=VSS
XU387 oaim22d1 $PINS A1=HFSNET_33 A2=HFSNET_140 B1=copt_net_1904 B2=HFSNET_140
+ ZN=n598 VDD=VDD VSS=VSS
XU388 oaim22d1 $PINS A1=copt_net_2646 A2=HFSNET_137 B1=copt_net_827
+ B2=HFSNET_137 ZN=n599 VDD=VDD VSS=VSS
XU389 oaim22d1 $PINS A1=n153 A2=HFSNET_137 B1=copt_net_949 B2=HFSNET_137
+ ZN=n600 VDD=VDD VSS=VSS
XU390 oaim22d1 $PINS A1=copt_net_2329 A2=HFSNET_137 B1=copt_net_1383
+ B2=HFSNET_137 ZN=n601 VDD=VDD VSS=VSS
XU391 oaim22d1 $PINS A1=copt_net_2274 A2=HFSNET_136 B1=copt_net_1272
+ B2=HFSNET_136 ZN=n602 VDD=VDD VSS=VSS
XU392 oaim22d1 $PINS A1=copt_net_2311 A2=HFSNET_138 B1=copt_net_1358
+ B2=HFSNET_138 ZN=n603 VDD=VDD VSS=VSS
XU393 oaim22d1 $PINS A1=n149 A2=HFSNET_138 B1=copt_net_989 B2=HFSNET_138
+ ZN=n604 VDD=VDD VSS=VSS
XU394 oaim22d1 $PINS A1=n148 A2=HFSNET_136 B1=copt_net_870 B2=HFSNET_136
+ ZN=n605 VDD=VDD VSS=VSS
XU395 oaim22d1 $PINS A1=n147 A2=HFSNET_138 B1=copt_net_867 B2=HFSNET_138
+ ZN=n606 VDD=VDD VSS=VSS
XU397 oaim22d1 $PINS A1=HFSNET_53 A2=HFSNET_165 B1=copt_net_1041 B2=HFSNET_165
+ ZN=n607 VDD=VDD VSS=VSS
XU399 oaim22d1 $PINS A1=HFSNET_64 A2=HFSNET_168 B1=copt_net_1140 B2=HFSNET_168
+ ZN=n608 VDD=VDD VSS=VSS
XU401 oaim22d1 $PINS A1=n937 A2=HFSNET_167 B1=copt_net_772 B2=HFSNET_167
+ ZN=n609 VDD=VDD VSS=VSS
XU403 oaim22d1 $PINS A1=HFSNET_72 A2=HFSNET_167 B1=copt_net_756 B2=HFSNET_167
+ ZN=n610 VDD=VDD VSS=VSS
XU405 oaim22d1 $PINS A1=n935 A2=HFSNET_167 B1=copt_net_781 B2=HFSNET_167
+ ZN=n611 VDD=VDD VSS=VSS
XU409 oaim22d1 $PINS A1=n933 A2=HFSNET_166 B1=copt_net_1183 B2=HFSNET_166
+ ZN=n613 VDD=VDD VSS=VSS
XU411 oaim22d1 $PINS A1=HFSNET_73 A2=HFSNET_166 B1=copt_net_1624 B2=HFSNET_166
+ ZN=n614 VDD=VDD VSS=VSS
XU413 oaim22d1 $PINS A1=copt_net_2565 A2=HFSNET_166 B1=copt_net_1214
+ B2=HFSNET_166 ZN=n615 VDD=VDD VSS=VSS
XU415 oaim22d1 $PINS A1=HFSNET_74 A2=HFSNET_161 B1=copt_net_1412 B2=HFSNET_161
+ ZN=n616 VDD=VDD VSS=VSS
XU417 oaim22d1 $PINS A1=HFSNET_54 A2=HFSNET_168 B1=copt_net_1679 B2=HFSNET_168
+ ZN=n617 VDD=VDD VSS=VSS
XU419 oaim22d1 $PINS A1=n928 A2=HFSNET_165 B1=copt_net_1065 B2=HFSNET_165
+ ZN=n618 VDD=VDD VSS=VSS
XU421 oaim22d1 $PINS A1=HFSNET_55 A2=HFSNET_162 B1=copt_net_1521 B2=HFSNET_162
+ ZN=n619 VDD=VDD VSS=VSS
XU423 oaim22d1 $PINS A1=HFSNET_56 A2=HFSNET_163 B1=copt_net_1146 B2=HFSNET_163
+ ZN=n620 VDD=VDD VSS=VSS
XU425 oaim22d1 $PINS A1=n925 A2=HFSNET_165 B1=copt_net_955 B2=HFSNET_165
+ ZN=n621 VDD=VDD VSS=VSS
XU427 oaim22d1 $PINS A1=HFSNET_57 A2=HFSNET_161 B1=copt_net_1095 B2=HFSNET_161
+ ZN=n622 VDD=VDD VSS=VSS
XU429 oaim22d1 $PINS A1=HFSNET_58 A2=HFSNET_168 B1=copt_net_1680 B2=HFSNET_168
+ ZN=n623 VDD=VDD VSS=VSS
XU431 oaim22d1 $PINS A1=n922 A2=HFSNET_166 B1=copt_net_779 B2=HFSNET_166
+ ZN=n624 VDD=VDD VSS=VSS
XctmTdsLR_1_1261 mx02d1 $PINS I0=c_in[18] I1=copt_net_1879 S=HFSNET_148 Z=n369
+ VDD=VDD VSS=VSS
XU435 oaim22d1 $PINS A1=HFSNET_63 A2=HFSNET_168 B1=copt_net_1736 B2=HFSNET_168
+ ZN=n626 VDD=VDD VSS=VSS
XU437 oaim22d1 $PINS A1=copt_gre_net_2956 A2=HFSNET_167 B1=copt_net_983
+ B2=HFSNET_167 ZN=n627 VDD=VDD VSS=VSS
XU439 oaim22d1 $PINS A1=copt_gre_net_2954 A2=HFSNET_168 B1=copt_net_916
+ B2=HFSNET_168 ZN=n628 VDD=VDD VSS=VSS
XU441 oaim22d1 $PINS A1=n917 A2=HFSNET_165 B1=copt_net_802 B2=HFSNET_165
+ ZN=n629 VDD=VDD VSS=VSS
XU443 oaim22d1 $PINS A1=HFSNET_65 A2=HFSNET_166 B1=copt_net_1157 B2=HFSNET_166
+ ZN=n630 VDD=VDD VSS=VSS
XU445 oaim22d1 $PINS A1=n915 A2=HFSNET_168 B1=copt_net_767 B2=HFSNET_168
+ ZN=n631 VDD=VDD VSS=VSS
XU447 oaim22d1 $PINS A1=HFSNET_66 A2=HFSNET_169 B1=copt_net_1055 B2=HFSNET_169
+ ZN=n632 VDD=VDD VSS=VSS
XU449 oaim22d1 $PINS A1=HFSNET_67 A2=HFSNET_169 B1=copt_net_1420 B2=HFSNET_169
+ ZN=n633 VDD=VDD VSS=VSS
XU451 oaim22d1 $PINS A1=HFSNET_68 A2=HFSNET_169 B1=copt_net_1688 B2=HFSNET_169
+ ZN=n634 VDD=VDD VSS=VSS
XU453 oaim22d1 $PINS A1=HFSNET_69 A2=HFSNET_162 B1=copt_net_1460 B2=HFSNET_162
+ ZN=n635 VDD=VDD VSS=VSS
XU455 oaim22d1 $PINS A1=HFSNET_70 A2=HFSNET_165 B1=copt_net_1495 B2=HFSNET_165
+ ZN=n636 VDD=VDD VSS=VSS
XU457 oaim22d1 $PINS A1=HFSNET_71 A2=HFSNET_169 B1=copt_net_1107 B2=HFSNET_169
+ ZN=n637 VDD=VDD VSS=VSS
XU459 oaim22d1 $PINS A1=HFSNET_47 A2=HFSNET_169 B1=copt_net_1132 B2=HFSNET_169
+ ZN=n638 VDD=VDD VSS=VSS
XU461 oaim22d1 $PINS A1=HFSNET_75 A2=HFSNET_168 B1=copt_net_1052 B2=HFSNET_168
+ ZN=n639 VDD=VDD VSS=VSS
XU463 oaim22d1 $PINS A1=n906 A2=HFSNET_168 B1=copt_net_1016 B2=HFSNET_168
+ ZN=n640 VDD=VDD VSS=VSS
XU465 oaim22d1 $PINS A1=HFSNET_95 A2=HFSNET_169 B1=copt_net_947 B2=HFSNET_169
+ ZN=n641 VDD=VDD VSS=VSS
XctmTdsLR_1_1251 mx02d1 $PINS I0=c_in[18] I1=copt_net_1854 S=HFSNET_161 Z=n625
+ VDD=VDD VSS=VSS
XU469 oaim22d1 $PINS A1=HFSNET_98 A2=HFSNET_165 B1=copt_net_1121 B2=HFSNET_165
+ ZN=n643 VDD=VDD VSS=VSS
XU471 oaim22d1 $PINS A1=n902 A2=HFSNET_166 B1=copt_net_1070 B2=HFSNET_166
+ ZN=n644 VDD=VDD VSS=VSS
XU473 oaim22d1 $PINS A1=n901 A2=HFSNET_166 B1=copt_net_1873 B2=HFSNET_166
+ ZN=n645 VDD=VDD VSS=VSS
XU475 oaim22d1 $PINS A1=HFSNET_99 A2=HFSNET_169 B1=c_dst[423] B2=HFSNET_169
+ ZN=n646 VDD=VDD VSS=VSS
XU477 oaim22d1 $PINS A1=HFSNET_100 A2=HFSNET_166 B1=copt_net_1742 B2=HFSNET_166
+ ZN=n647 VDD=VDD VSS=VSS
XU479 oaim22d1 $PINS A1=HFSNET_101 A2=HFSNET_168 B1=copt_net_1501 B2=HFSNET_168
+ ZN=n648 VDD=VDD VSS=VSS
XU481 oaim22d1 $PINS A1=HFSNET_76 A2=HFSNET_165 B1=copt_net_1965 B2=HFSNET_165
+ ZN=n649 VDD=VDD VSS=VSS
XU483 oaim22d1 $PINS A1=HFSNET_77 A2=HFSNET_166 B1=copt_net_1264 B2=HFSNET_166
+ ZN=n650 VDD=VDD VSS=VSS
XU485 oaim22d1 $PINS A1=HFSNET_78 A2=HFSNET_169 B1=copt_net_1127 B2=HFSNET_169
+ ZN=n651 VDD=VDD VSS=VSS
XU487 oaim22d1 $PINS A1=HFSNET_79 A2=HFSNET_166 B1=copt_net_1159 B2=HFSNET_166
+ ZN=n652 VDD=VDD VSS=VSS
XU489 oaim22d1 $PINS A1=HFSNET_80 A2=HFSNET_165 B1=copt_net_1533 B2=HFSNET_165
+ ZN=n653 VDD=VDD VSS=VSS
XU491 oaim22d1 $PINS A1=HFSNET_81 A2=HFSNET_165 B1=copt_net_1124 B2=HFSNET_165
+ ZN=n654 VDD=VDD VSS=VSS
XU493 oaim22d1 $PINS A1=HFSNET_82 A2=HFSNET_165 B1=copt_net_1079 B2=HFSNET_165
+ ZN=n655 VDD=VDD VSS=VSS
XU495 oaim22d1 $PINS A1=HFSNET_83 A2=HFSNET_166 B1=copt_net_2374 B2=HFSNET_166
+ ZN=n656 VDD=VDD VSS=VSS
XU497 oaim22d1 $PINS A1=HFSNET_84 A2=HFSNET_166 B1=copt_net_2367 B2=HFSNET_166
+ ZN=n657 VDD=VDD VSS=VSS
XU499 oaim22d1 $PINS A1=HFSNET_85 A2=HFSNET_165 B1=c_dst[435] B2=HFSNET_165
+ ZN=n658 VDD=VDD VSS=VSS
XU501 oaim22d1 $PINS A1=HFSNET_86 A2=HFSNET_166 B1=copt_net_2387 B2=HFSNET_166
+ ZN=n659 VDD=VDD VSS=VSS
XU503 oaim22d1 $PINS A1=HFSNET_87 A2=HFSNET_165 B1=copt_net_2439 B2=HFSNET_165
+ ZN=n660 VDD=VDD VSS=VSS
XU505 oaim22d1 $PINS A1=HFSNET_88 A2=HFSNET_161 B1=copt_net_2246 B2=HFSNET_161
+ ZN=n661 VDD=VDD VSS=VSS
XU507 oaim22d1 $PINS A1=copt_net_1399 A2=HFSNET_161 B1=copt_net_2418
+ B2=HFSNET_161 ZN=n662 VDD=VDD VSS=VSS
XU509 oaim22d1 $PINS A1=copt_net_2174 A2=HFSNET_161 B1=copt_net_2096
+ B2=HFSNET_161 ZN=n663 VDD=VDD VSS=VSS
XU511 oaim22d1 $PINS A1=HFSNET_91 A2=HFSNET_161 B1=copt_net_2412 B2=HFSNET_161
+ ZN=n664 VDD=VDD VSS=VSS
XU513 oaim22d1 $PINS A1=HFSNET_92 A2=HFSNET_161 B1=copt_net_1366 B2=HFSNET_161
+ ZN=n665 VDD=VDD VSS=VSS
XU515 oaim22d1 $PINS A1=HFSNET_93 A2=HFSNET_161 B1=copt_net_1023 B2=HFSNET_161
+ ZN=n666 VDD=VDD VSS=VSS
XU517 oaim22d1 $PINS A1=HFSNET_94 A2=HFSNET_161 B1=copt_net_935 B2=HFSNET_161
+ ZN=n667 VDD=VDD VSS=VSS
XU519 oaim22d1 $PINS A1=n878 A2=HFSNET_161 B1=copt_net_1045 B2=HFSNET_161
+ ZN=n668 VDD=VDD VSS=VSS
XU521 oaim22d1 $PINS A1=HFSNET_96 A2=HFSNET_162 B1=copt_net_1369 B2=HFSNET_162
+ ZN=n669 VDD=VDD VSS=VSS
XU523 oaim22d1 $PINS A1=HFSNET_97 A2=HFSNET_168 B1=copt_net_1610 B2=HFSNET_168
+ ZN=n670 VDD=VDD VSS=VSS
XU525 oaim22d1 $PINS A1=HFSNET_102 A2=HFSNET_168 B1=copt_net_1559 B2=HFSNET_168
+ ZN=n671 VDD=VDD VSS=VSS
XU527 oaim22d1 $PINS A1=n874 A2=HFSNET_161 B1=copt_net_1104 B2=HFSNET_161
+ ZN=n672 VDD=VDD VSS=VSS
XU529 oaim22d1 $PINS A1=HFSNET_118 A2=HFSNET_161 B1=copt_net_774 B2=HFSNET_161
+ ZN=n673 VDD=VDD VSS=VSS
XU531 oaim22d1 $PINS A1=HFSNET_121 A2=HFSNET_161 B1=copt_net_1497 B2=HFSNET_161
+ ZN=n674 VDD=VDD VSS=VSS
XU533 oaim22d1 $PINS A1=HFSNET_122 A2=HFSNET_161 B1=copt_net_1477 B2=HFSNET_161
+ ZN=n675 VDD=VDD VSS=VSS
XU535 oaim22d1 $PINS A1=n870 A2=HFSNET_161 B1=copt_net_1222 B2=HFSNET_161
+ ZN=n676 VDD=VDD VSS=VSS
XU537 oaim22d1 $PINS A1=HFSNET_123 A2=HFSNET_161 B1=copt_net_884 B2=HFSNET_161
+ ZN=n677 VDD=VDD VSS=VSS
XU539 oaim22d1 $PINS A1=HFSNET_124 A2=HFSNET_161 B1=copt_net_1320 B2=HFSNET_161
+ ZN=n678 VDD=VDD VSS=VSS
XU541 oaim22d1 $PINS A1=HFSNET_51 A2=HFSNET_163 B1=copt_net_1007 B2=HFSNET_163
+ ZN=n679 VDD=VDD VSS=VSS
XU543 oaim22d1 $PINS A1=HFSNET_52 A2=HFSNET_163 B1=copt_net_1351 B2=HFSNET_163
+ ZN=n680 VDD=VDD VSS=VSS
XU545 oaim22d1 $PINS A1=HFSNET_103 A2=HFSNET_162 B1=copt_net_1346 B2=HFSNET_162
+ ZN=n681 VDD=VDD VSS=VSS
XU547 oaim22d1 $PINS A1=HFSNET_104 A2=HFSNET_165 B1=copt_net_1639 B2=HFSNET_165
+ ZN=n682 VDD=VDD VSS=VSS
XU549 oaim22d1 $PINS A1=n863 A2=HFSNET_168 B1=copt_net_1138 B2=HFSNET_168
+ ZN=n683 VDD=VDD VSS=VSS
XU551 oaim22d1 $PINS A1=HFSNET_105 A2=HFSNET_165 B1=copt_net_1547 B2=HFSNET_165
+ ZN=n684 VDD=VDD VSS=VSS
XU553 oaim22d1 $PINS A1=HFSNET_106 A2=HFSNET_166 B1=copt_net_1950 B2=HFSNET_166
+ ZN=n685 VDD=VDD VSS=VSS
XU555 oaim22d1 $PINS A1=HFSNET_107 A2=HFSNET_166 B1=copt_net_2086 B2=HFSNET_166
+ ZN=n686 VDD=VDD VSS=VSS
XU557 oaim22d1 $PINS A1=HFSNET_108 A2=HFSNET_168 B1=copt_net_2039 B2=HFSNET_168
+ ZN=n687 VDD=VDD VSS=VSS
XU559 oaim22d1 $PINS A1=HFSNET_109 A2=HFSNET_162 B1=copt_net_1131 B2=HFSNET_162
+ ZN=n688 VDD=VDD VSS=VSS
XU561 oaim22d1 $PINS A1=HFSNET_110 A2=HFSNET_164 B1=copt_net_1334 B2=HFSNET_164
+ ZN=n689 VDD=VDD VSS=VSS
XU563 oaim22d1 $PINS A1=HFSNET_111 A2=HFSNET_169 B1=copt_net_1389 B2=HFSNET_169
+ ZN=n690 VDD=VDD VSS=VSS
XU565 oaim22d1 $PINS A1=HFSNET_112 A2=HFSNET_168 B1=copt_net_2038 B2=HFSNET_168
+ ZN=n691 VDD=VDD VSS=VSS
XU567 oaim22d1 $PINS A1=HFSNET_113 A2=HFSNET_168 B1=copt_net_1962 B2=HFSNET_168
+ ZN=n692 VDD=VDD VSS=VSS
XU569 oaim22d1 $PINS A1=HFSNET_114 A2=HFSNET_168 B1=copt_net_1195 B2=HFSNET_168
+ ZN=n693 VDD=VDD VSS=VSS
XU571 oaim22d1 $PINS A1=n852 A2=HFSNET_168 B1=copt_net_1425 B2=HFSNET_168
+ ZN=n694 VDD=VDD VSS=VSS
XU573 oaim22d1 $PINS A1=HFSNET_115 A2=HFSNET_168 B1=copt_net_1955 B2=HFSNET_168
+ ZN=n695 VDD=VDD VSS=VSS
XU575 oaim22d1 $PINS A1=n850 A2=HFSNET_163 B1=copt_net_1114 B2=HFSNET_163
+ ZN=n696 VDD=VDD VSS=VSS
XU577 oaim22d1 $PINS A1=HFSNET_116 A2=HFSNET_169 B1=copt_net_1152 B2=HFSNET_169
+ ZN=n697 VDD=VDD VSS=VSS
XU579 oaim22d1 $PINS A1=HFSNET_117 A2=HFSNET_164 B1=copt_net_1108 B2=HFSNET_164
+ ZN=n698 VDD=VDD VSS=VSS
XU581 oaim22d1 $PINS A1=n210 A2=HFSNET_163 B1=copt_net_1020 B2=HFSNET_163
+ ZN=n699 VDD=VDD VSS=VSS
XU583 oaim22d1 $PINS A1=n209 A2=HFSNET_164 B1=copt_net_754 B2=HFSNET_164
+ ZN=n700 VDD=VDD VSS=VSS
XU585 oaim22d1 $PINS A1=HFSNET_119 A2=HFSNET_169 B1=copt_net_1339 B2=HFSNET_169
+ ZN=n701 VDD=VDD VSS=VSS
XU587 oaim22d1 $PINS A1=HFSNET_120 A2=HFSNET_169 B1=copt_net_1149 B2=HFSNET_169
+ ZN=n702 VDD=VDD VSS=VSS
XU589 oaim22d1 $PINS A1=copt_net_2288 A2=HFSNET_169 B1=copt_net_1513
+ B2=HFSNET_169 ZN=n703 VDD=VDD VSS=VSS
XU591 oaim22d1 $PINS A1=copt_net_2279 A2=HFSNET_169 B1=copt_net_1446
+ B2=HFSNET_169 ZN=n704 VDD=VDD VSS=VSS
XU593 oaim22d4 $PINS A1=copt_net_2280 A2=HFSNET_169 B1=copt_net_1419
+ B2=HFSNET_169 ZN=n705 VDD=VDD VSS=VSS
XU595 oaim22d1 $PINS A1=n194 A2=HFSNET_163 B1=copt_net_807 B2=HFSNET_163
+ ZN=n706 VDD=VDD VSS=VSS
XU597 oaim22d1 $PINS A1=copt_net_2316 A2=HFSNET_163 B1=copt_net_1271
+ B2=HFSNET_163 ZN=n707 VDD=VDD VSS=VSS
XU599 oaim22d1 $PINS A1=copt_net_2575 A2=HFSNET_163 B1=copt_net_1371
+ B2=HFSNET_163 ZN=n708 VDD=VDD VSS=VSS
XU603 oaim22d1 $PINS A1=copt_net_2436 A2=HFSNET_164 B1=copt_net_1350
+ B2=HFSNET_164 ZN=n710 VDD=VDD VSS=VSS
XU605 oaim22d1 $PINS A1=copt_net_2727 A2=HFSNET_164 B1=copt_net_797
+ B2=HFSNET_164 ZN=n711 VDD=VDD VSS=VSS
XU607 oaim22d1 $PINS A1=copt_net_2272 A2=HFSNET_164 B1=copt_net_1542
+ B2=HFSNET_164 ZN=n712 VDD=VDD VSS=VSS
XU609 oaim22d1 $PINS A1=ropt_net_3204 A2=HFSNET_164 B1=copt_net_812
+ B2=HFSNET_164 ZN=n713 VDD=VDD VSS=VSS
XU611 oaim22d2 $PINS A1=n167 A2=HFSNET_163 B1=copt_net_1001 B2=HFSNET_163
+ ZN=n714 VDD=VDD VSS=VSS
XU613 oaim22d1 $PINS A1=n166 A2=HFSNET_163 B1=copt_net_1187 B2=HFSNET_163
+ ZN=n715 VDD=VDD VSS=VSS
XU615 oaim22d1 $PINS A1=copt_net_2596 A2=HFSNET_163 B1=copt_net_1184
+ B2=HFSNET_163 ZN=n716 VDD=VDD VSS=VSS
XU617 oaim22d1 $PINS A1=copt_net_2362 A2=HFSNET_163 B1=copt_net_1336
+ B2=HFSNET_163 ZN=n717 VDD=VDD VSS=VSS
XU619 oaim22d1 $PINS A1=copt_net_2282 A2=HFSNET_163 B1=copt_net_1995
+ B2=HFSNET_163 ZN=n718 VDD=VDD VSS=VSS
XU621 oaim22d1 $PINS A1=copt_net_2673 A2=HFSNET_163 B1=copt_net_1106
+ B2=HFSNET_163 ZN=n719 VDD=VDD VSS=VSS
XU625 oaim22d1 $PINS A1=copt_net_2335 A2=HFSNET_163 B1=copt_net_1323
+ B2=HFSNET_163 ZN=n721 VDD=VDD VSS=VSS
XU629 oaim22d1 $PINS A1=copt_net_2303 A2=HFSNET_163 B1=copt_net_1896
+ B2=HFSNET_163 ZN=n723 VDD=VDD VSS=VSS
XU631 oaim22d1 $PINS A1=n157 A2=HFSNET_164 B1=copt_net_1010 B2=HFSNET_164
+ ZN=n724 VDD=VDD VSS=VSS
XU633 oaim22d1 $PINS A1=copt_net_2474 A2=HFSNET_164 B1=copt_net_1220
+ B2=HFSNET_164 ZN=n725 VDD=VDD VSS=VSS
XU637 oaim22d1 $PINS A1=copt_net_2646 A2=HFSNET_164 B1=copt_net_761
+ B2=HFSNET_164 ZN=n727 VDD=VDD VSS=VSS
XU639 oaim22d1 $PINS A1=n153 A2=HFSNET_164 B1=copt_net_747 B2=HFSNET_164
+ ZN=n728 VDD=VDD VSS=VSS
XU641 oaim22d1 $PINS A1=copt_net_2329 A2=HFSNET_164 B1=copt_net_1415
+ B2=HFSNET_164 ZN=n729 VDD=VDD VSS=VSS
XU643 oaim22d1 $PINS A1=copt_net_2274 A2=HFSNET_164 B1=copt_net_1775
+ B2=HFSNET_164 ZN=n730 VDD=VDD VSS=VSS
XU645 oaim22d1 $PINS A1=copt_net_2311 A2=HFSNET_164 B1=copt_net_1374
+ B2=HFSNET_164 ZN=n731 VDD=VDD VSS=VSS
XU647 oaim22d1 $PINS A1=n149 A2=HFSNET_164 B1=copt_net_1064 B2=HFSNET_164
+ ZN=n732 VDD=VDD VSS=VSS
XU649 oaim22d1 $PINS A1=n148 A2=HFSNET_162 B1=copt_net_798 B2=HFSNET_162
+ ZN=n733 VDD=VDD VSS=VSS
XU651 oaim22d1 $PINS A1=n147 A2=HFSNET_162 B1=copt_net_859 B2=HFSNET_162
+ ZN=n734 VDD=VDD VSS=VSS
XU656 aor22d1 $PINS A1=HFSNET_134 A2=dim_n[0] B1=copt_net_1295 B2=HFSNET_126
+ Z=n735 VDD=VDD VSS=VSS
XU657 aor22d1 $PINS A1=dim_k[2] A2=HFSNET_134 B1=copt_net_613 B2=HFSNET_126
+ Z=n736 VDD=VDD VSS=VSS
XU658 aor22d1 $PINS A1=HFSNET_131 A2=dim_k[1] B1=job_k[1] B2=HFSNET_127 Z=n737
+ VDD=VDD VSS=VSS
XU659 aor22d1 $PINS A1=HFSNET_131 A2=dim_k[0] B1=copt_net_1047 B2=HFSNET_127
+ Z=n738 VDD=VDD VSS=VSS
XU660 oai22d1 $PINS A1=HFSNET_131 A2=n952 B1=n957 B2=HFSNET_127 ZN=n739 VDD=VDD
+ VSS=VSS
XU662 aor22d1 $PINS A1=HFSNET_127 A2=job_m[1] B1=HFSNET_131 B2=dim_m[1] Z=n740
+ VDD=VDD VSS=VSS
XU663 aor22d1 $PINS A1=HFSNET_127 A2=copt_net_2082 B1=dest_c[31] B2=HFSNET_131
+ Z=n741 VDD=VDD VSS=VSS
XU664 aor22d1 $PINS A1=HFSNET_127 A2=copt_net_1273 B1=dest_c[30] B2=HFSNET_131
+ Z=n742 VDD=VDD VSS=VSS
XU665 aor22d1 $PINS A1=HFSNET_127 A2=copt_net_1411 B1=dest_c[29] B2=HFSNET_131
+ Z=n743 VDD=VDD VSS=VSS
XU666 aor22d1 $PINS A1=HFSNET_128 A2=copt_net_1281 B1=dest_c[28] B2=HFSNET_132
+ Z=n744 VDD=VDD VSS=VSS
XU667 aor22d1 $PINS A1=HFSNET_127 A2=copt_net_2251 B1=dest_c[27] B2=HFSNET_131
+ Z=n745 VDD=VDD VSS=VSS
XU668 aor22d1 $PINS A1=HFSNET_127 A2=copt_net_1788 B1=dest_c[26] B2=HFSNET_131
+ Z=n746 VDD=VDD VSS=VSS
XU669 aor22d1 $PINS A1=HFSNET_127 A2=copt_net_1832 B1=dest_c[25] B2=HFSNET_131
+ Z=n747 VDD=VDD VSS=VSS
XU670 aor22d1 $PINS A1=HFSNET_127 A2=copt_net_1852 B1=dest_c[24] B2=HFSNET_131
+ Z=n748 VDD=VDD VSS=VSS
XU671 aor22d1 $PINS A1=n177 A2=copt_net_1781 B1=dest_c[23] B2=HFSNET_133 Z=n749
+ VDD=VDD VSS=VSS
XU672 aor22d1 $PINS A1=n177 A2=copt_net_1662 B1=dest_c[22] B2=HFSNET_133 Z=n750
+ VDD=VDD VSS=VSS
XU673 aor22d1 $PINS A1=n177 A2=copt_net_1703 B1=dest_c[21] B2=HFSNET_133 Z=n751
+ VDD=VDD VSS=VSS
XU674 aor22d1 $PINS A1=n177 A2=copt_net_2199 B1=HFSNET_22 B2=HFSNET_133 Z=n752
+ VDD=VDD VSS=VSS
XU675 aor22d1 $PINS A1=n177 A2=copt_net_1875 B1=dest_c[19] B2=HFSNET_133 Z=n753
+ VDD=VDD VSS=VSS
XU676 aor22d1 $PINS A1=n177 A2=copt_net_1387 B1=dest_c[18] B2=HFSNET_133 Z=n754
+ VDD=VDD VSS=VSS
XU677 aor22d1 $PINS A1=HFSNET_127 A2=copt_net_1668 B1=dest_c[17] B2=HFSNET_131
+ Z=n755 VDD=VDD VSS=VSS
XU678 aor22d1 $PINS A1=HFSNET_126 A2=copt_net_1203 B1=dest_c[16] B2=HFSNET_134
+ Z=n756 VDD=VDD VSS=VSS
XU679 aor22d1 $PINS A1=n177 A2=copt_net_1378 B1=dest_c[15] B2=HFSNET_133 Z=n757
+ VDD=VDD VSS=VSS
XU680 aor22d1 $PINS A1=HFSNET_127 A2=copt_net_1572 B1=dest_c[14] B2=HFSNET_131
+ Z=n758 VDD=VDD VSS=VSS
XU681 aor22d1 $PINS A1=HFSNET_127 A2=copt_net_2365 B1=dest_c[13] B2=HFSNET_131
+ Z=n759 VDD=VDD VSS=VSS
XU682 aor22d1 $PINS A1=HFSNET_126 A2=copt_net_1696 B1=dest_c[12] B2=HFSNET_134
+ Z=n760 VDD=VDD VSS=VSS
XU683 aor22d1 $PINS A1=HFSNET_127 A2=copt_net_1535 B1=dest_c[11] B2=HFSNET_131
+ Z=n761 VDD=VDD VSS=VSS
XU684 aor22d1 $PINS A1=HFSNET_127 A2=copt_net_1793 B1=dest_c[10] B2=HFSNET_131
+ Z=n762 VDD=VDD VSS=VSS
XU685 aor22d1 $PINS A1=HFSNET_127 A2=copt_net_1837 B1=dest_c[9] B2=HFSNET_131
+ Z=n763 VDD=VDD VSS=VSS
XU686 aor22d1 $PINS A1=HFSNET_128 A2=copt_net_1866 B1=dest_c[8] B2=HFSNET_132
+ Z=n764 VDD=VDD VSS=VSS
XU687 aor22d1 $PINS A1=HFSNET_128 A2=copt_net_1969 B1=dest_c[7] B2=HFSNET_132
+ Z=n765 VDD=VDD VSS=VSS
XU688 aor22d1 $PINS A1=HFSNET_128 A2=copt_net_2094 B1=dest_c[6] B2=HFSNET_132
+ Z=n766 VDD=VDD VSS=VSS
XU689 aor22d1 $PINS A1=HFSNET_128 A2=copt_net_1681 B1=dest_c[5] B2=HFSNET_132
+ Z=n767 VDD=VDD VSS=VSS
XU690 aor22d1 $PINS A1=HFSNET_128 A2=copt_net_2327 B1=copt_net_971
+ B2=HFSNET_132 Z=n768 VDD=VDD VSS=VSS
XU691 aor22d1 $PINS A1=HFSNET_128 A2=copt_net_2148 B1=dest_c[3] B2=HFSNET_132
+ Z=n769 VDD=VDD VSS=VSS
XU692 aor22d1 $PINS A1=HFSNET_128 A2=copt_net_2055 B1=dest_c[2] B2=HFSNET_132
+ Z=n770 VDD=VDD VSS=VSS
XU693 aor22d1 $PINS A1=HFSNET_128 A2=copt_net_2108 B1=dest_c[1] B2=HFSNET_132
+ Z=n771 VDD=VDD VSS=VSS
XU694 aor22d1 $PINS A1=HFSNET_128 A2=copt_net_2376 B1=dest_c[0] B2=HFSNET_132
+ Z=n772 VDD=VDD VSS=VSS
XU695 aor22d1 $PINS A1=HFSNET_128 A2=copt_net_1401 B1=src_b[31] B2=HFSNET_132
+ Z=n773 VDD=VDD VSS=VSS
XU696 aor22d1 $PINS A1=HFSNET_128 A2=copt_net_2020 B1=src_b[30] B2=HFSNET_132
+ Z=n774 VDD=VDD VSS=VSS
XU697 aor22d1 $PINS A1=HFSNET_128 A2=copt_net_1493 B1=src_b[29] B2=HFSNET_132
+ Z=n775 VDD=VDD VSS=VSS
XU698 aor22d1 $PINS A1=HFSNET_127 A2=copt_net_2052 B1=src_b[28] B2=HFSNET_131
+ Z=n776 VDD=VDD VSS=VSS
XU699 aor22d1 $PINS A1=HFSNET_127 A2=copt_net_1921 B1=src_b[27] B2=HFSNET_131
+ Z=n777 VDD=VDD VSS=VSS
XU700 aor22d1 $PINS A1=HFSNET_128 A2=copt_net_1716 B1=src_b[26] B2=HFSNET_132
+ Z=n778 VDD=VDD VSS=VSS
XU701 aor22d1 $PINS A1=HFSNET_127 A2=copt_net_1893 B1=src_b[25] B2=HFSNET_131
+ Z=n779 VDD=VDD VSS=VSS
XU702 aor22d1 $PINS A1=HFSNET_128 A2=copt_net_1717 B1=src_b[24] B2=HFSNET_132
+ Z=n780 VDD=VDD VSS=VSS
XU703 aor22d1 $PINS A1=HFSNET_127 A2=copt_net_2042 B1=src_b[23] B2=HFSNET_131
+ Z=n781 VDD=VDD VSS=VSS
XU704 aor22d1 $PINS A1=n177 A2=copt_net_1858 B1=HFSNET_32 B2=HFSNET_133 Z=n782
+ VDD=VDD VSS=VSS
XU705 aor22d1 $PINS A1=n177 A2=copt_net_1732 B1=src_b[21] B2=HFSNET_133 Z=n783
+ VDD=VDD VSS=VSS
XU706 aor22d1 $PINS A1=n177 A2=copt_net_1957 B1=HFSNET_31 B2=HFSNET_133 Z=n784
+ VDD=VDD VSS=VSS
XU707 aor22d1 $PINS A1=n177 A2=copt_net_1948 B1=src_b[19] B2=HFSNET_133 Z=n785
+ VDD=VDD VSS=VSS
XU708 aor22d1 $PINS A1=n177 A2=copt_net_2239 B1=gre_a_INV_58_3 B2=HFSNET_133
+ Z=n786 VDD=VDD VSS=VSS
XU709 aor22d1 $PINS A1=n177 A2=copt_net_1826 B1=src_b[17] B2=HFSNET_133 Z=n787
+ VDD=VDD VSS=VSS
XU710 aor22d1 $PINS A1=n177 A2=copt_net_1644 B1=HFSNET_29 B2=HFSNET_133 Z=n788
+ VDD=VDD VSS=VSS
XU711 aor22d1 $PINS A1=n177 A2=copt_net_1394 B1=src_b[15] B2=HFSNET_133 Z=n789
+ VDD=VDD VSS=VSS
XU712 aor22d1 $PINS A1=n177 A2=copt_net_1625 B1=HFSNET_28 B2=HFSNET_133 Z=n790
+ VDD=VDD VSS=VSS
XU713 aor22d1 $PINS A1=HFSNET_126 A2=copt_net_2368 B1=src_b[13] B2=HFSNET_134
+ Z=n791 VDD=VDD VSS=VSS
XU714 aor22d1 $PINS A1=HFSNET_126 A2=copt_net_1465 B1=src_b[12] B2=HFSNET_134
+ Z=n792 VDD=VDD VSS=VSS
XU715 aor22d1 $PINS A1=n177 A2=copt_net_1586 B1=src_b[11] B2=HFSNET_133 Z=n793
+ VDD=VDD VSS=VSS
XU716 aor22d1 $PINS A1=n177 A2=copt_net_1092 B1=src_b[10] B2=HFSNET_133 Z=n794
+ VDD=VDD VSS=VSS
XU717 aor22d1 $PINS A1=HFSNET_126 A2=copt_net_1439 B1=src_b[9] B2=HFSNET_134
+ Z=n795 VDD=VDD VSS=VSS
XU718 aor22d1 $PINS A1=HFSNET_126 A2=copt_net_1997 B1=src_b[8] B2=HFSNET_134
+ Z=n796 VDD=VDD VSS=VSS
XU719 aor22d1 $PINS A1=HFSNET_126 A2=copt_net_1391 B1=src_b[7] B2=HFSNET_134
+ Z=n797 VDD=VDD VSS=VSS
XU720 aor22d1 $PINS A1=HFSNET_126 A2=copt_net_1011 B1=src_b[6] B2=HFSNET_134
+ Z=n798 VDD=VDD VSS=VSS
XU721 aor22d1 $PINS A1=HFSNET_126 A2=copt_net_1755 B1=src_b[5] B2=HFSNET_134
+ Z=n799 VDD=VDD VSS=VSS
XU722 aor22d1 $PINS A1=HFSNET_127 A2=copt_net_1377 B1=src_b[4] B2=HFSNET_131
+ Z=n800 VDD=VDD VSS=VSS
XU723 aor22d1 $PINS A1=HFSNET_127 A2=copt_net_1398 B1=src_b[3] B2=HFSNET_131
+ Z=n801 VDD=VDD VSS=VSS
XU724 aor22d1 $PINS A1=HFSNET_127 A2=copt_net_2077 B1=src_b[2] B2=HFSNET_131
+ Z=n802 VDD=VDD VSS=VSS
XU725 aor22d1 $PINS A1=HFSNET_127 A2=src_b_lat[1] B1=src_b[1] B2=HFSNET_131
+ Z=n803 VDD=VDD VSS=VSS
XU726 aor22d1 $PINS A1=HFSNET_127 A2=copt_net_2391 B1=src_b[0] B2=HFSNET_131
+ Z=n804 VDD=VDD VSS=VSS
XU727 aor22d1 $PINS A1=HFSNET_127 A2=copt_net_1130 B1=src_a[31] B2=HFSNET_131
+ Z=n805 VDD=VDD VSS=VSS
XU728 aor22d1 $PINS A1=HFSNET_127 A2=copt_net_1247 B1=src_a[30] B2=HFSNET_131
+ Z=n806 VDD=VDD VSS=VSS
XU729 aor22d1 $PINS A1=HFSNET_127 A2=copt_net_1473 B1=src_a[29] B2=HFSNET_131
+ Z=n807 VDD=VDD VSS=VSS
XU730 aor22d1 $PINS A1=HFSNET_127 A2=copt_net_1352 B1=src_a[28] B2=HFSNET_131
+ Z=n808 VDD=VDD VSS=VSS
XU731 aor22d1 $PINS A1=n177 A2=copt_net_1933 B1=src_a[27] B2=HFSNET_133 Z=n809
+ VDD=VDD VSS=VSS
XU732 aor22d1 $PINS A1=n177 A2=copt_net_1758 B1=src_a[26] B2=HFSNET_133 Z=n810
+ VDD=VDD VSS=VSS
XU733 aor22d1 $PINS A1=n177 A2=copt_net_1895 B1=src_a[25] B2=HFSNET_133 Z=n811
+ VDD=VDD VSS=VSS
XU734 aor22d1 $PINS A1=n177 A2=copt_net_1877 B1=src_a[24] B2=HFSNET_133 Z=n812
+ VDD=VDD VSS=VSS
XU735 aor22d1 $PINS A1=n177 A2=copt_net_1838 B1=src_a[23] B2=HFSNET_133 Z=n813
+ VDD=VDD VSS=VSS
XU736 aor22d1 $PINS A1=n177 A2=copt_net_1488 B1=src_a[22] B2=HFSNET_133 Z=n814
+ VDD=VDD VSS=VSS
XU737 aor22d1 $PINS A1=n177 A2=copt_net_1816 B1=src_a[21] B2=HFSNET_133 Z=n815
+ VDD=VDD VSS=VSS
XU738 aor22d1 $PINS A1=n177 A2=copt_net_1570 B1=src_a[20] B2=HFSNET_133 Z=n816
+ VDD=VDD VSS=VSS
XU739 aor22d1 $PINS A1=n177 A2=copt_net_1840 B1=src_a[19] B2=HFSNET_133 Z=n817
+ VDD=VDD VSS=VSS
XU740 aor22d1 $PINS A1=n177 A2=copt_net_1900 B1=HFSNET_27 B2=HFSNET_133 Z=n818
+ VDD=VDD VSS=VSS
XU741 aor22d1 $PINS A1=n177 A2=copt_net_1706 B1=src_a[17] B2=HFSNET_133 Z=n819
+ VDD=VDD VSS=VSS
XU742 aor22d1 $PINS A1=n177 A2=copt_net_1694 B1=HFSNET_26 B2=HFSNET_133 Z=n820
+ VDD=VDD VSS=VSS
XU743 aor22d1 $PINS A1=n177 A2=copt_net_1545 B1=src_a[15] B2=HFSNET_133 Z=n821
+ VDD=VDD VSS=VSS
XU744 aor22d1 $PINS A1=n177 A2=copt_net_2226 B1=HFSNET_25 B2=HFSNET_133 Z=n822
+ VDD=VDD VSS=VSS
XU745 aor22d1 $PINS A1=n177 A2=copt_net_2375 B1=src_a[13] B2=HFSNET_133 Z=n823
+ VDD=VDD VSS=VSS
XU746 aor22d1 $PINS A1=HFSNET_126 A2=copt_net_1405 B1=HFSNET_24 B2=HFSNET_134
+ Z=n824 VDD=VDD VSS=VSS
XU747 aor22d1 $PINS A1=n177 A2=copt_net_1388 B1=src_a[11] B2=HFSNET_133 Z=n825
+ VDD=VDD VSS=VSS
XU748 aor22d1 $PINS A1=HFSNET_126 A2=copt_net_2041 B1=HFSNET_23 B2=HFSNET_134
+ Z=n826 VDD=VDD VSS=VSS
XU749 aor22d1 $PINS A1=HFSNET_126 A2=copt_net_1361 B1=src_a[9] B2=HFSNET_134
+ Z=n827 VDD=VDD VSS=VSS
XU750 aor22d1 $PINS A1=HFSNET_126 A2=copt_net_1626 B1=src_a[8] B2=HFSNET_134
+ Z=n828 VDD=VDD VSS=VSS
XU751 aor22d1 $PINS A1=HFSNET_126 A2=copt_net_1265 B1=src_a[7] B2=HFSNET_134
+ Z=n829 VDD=VDD VSS=VSS
XU752 aor22d1 $PINS A1=HFSNET_126 A2=copt_net_1133 B1=src_a[6] B2=HFSNET_134
+ Z=n830 VDD=VDD VSS=VSS
XU753 aor22d1 $PINS A1=HFSNET_126 A2=copt_net_1794 B1=src_a[5] B2=HFSNET_134
+ Z=n831 VDD=VDD VSS=VSS
XU754 aor22d1 $PINS A1=HFSNET_126 A2=copt_net_1711 B1=src_a[4] B2=HFSNET_134
+ Z=n832 VDD=VDD VSS=VSS
XU755 aor22d1 $PINS A1=HFSNET_126 A2=copt_net_1289 B1=src_a[3] B2=HFSNET_134
+ Z=n833 VDD=VDD VSS=VSS
XU756 aor22d1 $PINS A1=HFSNET_126 A2=copt_net_1345 B1=src_a[2] B2=HFSNET_134
+ Z=n834 VDD=VDD VSS=VSS
XU757 aor22d1 $PINS A1=HFSNET_126 A2=src_a_lat[1] B1=src_a[1] B2=HFSNET_134
+ Z=n835 VDD=VDD VSS=VSS
XU758 aor22d1 $PINS A1=HFSNET_126 A2=copt_net_1481 B1=src_a[0] B2=HFSNET_134
+ Z=n836 VDD=VDD VSS=VSS
XU759 aor22d1 $PINS A1=HFSNET_171 A2=HFSNET_126 B1=mode_unsigned B2=HFSNET_134
+ Z=n837 VDD=VDD VSS=VSS
XU760 aor22d1 $PINS A1=dim_n[2] A2=HFSNET_134 B1=job_n[2] B2=HFSNET_126 Z=n838
+ VDD=VDD VSS=VSS
XU761 aor22d1 $PINS A1=HFSNET_134 A2=dim_n[1] B1=job_n[1] B2=HFSNET_126 Z=n839
+ VDD=VDD VSS=VSS
XU762 aor22d1 $PINS A1=HFSNET_126 A2=copt_net_2734 B1=HFSNET_134
+ B2=copt_net_2400 Z=n840 VDD=VDD VSS=VSS
XU765 oai22d1 $PINS A1=n176 A2=n182 B1=n945 B2=n183 ZN=n841 VDD=VDD VSS=VSS
XZCTSBUF_91322_2524 buffd3 $PINS I=ZCTSNET_217 Z=ZCTSNET_1 VDD=VDD VSS=VSS
XU769 oai22d1 $PINS A1=n175 A2=n182 B1=n944 B2=n183 ZN=n842 VDD=VDD VSS=VSS
XU771 xr02d1 $PINS A1=n186 A2=cycle[2] Z=n175 VDD=VDD VSS=VSS
XU772 oai22d1 $PINS A1=n169 A2=n182 B1=n221 B2=n183 ZN=n843 VDD=VDD VSS=VSS
XU773 oai21d1 $PINS B1=cycle[0] B2=n943 A=n186 ZN=n169 VDD=VDD VSS=VSS
XU775 aon211d1 $PINS C1=n188 C2=n39 B=n189 A=n190 ZN=n844 VDD=VDD VSS=VSS
XU777 aon211d1 $PINS C1=n940 C2=n947 B=n956 A=n195 ZN=n845 VDD=VDD VSS=VSS
XU780 or04d0 $PINS A1=a_swap A2=n192 A3=n197 A4=w_swap Z=n846 VDD=VDD VSS=VSS
XctmTdsLR_1_1262 mx02d1 $PINS I0=c_in[35] I1=copt_net_2059 S=HFSNET_147 Z=n386
+ VDD=VDD VSS=VSS
XctmTdsLR_1_1270 an03d1 $PINS A1=n170 A2=n942 A3=cycle[0] Z=HFSNET_143 VDD=VDD
+ VSS=VSS
XctmTdsLR_1_1371 aoim22d1 $PINS A1=job_m[0] A2=n941 B1=job_m[0] B2=n941 Z=n213
+ VDD=VDD VSS=VSS
XU795 oai221d1 $PINS B1=start B2=n188 C1=job_done C2=n39 A=n949 ZN=n189 VDD=VDD
+ VSS=VSS
XU797 aoim21d1 $PINS B1=n950 B2=n211 A=error ZN=n188 VDD=VDD VSS=VSS
XU799 oai22d1 $PINS A1=cycle[0] A2=n182 B1=n941 B2=n183 ZN=n848 VDD=VDD VSS=VSS
XctmTdsLR_2_1372 aoim22d1 $PINS A1=cycle[2] A2=n217 B1=cycle[2] B2=n217 Z=n214
+ VDD=VDD VSS=VSS
Xcopt_h_inst_3069 dl02d1 $PINS I=c_in[49] Z=copt_net_239 VDD=VDD VSS=VSS
XU806 xr02d1 $PINS A1=job_m[2] A2=job_m[1] Z=n217 VDD=VDD VSS=VSS
XU807 xr02d1 $PINS A1=job_m[1] A2=n943 Z=n37 VDD=VDD VSS=VSS
XZCTSBUF_72174_2543 buffd3 $PINS I=ZCTSNET_6 Z=ZCTSNET_7 VDD=VDD VSS=VSS
XU814 aor222d1 $PINS A1=copt_net_1439 A2=job_kind[0] B1=copt_net_1361 B2=n6
+ C1=copt_net_1837 C2=job_kind[1] Z=job_base_addr[9] VDD=VDD VSS=VSS
XU815 aor222d1 $PINS A1=copt_net_1997 A2=job_kind[0] B1=copt_net_1626 B2=n6
+ C1=dest_c_lat[8] C2=n95 Z=job_base_addr[8] VDD=VDD VSS=VSS
XU816 aor222d1 $PINS A1=copt_net_1391 A2=job_kind[0] B1=copt_net_1265 B2=n6
+ C1=copt_net_1969 C2=n95 Z=job_base_addr[7] VDD=VDD VSS=VSS
XU817 aor222d1 $PINS A1=copt_net_1011 A2=n961 B1=copt_net_1133 B2=n6
+ C1=copt_net_2094 C2=n95 Z=job_base_addr[6] VDD=VDD VSS=VSS
XU818 aor222d1 $PINS A1=copt_net_1755 A2=job_kind[0] B1=copt_net_1794 B2=n6
+ C1=copt_net_1681 C2=n95 Z=job_base_addr[5] VDD=VDD VSS=VSS
XU819 aor222d1 $PINS A1=copt_net_1377 A2=n961 B1=copt_net_1711 B2=n6
+ C1=copt_net_2327 C2=n95 Z=job_base_addr[4] VDD=VDD VSS=VSS
XU820 aor222d1 $PINS A1=copt_net_1398 A2=n93 B1=copt_net_1289 B2=n6
+ C1=copt_net_2148 C2=n95 Z=job_base_addr[3] VDD=VDD VSS=VSS
XU821 aor222d1 $PINS A1=copt_net_1401 A2=n93 B1=copt_net_1130 B2=n6
+ C1=copt_net_2082 C2=n95 Z=job_base_addr[31] VDD=VDD VSS=VSS
XU822 aor222d1 $PINS A1=copt_net_2020 A2=n93 B1=copt_net_1248 B2=n6
+ C1=copt_net_1273 C2=n95 Z=job_base_addr[30] VDD=VDD VSS=VSS
XU823 aor222d1 $PINS A1=copt_net_2077 A2=n93 B1=copt_net_1345 B2=n6
+ C1=copt_net_2055 C2=n95 Z=job_base_addr[2] VDD=VDD VSS=VSS
XU824 aor222d1 $PINS A1=copt_net_1493 A2=n93 B1=copt_net_1473 B2=n6
+ C1=copt_net_1411 C2=n95 Z=job_base_addr[29] VDD=VDD VSS=VSS
XU825 aor222d1 $PINS A1=copt_net_2052 A2=job_kind[0] B1=copt_net_1352 B2=n6
+ C1=copt_net_1281 C2=n95 Z=job_base_addr[28] VDD=VDD VSS=VSS
XU826 aor222d1 $PINS A1=copt_net_1921 A2=n93 B1=copt_net_1933 B2=n6
+ C1=copt_net_2251 C2=n95 Z=job_base_addr[27] VDD=VDD VSS=VSS
XU827 aor222d1 $PINS A1=copt_net_1716 A2=n93 B1=copt_net_1758 B2=n6
+ C1=copt_net_1788 C2=n95 Z=job_base_addr[26] VDD=VDD VSS=VSS
XU828 aor222d1 $PINS A1=copt_net_1893 A2=n93 B1=copt_net_1895 B2=n6
+ C1=copt_net_1832 C2=n95 Z=job_base_addr[25] VDD=VDD VSS=VSS
XU829 aor222d1 $PINS A1=copt_net_1717 A2=n93 B1=copt_net_1877 B2=n6
+ C1=copt_net_1852 C2=n95 Z=job_base_addr[24] VDD=VDD VSS=VSS
XU830 aor222d1 $PINS A1=copt_net_2042 A2=n93 B1=copt_net_1838 B2=n5
+ C1=dest_c_lat[23] C2=n95 Z=job_base_addr[23] VDD=VDD VSS=VSS
XU831 aor222d1 $PINS A1=copt_net_1858 A2=n93 B1=copt_net_1488 B2=n197
+ C1=copt_net_1662 C2=n95 Z=job_base_addr[22] VDD=VDD VSS=VSS
XU832 aor222d1 $PINS A1=copt_net_1732 A2=n93 B1=copt_net_1816 B2=n197
+ C1=copt_net_1703 C2=job_kind[1] Z=job_base_addr[21] VDD=VDD VSS=VSS
XU833 aor222d1 $PINS A1=copt_net_1957 A2=n93 B1=copt_net_1570 B2=n197
+ C1=copt_net_2199 C2=job_kind[1] Z=job_base_addr[20] VDD=VDD VSS=VSS
XU834 aor222d1 $PINS A1=src_b_lat[1] A2=n93 B1=src_a_lat[1] B2=n5
+ C1=copt_net_2108 C2=job_kind[1] Z=job_base_addr[1] VDD=VDD VSS=VSS
XU835 aor222d1 $PINS A1=copt_net_1948 A2=n93 B1=copt_net_1840 B2=n5
+ C1=dest_c_lat[19] C2=n960 Z=job_base_addr[19] VDD=VDD VSS=VSS
XU836 aor222d1 $PINS A1=copt_net_2239 A2=n93 B1=copt_net_1900 B2=n5
+ C1=copt_net_1387 C2=job_kind[1] Z=job_base_addr[18] VDD=VDD VSS=VSS
XU837 aor222d1 $PINS A1=copt_net_1826 A2=job_kind[0] B1=copt_net_1706 B2=n6
+ C1=copt_net_1668 C2=job_kind[1] Z=job_base_addr[17] VDD=VDD VSS=VSS
XU838 aor222d1 $PINS A1=copt_net_1644 A2=job_kind[0] B1=src_a_lat[16] B2=n5
+ C1=copt_net_1203 C2=n960 Z=job_base_addr[16] VDD=VDD VSS=VSS
XU839 aor222d1 $PINS A1=copt_net_1394 A2=job_kind[0] B1=copt_net_1545 B2=n5
+ C1=copt_net_1378 C2=job_kind[1] Z=job_base_addr[15] VDD=VDD VSS=VSS
XU840 aor222d1 $PINS A1=copt_net_1625 A2=job_kind[0] B1=copt_net_2226 B2=n5
+ C1=copt_net_1572 C2=job_kind[1] Z=job_base_addr[14] VDD=VDD VSS=VSS
XU841 aor222d1 $PINS A1=src_b_lat[13] A2=job_kind[0] B1=src_a_lat[13] B2=n5
+ C1=dest_c_lat[13] C2=job_kind[1] Z=job_base_addr[13] VDD=VDD VSS=VSS
XU842 aor222d1 $PINS A1=copt_net_1465 A2=job_kind[0] B1=copt_net_1405 B2=n5
+ C1=copt_net_1696 C2=job_kind[1] Z=job_base_addr[12] VDD=VDD VSS=VSS
XU843 aor222d1 $PINS A1=copt_net_1587 A2=job_kind[0] B1=copt_net_1388 B2=n5
+ C1=copt_net_1535 C2=job_kind[1] Z=job_base_addr[11] VDD=VDD VSS=VSS
XU844 aor222d1 $PINS A1=copt_net_1092 A2=job_kind[0] B1=copt_net_2041 B2=n5
+ C1=copt_net_1793 C2=job_kind[1] Z=job_base_addr[10] VDD=VDD VSS=VSS
XU845 aor222d1 $PINS A1=copt_net_2391 A2=n93 B1=copt_net_1481 B2=n5
+ C1=copt_net_2376 C2=n960 Z=job_base_addr[0] VDD=VDD VSS=VSS
XctmTdsLR_1_1239 mx02d1 $PINS I0=c_in[35] I1=copt_net_1360 S=HFSNET_169 Z=n642
+ VDD=VDD VSS=VSS
XU854 aoi211d1 $PINS C1=n218 C2=state[2] A=a_swap B=n212 ZN=n219 VDD=VDD
+ VSS=VSS
XU784 an03d1 $PINS A1=n181 A2=n955 A3=n951 Z=n38 VDD=VDD VSS=VSS
XU802 nd04d0 $PINS A1=n213 A2=n215 A3=n214 A4=n37 ZN=n191 VDD=VDD VSS=VSS
Xn_lat_reg_1_ dfcrq2 $PINS D=copt_net_356 CP=ZCTSNET_220 CDN=HFSNET_186
+ Q=job_n[1] VDD=VDD VSS=VSS
Xn_lat_reg_2_ dfcrq2 $PINS D=n838 CP=ZCTSNET_220 CDN=HFSNET_186
+ Q=aps_rename_23_ VDD=VDD VSS=VSS
Xn_lat_reg_0_ dfcrq2 $PINS D=n735 CP=ZCTSNET_220 CDN=HFSNET_186 Q=job_n[0]
+ VDD=VDD VSS=VSS
Xk_lat_reg_0_ dfcrq2 $PINS D=n738 CP=ZCTSNET_6 CDN=HFSNET_182 Q=job_k[0]
+ VDD=VDD VSS=VSS
Xk_lat_reg_1_ dfcrq2 $PINS D=copt_net_2854 CP=ZCTSNET_6 CDN=HFSNET_182
+ Q=job_k[1] VDD=VDD VSS=VSS
Xk_lat_reg_2_ dfcrq2 $PINS D=n736 CP=ZCTSNET_220 CDN=HFSNET_186 Q=job_k[2]
+ VDD=VDD VSS=VSS
Xsrc_b_lat_reg_0_ dfcrq2 $PINS D=n804 CP=ZCTSNET_7 CDN=HFSNET_187
+ Q=src_b_lat[0] VDD=VDD VSS=VSS
Xsrc_b_lat_reg_1_ dfcrq2 $PINS D=copt_net_2822 CP=ZCTSNET_7 CDN=HFSNET_187
+ Q=src_b_lat[1] VDD=VDD VSS=VSS
Xsrc_b_lat_reg_2_ dfcrq2 $PINS D=n802 CP=ZCTSNET_6 CDN=HFSNET_187
+ Q=src_b_lat[2] VDD=VDD VSS=VSS
Xsrc_b_lat_reg_3_ dfcrq2 $PINS D=n801 CP=ZCTSNET_6 CDN=HFSNET_187
+ Q=src_b_lat[3] VDD=VDD VSS=VSS
Xsrc_b_lat_reg_4_ dfcrq2 $PINS D=n800 CP=ZCTSNET_7 CDN=HFSNET_187
+ Q=src_b_lat[4] VDD=VDD VSS=VSS
Xsrc_b_lat_reg_5_ dfcrq2 $PINS D=n799 CP=ZCTSNET_13 CDN=HFSNET_180
+ Q=src_b_lat[5] VDD=VDD VSS=VSS
Xsrc_b_lat_reg_6_ dfcrq2 $PINS D=n798 CP=ZCTSNET_6 CDN=HFSNET_186
+ Q=src_b_lat[6] VDD=VDD VSS=VSS
Xsrc_b_lat_reg_7_ dfcrq2 $PINS D=n797 CP=ZCTSNET_6 CDN=HFSNET_186
+ Q=src_b_lat[7] VDD=VDD VSS=VSS
Xsrc_b_lat_reg_8_ dfcrq2 $PINS D=n796 CP=ZCTSNET_13 CDN=HFSNET_180
+ Q=src_b_lat[8] VDD=VDD VSS=VSS
Xsrc_b_lat_reg_9_ dfcrq2 $PINS D=n795 CP=ZCTSNET_13 CDN=HFSNET_180
+ Q=src_b_lat[9] VDD=VDD VSS=VSS
Xsrc_b_lat_reg_10_ dfcrq2 $PINS D=n794 CP=ZCTSNET_219 CDN=HFSNET_186
+ Q=src_b_lat[10] VDD=VDD VSS=VSS
Xsrc_b_lat_reg_11_ dfcrq2 $PINS D=n793 CP=ZCTSNET_13 CDN=HFSNET_180
+ Q=src_b_lat[11] VDD=VDD VSS=VSS
Xsrc_b_lat_reg_12_ dfcrq2 $PINS D=n792 CP=ZCTSNET_219 CDN=HFSNET_186
+ Q=src_b_lat[12] VDD=VDD VSS=VSS
Xsrc_b_lat_reg_13_ dfcrq2 $PINS D=n791 CP=ZCTSNET_6 CDN=HFSNET_186
+ Q=src_b_lat[13] VDD=VDD VSS=VSS
Xsrc_b_lat_reg_14_ dfcrq2 $PINS D=n790 CP=ZCTSNET_219 CDN=HFSNET_183
+ Q=src_b_lat[14] VDD=VDD VSS=VSS
Xsrc_b_lat_reg_15_ dfcrq2 $PINS D=n789 CP=ZCTSNET_219 CDN=HFSNET_183
+ Q=src_b_lat[15] VDD=VDD VSS=VSS
Xsrc_b_lat_reg_16_ dfcrq2 $PINS D=n788 CP=ZCTSNET_219 CDN=HFSNET_183
+ Q=src_b_lat[16] VDD=VDD VSS=VSS
Xsrc_b_lat_reg_17_ dfcrq2 $PINS D=n787 CP=ZCTSNET_219 CDN=HFSNET_183
+ Q=src_b_lat[17] VDD=VDD VSS=VSS
Xsrc_b_lat_reg_18_ dfcrq2 $PINS D=n786 CP=ZCTSNET_219 CDN=HFSNET_183
+ Q=src_b_lat[18] VDD=VDD VSS=VSS
Xsrc_b_lat_reg_19_ dfcrq2 $PINS D=n785 CP=ZCTSNET_219 CDN=HFSNET_183
+ Q=src_b_lat[19] VDD=VDD VSS=VSS
Xsrc_b_lat_reg_20_ dfcrq2 $PINS D=n784 CP=ZCTSNET_219 CDN=HFSNET_183
+ Q=src_b_lat[20] VDD=VDD VSS=VSS
Xsrc_b_lat_reg_21_ dfcrq2 $PINS D=n783 CP=ZCTSNET_219 CDN=HFSNET_183
+ Q=src_b_lat[21] VDD=VDD VSS=VSS
Xsrc_b_lat_reg_22_ dfcrq2 $PINS D=n782 CP=ZCTSNET_13 CDN=HFSNET_180
+ Q=src_b_lat[22] VDD=VDD VSS=VSS
Xsrc_b_lat_reg_23_ dfcrq2 $PINS D=n781 CP=ZCTSNET_13 CDN=HFSNET_184
+ Q=src_b_lat[23] VDD=VDD VSS=VSS
Xsrc_b_lat_reg_24_ dfcrq2 $PINS D=n780 CP=ZCTSNET_12 CDN=HFSNET_184
+ Q=src_b_lat[24] VDD=VDD VSS=VSS
Xsrc_b_lat_reg_25_ dfcrq2 $PINS D=n779 CP=ZCTSNET_13 CDN=HFSNET_184
+ Q=src_b_lat[25] VDD=VDD VSS=VSS
Xsrc_b_lat_reg_26_ dfcrq2 $PINS D=n778 CP=ZCTSNET_12 CDN=HFSNET_184
+ Q=src_b_lat[26] VDD=VDD VSS=VSS
Xsrc_b_lat_reg_27_ dfcrq2 $PINS D=n777 CP=ZCTSNET_13 CDN=HFSNET_184
+ Q=src_b_lat[27] VDD=VDD VSS=VSS
Xsrc_b_lat_reg_28_ dfcrq2 $PINS D=n776 CP=ZCTSNET_13 CDN=HFSNET_184
+ Q=src_b_lat[28] VDD=VDD VSS=VSS
Xsrc_b_lat_reg_29_ dfcrq2 $PINS D=n775 CP=ZCTSNET_12 CDN=HFSNET_184
+ Q=src_b_lat[29] VDD=VDD VSS=VSS
Xsrc_b_lat_reg_30_ dfcrq2 $PINS D=n774 CP=ZCTSNET_12 CDN=HFSNET_182
+ Q=src_b_lat[30] VDD=VDD VSS=VSS
Xsrc_b_lat_reg_31_ dfcrq2 $PINS D=n773 CP=ZCTSNET_12 CDN=HFSNET_182
+ Q=src_b_lat[31] VDD=VDD VSS=VSS
Xsrc_a_lat_reg_0_ dfcrq2 $PINS D=n836 CP=ZCTSNET_219 CDN=HFSNET_186
+ Q=src_a_lat[0] VDD=VDD VSS=VSS
Xsrc_a_lat_reg_1_ dfcrq2 $PINS D=copt_net_2747 CP=ZCTSNET_7 CDN=HFSNET_187
+ Q=src_a_lat[1] VDD=VDD VSS=VSS
Xsrc_a_lat_reg_2_ dfcrq2 $PINS D=n834 CP=ZCTSNET_6 CDN=HFSNET_187
+ Q=src_a_lat[2] VDD=VDD VSS=VSS
Xsrc_a_lat_reg_3_ dfcrq2 $PINS D=n833 CP=ZCTSNET_6 CDN=HFSNET_187
+ Q=src_a_lat[3] VDD=VDD VSS=VSS
Xsrc_a_lat_reg_4_ dfcrq2 $PINS D=n832 CP=ZCTSNET_7 CDN=HFSNET_187
+ Q=src_a_lat[4] VDD=VDD VSS=VSS
Xsrc_a_lat_reg_5_ dfcrq2 $PINS D=n831 CP=ZCTSNET_7 CDN=HFSNET_187
+ Q=src_a_lat[5] VDD=VDD VSS=VSS
Xsrc_a_lat_reg_6_ dfcrq2 $PINS D=n830 CP=ZCTSNET_6 CDN=HFSNET_186
+ Q=src_a_lat[6] VDD=VDD VSS=VSS
Xsrc_a_lat_reg_7_ dfcrq2 $PINS D=n829 CP=ZCTSNET_6 CDN=HFSNET_187
+ Q=src_a_lat[7] VDD=VDD VSS=VSS
Xsrc_a_lat_reg_8_ dfcrq2 $PINS D=n828 CP=ZCTSNET_7 CDN=HFSNET_187
+ Q=src_a_lat[8] VDD=VDD VSS=VSS
Xsrc_a_lat_reg_9_ dfcrq2 $PINS D=n827 CP=ZCTSNET_7 CDN=HFSNET_187
+ Q=src_a_lat[9] VDD=VDD VSS=VSS
Xsrc_a_lat_reg_10_ dfcrq2 $PINS D=n826 CP=ZCTSNET_219 CDN=HFSNET_183
+ Q=src_a_lat[10] VDD=VDD VSS=VSS
Xsrc_a_lat_reg_11_ dfcrq2 $PINS D=n825 CP=ZCTSNET_219 CDN=HFSNET_183
+ Q=src_a_lat[11] VDD=VDD VSS=VSS
Xsrc_a_lat_reg_12_ dfcrq2 $PINS D=n824 CP=ZCTSNET_219 CDN=HFSNET_183
+ Q=src_a_lat[12] VDD=VDD VSS=VSS
Xsrc_a_lat_reg_13_ dfcrq2 $PINS D=n823 CP=ZCTSNET_219 CDN=HFSNET_183
+ Q=src_a_lat[13] VDD=VDD VSS=VSS
Xsrc_a_lat_reg_14_ dfcrq2 $PINS D=n822 CP=ZCTSNET_219 CDN=HFSNET_183
+ Q=src_a_lat[14] VDD=VDD VSS=VSS
Xsrc_a_lat_reg_15_ dfcrq2 $PINS D=n821 CP=ZCTSNET_219 CDN=HFSNET_183
+ Q=src_a_lat[15] VDD=VDD VSS=VSS
Xsrc_a_lat_reg_16_ dfcrq2 $PINS D=n820 CP=ZCTSNET_219 CDN=HFSNET_183
+ Q=src_a_lat[16] VDD=VDD VSS=VSS
Xsrc_a_lat_reg_17_ dfcrq2 $PINS D=n819 CP=ZCTSNET_219 CDN=HFSNET_183
+ Q=src_a_lat[17] VDD=VDD VSS=VSS
Xsrc_a_lat_reg_18_ dfcrq2 $PINS D=n818 CP=ZCTSNET_219 CDN=HFSNET_183
+ Q=src_a_lat[18] VDD=VDD VSS=VSS
Xsrc_a_lat_reg_19_ dfcrq2 $PINS D=n817 CP=ZCTSNET_13 CDN=HFSNET_180
+ Q=src_a_lat[19] VDD=VDD VSS=VSS
Xsrc_a_lat_reg_20_ dfcrq2 $PINS D=n816 CP=ZCTSNET_13 CDN=HFSNET_180
+ Q=src_a_lat[20] VDD=VDD VSS=VSS
Xsrc_a_lat_reg_21_ dfcrq2 $PINS D=n815 CP=ZCTSNET_13 CDN=HFSNET_180
+ Q=src_a_lat[21] VDD=VDD VSS=VSS
Xsrc_a_lat_reg_22_ dfcrq2 $PINS D=n814 CP=ZCTSNET_13 CDN=HFSNET_180
+ Q=src_a_lat[22] VDD=VDD VSS=VSS
Xsrc_a_lat_reg_23_ dfcrq2 $PINS D=n813 CP=ZCTSNET_13 CDN=HFSNET_180
+ Q=src_a_lat[23] VDD=VDD VSS=VSS
Xsrc_a_lat_reg_24_ dfcrq2 $PINS D=n812 CP=ZCTSNET_13 CDN=HFSNET_180
+ Q=src_a_lat[24] VDD=VDD VSS=VSS
Xsrc_a_lat_reg_25_ dfcrq2 $PINS D=n811 CP=ZCTSNET_13 CDN=HFSNET_180
+ Q=src_a_lat[25] VDD=VDD VSS=VSS
Xsrc_a_lat_reg_26_ dfcrq2 $PINS D=n810 CP=ZCTSNET_13 CDN=HFSNET_180
+ Q=src_a_lat[26] VDD=VDD VSS=VSS
Xsrc_a_lat_reg_27_ dfcrq2 $PINS D=n809 CP=ZCTSNET_13 CDN=HFSNET_180
+ Q=src_a_lat[27] VDD=VDD VSS=VSS
Xsrc_a_lat_reg_28_ dfcrq2 $PINS D=n808 CP=ZCTSNET_6 CDN=HFSNET_184
+ Q=src_a_lat[28] VDD=VDD VSS=VSS
Xsrc_a_lat_reg_29_ dfcrq2 $PINS D=n807 CP=ZCTSNET_7 CDN=HFSNET_187
+ Q=src_a_lat[29] VDD=VDD VSS=VSS
Xsrc_a_lat_reg_30_ dfcrq2 $PINS D=n806 CP=ZCTSNET_6 CDN=HFSNET_187
+ Q=src_a_lat[30] VDD=VDD VSS=VSS
Xsrc_a_lat_reg_31_ dfcrq2 $PINS D=n805 CP=ZCTSNET_6 CDN=HFSNET_187
+ Q=src_a_lat[31] VDD=VDD VSS=VSS
Xdest_c_lat_reg_0_ dfcrq2 $PINS D=n772 CP=ZCTSNET_212 CDN=HFSNET_185
+ Q=dest_c_lat[0] VDD=VDD VSS=VSS
Xdest_c_lat_reg_1_ dfcrq2 $PINS D=n771 CP=ZCTSNET_212 CDN=HFSNET_185
+ Q=dest_c_lat[1] VDD=VDD VSS=VSS
Xdest_c_lat_reg_2_ dfcrq2 $PINS D=copt_net_2823 CP=ZCTSNET_212 CDN=HFSNET_185
+ Q=dest_c_lat[2] VDD=VDD VSS=VSS
Xdest_c_lat_reg_3_ dfcrq2 $PINS D=n769 CP=ZCTSNET_12 CDN=HFSNET_185
+ Q=dest_c_lat[3] VDD=VDD VSS=VSS
Xdest_c_lat_reg_4_ dfcrq2 $PINS D=n768 CP=ZCTSNET_212 CDN=HFSNET_185
+ Q=dest_c_lat[4] VDD=VDD VSS=VSS
Xdest_c_lat_reg_5_ dfcrq2 $PINS D=n767 CP=ZCTSNET_12 CDN=HFSNET_185
+ Q=dest_c_lat[5] VDD=VDD VSS=VSS
Xdest_c_lat_reg_6_ dfcrq2 $PINS D=n766 CP=ZCTSNET_12 CDN=HFSNET_185
+ Q=dest_c_lat[6] VDD=VDD VSS=VSS
Xdest_c_lat_reg_7_ dfcrq2 $PINS D=n765 CP=ZCTSNET_12 CDN=HFSNET_185
+ Q=dest_c_lat[7] VDD=VDD VSS=VSS
Xdest_c_lat_reg_8_ dfcrq2 $PINS D=n764 CP=ZCTSNET_12 CDN=HFSNET_185
+ Q=dest_c_lat[8] VDD=VDD VSS=VSS
Xdest_c_lat_reg_9_ dfcrq2 $PINS D=n763 CP=ZCTSNET_13 CDN=HFSNET_184
+ Q=dest_c_lat[9] VDD=VDD VSS=VSS
Xdest_c_lat_reg_10_ dfcrq2 $PINS D=n762 CP=ZCTSNET_13 CDN=HFSNET_184
+ Q=dest_c_lat[10] VDD=VDD VSS=VSS
Xdest_c_lat_reg_11_ dfcrq2 $PINS D=n761 CP=ZCTSNET_13 CDN=HFSNET_180
+ Q=dest_c_lat[11] VDD=VDD VSS=VSS
Xdest_c_lat_reg_12_ dfcrq2 $PINS D=n760 CP=ZCTSNET_13 CDN=HFSNET_180
+ Q=dest_c_lat[12] VDD=VDD VSS=VSS
Xdest_c_lat_reg_13_ dfcrq2 $PINS D=n759 CP=ZCTSNET_13 CDN=HFSNET_180
+ Q=dest_c_lat[13] VDD=VDD VSS=VSS
Xdest_c_lat_reg_14_ dfcrq2 $PINS D=n758 CP=ZCTSNET_13 CDN=HFSNET_184
+ Q=dest_c_lat[14] VDD=VDD VSS=VSS
Xdest_c_lat_reg_15_ dfcrq2 $PINS D=n757 CP=ZCTSNET_13 CDN=HFSNET_180
+ Q=dest_c_lat[15] VDD=VDD VSS=VSS
Xdest_c_lat_reg_16_ dfcrq2 $PINS D=n756 CP=ZCTSNET_13 CDN=HFSNET_180
+ Q=dest_c_lat[16] VDD=VDD VSS=VSS
Xdest_c_lat_reg_17_ dfcrq2 $PINS D=n755 CP=ZCTSNET_13 CDN=HFSNET_184
+ Q=dest_c_lat[17] VDD=VDD VSS=VSS
Xdest_c_lat_reg_18_ dfcrq2 $PINS D=n754 CP=ZCTSNET_13 CDN=HFSNET_180
+ Q=dest_c_lat[18] VDD=VDD VSS=VSS
Xdest_c_lat_reg_19_ dfcrq2 $PINS D=n753 CP=ZCTSNET_13 CDN=HFSNET_180
+ Q=dest_c_lat[19] VDD=VDD VSS=VSS
Xdest_c_lat_reg_20_ dfcrq2 $PINS D=n752 CP=ZCTSNET_13 CDN=HFSNET_180
+ Q=dest_c_lat[20] VDD=VDD VSS=VSS
Xdest_c_lat_reg_21_ dfcrq2 $PINS D=n751 CP=ZCTSNET_13 CDN=HFSNET_180
+ Q=dest_c_lat[21] VDD=VDD VSS=VSS
Xdest_c_lat_reg_22_ dfcrq2 $PINS D=n750 CP=ZCTSNET_13 CDN=HFSNET_180
+ Q=dest_c_lat[22] VDD=VDD VSS=VSS
Xdest_c_lat_reg_23_ dfcrq2 $PINS D=n749 CP=ZCTSNET_13 CDN=HFSNET_180
+ Q=dest_c_lat[23] VDD=VDD VSS=VSS
Xdest_c_lat_reg_24_ dfcrq2 $PINS D=n748 CP=ZCTSNET_13 CDN=HFSNET_180
+ Q=dest_c_lat[24] VDD=VDD VSS=VSS
Xdest_c_lat_reg_25_ dfcrq2 $PINS D=n747 CP=ZCTSNET_13 CDN=HFSNET_180
+ Q=dest_c_lat[25] VDD=VDD VSS=VSS
Xdest_c_lat_reg_26_ dfcrq2 $PINS D=n746 CP=ZCTSNET_13 CDN=HFSNET_184
+ Q=dest_c_lat[26] VDD=VDD VSS=VSS
Xdest_c_lat_reg_27_ dfcrq2 $PINS D=n745 CP=ZCTSNET_13 CDN=HFSNET_184
+ Q=dest_c_lat[27] VDD=VDD VSS=VSS
Xdest_c_lat_reg_28_ dfcrq2 $PINS D=n744 CP=ZCTSNET_212 CDN=HFSNET_182
+ Q=dest_c_lat[28] VDD=VDD VSS=VSS
Xdest_c_lat_reg_29_ dfcrq2 $PINS D=n743 CP=ZCTSNET_7 CDN=HFSNET_184
+ Q=dest_c_lat[29] VDD=VDD VSS=VSS
Xdest_c_lat_reg_30_ dfcrq2 $PINS D=n742 CP=ZCTSNET_12 CDN=HFSNET_182
+ Q=dest_c_lat[30] VDD=VDD VSS=VSS
Xdest_c_lat_reg_31_ dfcrq2 $PINS D=n741 CP=ZCTSNET_218 CDN=HFSNET_184
+ Q=dest_c_lat[31] VDD=VDD VSS=VSS
Xjob_issued_reg dfcrq2 $PINS D=n948 CP=ZCTSNET_219 CDN=HFSNET_186 Q=job_issued
+ VDD=VDD VSS=VSS
Xerror_code_reg_0_ dfcrq2 $PINS D=n220 CP=ZCTSNET_6 CDN=HFSNET_186
+ Q=error_code[0] VDD=VDD VSS=VSS
Xcycle_reg_3_ dfcrq2 $PINS D=copt_net_2863 CP=ZCTSNET_219 CDN=HFSNET_186
+ Q=cycle[3] VDD=VDD VSS=VSS
Xm_lat_reg_2_ dfcrq2 $PINS D=n739 CP=ZCTSNET_7 CDN=HFSNET_187 Q=aps_rename_20_
+ VDD=VDD VSS=VSS
Xcycle_reg_2_ dfcrq2 $PINS D=copt_net_2824 CP=ZCTSNET_219 CDN=HFSNET_186
+ Q=cycle[2] VDD=VDD VSS=VSS
Xm_lat_reg_0_ dfcrq2 $PINS D=n840 CP=ZCTSNET_220 CDN=HFSNET_186
+ Q=aps_rename_22_ VDD=VDD VSS=VSS
Xstate_reg_1_ dfcrq2 $PINS D=copt_net_2865 CP=ZCTSNET_219 CDN=HFSNET_186
+ Q=state[1] VDD=VDD VSS=VSS
Xstate_reg_2_ dfcrq2 $PINS D=copt_net_1303 CP=ZCTSNET_220 CDN=HFSNET_186
+ Q=state[2] VDD=VDD VSS=VSS
Xcycle_reg_0_ dfcrq2 $PINS D=copt_net_2352 CP=ZCTSNET_219 CDN=HFSNET_186
+ Q=cycle[0] VDD=VDD VSS=VSS
Xstate_reg_3_ dfcrq2 $PINS D=copt_net_2879 CP=ZCTSNET_219 CDN=HFSNET_186
+ Q=state[3] VDD=VDD VSS=VSS
Xstate_reg_0_ dfcrq2 $PINS D=copt_net_2825 CP=ZCTSNET_219 CDN=HFSNET_186
+ Q=state[0] VDD=VDD VSS=VSS
Xm_lat_reg_1_ dfcrq2 $PINS D=n740 CP=ZCTSNET_212 CDN=HFSNET_182
+ Q=aps_rename_21_ VDD=VDD VSS=VSS
Xc_dst_reg_2__2__31_ dfcrq2 $PINS D=n574 CP=ZCTSNET_6 CDN=HFSNET_173
+ Q=c_dst[351] VDD=VDD VSS=VSS
Xc_dst_reg_2__2__30_ dfcrq2 $PINS D=n573 CP=ZCTSNET_10 CDN=HFSNET_181
+ Q=c_dst[350] VDD=VDD VSS=VSS
Xc_dst_reg_2__2__29_ dfcrq2 $PINS D=n572 CP=ZCTSNET_6 CDN=HFSNET_181
+ Q=c_dst[349] VDD=VDD VSS=VSS
Xc_dst_reg_2__2__28_ dfcrq2 $PINS D=n571 CP=ZCTSNET_221 CDN=HFSNET_179
+ Q=c_dst[348] VDD=VDD VSS=VSS
Xc_dst_reg_2__2__27_ dfcrq2 $PINS D=n570 CP=ZCTSNET_10 CDN=HFSNET_198
+ Q=c_dst[347] VDD=VDD VSS=VSS
Xc_dst_reg_2__2__26_ dfcrq2 $PINS D=n569 CP=ZCTSNET_207 CDN=HFSNET_175
+ Q=c_dst[346] VDD=VDD VSS=VSS
Xc_dst_reg_2__2__25_ dfcrq2 $PINS D=n568 CP=ZCTSNET_6 CDN=HFSNET_198
+ Q=c_dst[345] VDD=VDD VSS=VSS
Xc_dst_reg_2__2__24_ dfcrq2 $PINS D=n567 CP=ZCTSNET_217 CDN=HFSNET_181
+ Q=c_dst[344] VDD=VDD VSS=VSS
Xc_dst_reg_2__2__23_ dfcrq2 $PINS D=n566 CP=ZCTSNET_207 CDN=HFSNET_175
+ Q=c_dst[343] VDD=VDD VSS=VSS
Xc_dst_reg_2__2__22_ dfcrq2 $PINS D=n565 CP=ZCTSNET_216 CDN=HFSNET_189
+ Q=c_dst[342] VDD=VDD VSS=VSS
Xc_dst_reg_2__2__21_ dfcrq2 $PINS D=n564 CP=ZCTSNET_221 CDN=HFSNET_173
+ Q=c_dst[341] VDD=VDD VSS=VSS
Xc_dst_reg_2__2__20_ dfcrq2 $PINS D=n563 CP=ZCTSNET_6 CDN=HFSNET_193
+ Q=c_dst[340] VDD=VDD VSS=VSS
Xc_dst_reg_2__2__19_ dfcrq2 $PINS D=n562 CP=ZCTSNET_10 CDN=HFSNET_198
+ Q=c_dst[339] VDD=VDD VSS=VSS
Xc_dst_reg_2__2__18_ dfcrq2 $PINS D=n561 CP=ZCTSNET_212 CDN=HFSNET_181
+ Q=c_dst[338] VDD=VDD VSS=VSS
Xc_dst_reg_2__2__17_ dfcrq2 $PINS D=n560 CP=ZCTSNET_19 CDN=HFSNET_190
+ Q=c_dst[337] VDD=VDD VSS=VSS
Xc_dst_reg_2__2__16_ dfcrq2 $PINS D=n559 CP=ZCTSNET_207 CDN=HFSNET_179
+ Q=c_dst[336] VDD=VDD VSS=VSS
Xc_dst_reg_2__2__15_ dfcrq2 $PINS D=n558 CP=ZCTSNET_221 CDN=HFSNET_173
+ Q=c_dst[335] VDD=VDD VSS=VSS
Xc_dst_reg_2__2__14_ dfcrq2 $PINS D=copt_net_2755 CP=ZCTSNET_221 CDN=HFSNET_173
+ Q=c_dst[334] VDD=VDD VSS=VSS
Xc_dst_reg_2__2__13_ dfcrq2 $PINS D=copt_net_2798 CP=ZCTSNET_216 CDN=HFSNET_197
+ Q=c_dst[333] VDD=VDD VSS=VSS
Xc_dst_reg_2__2__12_ dfcrq2 $PINS D=n555 CP=ZCTSNET_216 CDN=HFSNET_198
+ Q=c_dst[332] VDD=VDD VSS=VSS
Xc_dst_reg_2__2__11_ dfcrq2 $PINS D=n554 CP=ZCTSNET_10 CDN=HFSNET_182
+ Q=c_dst[331] VDD=VDD VSS=VSS
Xc_dst_reg_2__2__10_ dfcrq2 $PINS D=n553 CP=ZCTSNET_6 CDN=HFSNET_193
+ Q=c_dst[330] VDD=VDD VSS=VSS
Xc_dst_reg_2__2__9_ dfcrq2 $PINS D=n552 CP=ZCTSNET_6 CDN=HFSNET_181
+ Q=c_dst[329] VDD=VDD VSS=VSS
Xc_dst_reg_2__2__8_ dfcrq2 $PINS D=n551 CP=ZCTSNET_6 CDN=HFSNET_181
+ Q=c_dst[328] VDD=VDD VSS=VSS
Xc_dst_reg_2__2__7_ dfcrq2 $PINS D=n550 CP=ZCTSNET_9 CDN=HFSNET_193
+ Q=c_dst[327] VDD=VDD VSS=VSS
Xc_dst_reg_2__2__6_ dfcrq2 $PINS D=n549 CP=ZCTSNET_9 CDN=HFSNET_193
+ Q=c_dst[326] VDD=VDD VSS=VSS
Xc_dst_reg_2__2__5_ dfcrq2 $PINS D=n548 CP=ZCTSNET_202 CDN=HFSNET_188
+ Q=c_dst[325] VDD=VDD VSS=VSS
Xc_dst_reg_2__2__4_ dfcrq2 $PINS D=n547 CP=ZCTSNET_216 CDN=HFSNET_189
+ Q=c_dst[324] VDD=VDD VSS=VSS
Xc_dst_reg_2__2__3_ dfcrq2 $PINS D=n546 CP=ZCTSNET_19 CDN=HFSNET_190
+ Q=c_dst[323] VDD=VDD VSS=VSS
Xc_dst_reg_2__2__2_ dfcrq2 $PINS D=n545 CP=ZCTSNET_9 CDN=HFSNET_193
+ Q=c_dst[322] VDD=VDD VSS=VSS
Xc_dst_reg_2__2__1_ dfcrq2 $PINS D=n544 CP=ZCTSNET_216 CDN=HFSNET_189
+ Q=c_dst[321] VDD=VDD VSS=VSS
Xc_dst_reg_2__2__0_ dfcrq2 $PINS D=n543 CP=ZCTSNET_10 CDN=HFSNET_181
+ Q=c_dst[320] VDD=VDD VSS=VSS
Xc_dst_reg_2__0__31_ dfcrq2 $PINS D=copt_net_341 CP=ZCTSNET_8 CDN=HFSNET_175
+ Q=c_dst[287] VDD=VDD VSS=VSS
Xc_dst_reg_2__0__30_ dfcrq2 $PINS D=n509 CP=ZCTSNET_216 CDN=HFSNET_198
+ Q=c_dst[286] VDD=VDD VSS=VSS
Xc_dst_reg_2__0__29_ dfcrq2 $PINS D=n508 CP=ZCTSNET_6 CDN=HFSNET_193
+ Q=c_dst[285] VDD=VDD VSS=VSS
Xc_dst_reg_2__0__28_ dfcrq2 $PINS D=n507 CP=ZCTSNET_6 CDN=HFSNET_193
+ Q=c_dst[284] VDD=VDD VSS=VSS
Xc_dst_reg_2__0__27_ dfcrq2 $PINS D=n506 CP=ZCTSNET_19 CDN=HFSNET_192
+ Q=c_dst[283] VDD=VDD VSS=VSS
Xc_dst_reg_2__0__26_ dfcrq2 $PINS D=n505 CP=ZCTSNET_212 CDN=HFSNET_185
+ Q=c_dst[282] VDD=VDD VSS=VSS
Xc_dst_reg_2__0__25_ dfcrq2 $PINS D=n504 CP=ZCTSNET_10 CDN=HFSNET_181
+ Q=c_dst[281] VDD=VDD VSS=VSS
Xc_dst_reg_2__0__24_ dfcrq2 $PINS D=n503 CP=ZCTSNET_18 CDN=HFSNET_195
+ Q=c_dst[280] VDD=VDD VSS=VSS
Xc_dst_reg_2__0__23_ dfcrq2 $PINS D=n502 CP=ZCTSNET_207 CDN=HFSNET_175
+ Q=c_dst[279] VDD=VDD VSS=VSS
Xc_dst_reg_2__0__22_ dfcrq2 $PINS D=n501 CP=ZCTSNET_19 CDN=HFSNET_190
+ Q=c_dst[278] VDD=VDD VSS=VSS
Xc_dst_reg_2__0__21_ dfcrq2 $PINS D=n500 CP=ZCTSNET_202 CDN=HFSNET_190
+ Q=c_dst[277] VDD=VDD VSS=VSS
Xc_dst_reg_2__0__20_ dfcrq2 $PINS D=n499 CP=ZCTSNET_216 CDN=HFSNET_189
+ Q=c_dst[276] VDD=VDD VSS=VSS
Xc_dst_reg_2__0__19_ dfcrq2 $PINS D=n498 CP=ZCTSNET_207 CDN=HFSNET_175
+ Q=c_dst[275] VDD=VDD VSS=VSS
Xc_dst_reg_2__0__18_ dfcrq2 $PINS D=n497 CP=ZCTSNET_6 CDN=HFSNET_182
+ Q=c_dst[274] VDD=VDD VSS=VSS
Xc_dst_reg_2__0__17_ dfcrq2 $PINS D=n496 CP=ZCTSNET_207 CDN=HFSNET_175
+ Q=c_dst[273] VDD=VDD VSS=VSS
Xc_dst_reg_2__0__16_ dfcrq2 $PINS D=n495 CP=ZCTSNET_207 CDN=HFSNET_175
+ Q=c_dst[272] VDD=VDD VSS=VSS
Xc_dst_reg_2__0__15_ dfcrq2 $PINS D=n494 CP=ZCTSNET_19 CDN=HFSNET_190
+ Q=c_dst[271] VDD=VDD VSS=VSS
Xc_dst_reg_2__0__14_ dfcrq2 $PINS D=n493 CP=ZCTSNET_19 CDN=HFSNET_192
+ Q=c_dst[270] VDD=VDD VSS=VSS
Xc_dst_reg_2__0__13_ dfcrq2 $PINS D=n492 CP=ZCTSNET_208 CDN=HFSNET_200
+ Q=c_dst[269] VDD=VDD VSS=VSS
Xc_dst_reg_2__0__12_ dfcrq2 $PINS D=n491 CP=ZCTSNET_19 CDN=HFSNET_190
+ Q=c_dst[268] VDD=VDD VSS=VSS
Xc_dst_reg_2__0__11_ dfcrq2 $PINS D=n490 CP=ZCTSNET_207 CDN=HFSNET_175
+ Q=c_dst[267] VDD=VDD VSS=VSS
Xc_dst_reg_2__0__10_ dfcrq2 $PINS D=n489 CP=ZCTSNET_207 CDN=HFSNET_175
+ Q=c_dst[266] VDD=VDD VSS=VSS
Xc_dst_reg_2__0__9_ dfcrq2 $PINS D=n488 CP=ZCTSNET_216 CDN=HFSNET_197
+ Q=c_dst[265] VDD=VDD VSS=VSS
Xc_dst_reg_2__0__8_ dfcrq2 $PINS D=n487 CP=ZCTSNET_207 CDN=HFSNET_175
+ Q=c_dst[264] VDD=VDD VSS=VSS
Xc_dst_reg_2__0__7_ dfcrq2 $PINS D=n486 CP=ZCTSNET_19 CDN=HFSNET_190
+ Q=c_dst[263] VDD=VDD VSS=VSS
Xc_dst_reg_2__0__6_ dfcrq2 $PINS D=n485 CP=ZCTSNET_207 CDN=HFSNET_192
+ Q=c_dst[262] VDD=VDD VSS=VSS
Xc_dst_reg_2__0__5_ dfcrq2 $PINS D=copt_net_2797 CP=ZCTSNET_19 CDN=HFSNET_190
+ Q=c_dst[261] VDD=VDD VSS=VSS
Xc_dst_reg_2__0__4_ dfcrq2 $PINS D=n483 CP=ZCTSNET_19 CDN=HFSNET_190
+ Q=c_dst[260] VDD=VDD VSS=VSS
Xc_dst_reg_2__0__3_ dfcrq2 $PINS D=n482 CP=ZCTSNET_19 CDN=HFSNET_190
+ Q=c_dst[259] VDD=VDD VSS=VSS
Xc_dst_reg_2__0__2_ dfcrq2 $PINS D=n481 CP=ZCTSNET_17 CDN=HFSNET_190
+ Q=c_dst[258] VDD=VDD VSS=VSS
Xc_dst_reg_2__0__1_ dfcrq2 $PINS D=n480 CP=ZCTSNET_216 CDN=HFSNET_189
+ Q=c_dst[257] VDD=VDD VSS=VSS
Xc_dst_reg_2__0__0_ dfcrq2 $PINS D=n479 CP=ZCTSNET_216 CDN=HFSNET_189
+ Q=c_dst[256] VDD=VDD VSS=VSS
Xc_dst_reg_0__2__31_ dfcrq2 $PINS D=n318 CP=ZCTSNET_210 CDN=rst_n Q=c_dst[95]
+ VDD=VDD VSS=VSS
Xc_dst_reg_0__2__30_ dfcrq2 $PINS D=n317 CP=ZCTSNET_221 CDN=rst_n Q=c_dst[94]
+ VDD=VDD VSS=VSS
Xc_dst_reg_0__2__29_ dfcrq2 $PINS D=n316 CP=ZCTSNET_221 CDN=rst_n Q=c_dst[93]
+ VDD=VDD VSS=VSS
Xc_dst_reg_0__2__28_ dfcrq2 $PINS D=n315 CP=ZCTSNET_221 CDN=rst_n Q=c_dst[92]
+ VDD=VDD VSS=VSS
Xc_dst_reg_0__2__27_ dfcrq2 $PINS D=n314 CP=ZCTSNET_1 CDN=HFSNET_172
+ Q=c_dst[91] VDD=VDD VSS=VSS
Xc_dst_reg_0__2__26_ dfcrq2 $PINS D=n313 CP=ZCTSNET_221 CDN=rst_n Q=c_dst[90]
+ VDD=VDD VSS=VSS
Xc_dst_reg_0__2__25_ dfcrq2 $PINS D=copt_net_2894 CP=ZCTSNET_221 CDN=rst_n
+ Q=c_dst[89] VDD=VDD VSS=VSS
Xc_dst_reg_0__2__24_ dfcrq2 $PINS D=n311 CP=ZCTSNET_1 CDN=rst_n Q=c_dst[88]
+ VDD=VDD VSS=VSS
Xc_dst_reg_0__2__23_ dfcrq2 $PINS D=n310 CP=ZCTSNET_221 CDN=rst_n Q=c_dst[87]
+ VDD=VDD VSS=VSS
Xc_dst_reg_0__2__22_ dfcrq2 $PINS D=n309 CP=ZCTSNET_221 CDN=HFSNET_179
+ Q=c_dst[86] VDD=VDD VSS=VSS
Xc_dst_reg_0__2__21_ dfcrq2 $PINS D=copt_net_2757 CP=ZCTSNET_221 CDN=HFSNET_179
+ Q=c_dst[85] VDD=VDD VSS=VSS
Xc_dst_reg_0__2__20_ dfcrq2 $PINS D=n307 CP=ZCTSNET_221 CDN=HFSNET_179
+ Q=c_dst[84] VDD=VDD VSS=VSS
Xc_dst_reg_0__2__19_ dfcrq2 $PINS D=n306 CP=ZCTSNET_221 CDN=HFSNET_179
+ Q=c_dst[83] VDD=VDD VSS=VSS
Xc_dst_reg_0__2__18_ dfcrq2 $PINS D=n305 CP=ZCTSNET_221 CDN=HFSNET_179
+ Q=c_dst[82] VDD=VDD VSS=VSS
Xc_dst_reg_0__2__17_ dfcrq2 $PINS D=n304 CP=ZCTSNET_221 CDN=HFSNET_179
+ Q=c_dst[81] VDD=VDD VSS=VSS
Xc_dst_reg_0__2__16_ dfcrq2 $PINS D=n303 CP=ZCTSNET_221 CDN=HFSNET_179
+ Q=c_dst[80] VDD=VDD VSS=VSS
Xc_dst_reg_0__2__15_ dfcrq2 $PINS D=n302 CP=ZCTSNET_221 CDN=HFSNET_179
+ Q=c_dst[79] VDD=VDD VSS=VSS
Xc_dst_reg_0__2__14_ dfcrq2 $PINS D=n301 CP=ZCTSNET_221 CDN=HFSNET_179
+ Q=c_dst[78] VDD=VDD VSS=VSS
Xc_dst_reg_0__2__13_ dfcrq2 $PINS D=n300 CP=ZCTSNET_216 CDN=HFSNET_197
+ Q=c_dst[77] VDD=VDD VSS=VSS
Xc_dst_reg_0__2__12_ dfcrq2 $PINS D=n299 CP=ZCTSNET_216 CDN=HFSNET_197
+ Q=c_dst[76] VDD=VDD VSS=VSS
Xc_dst_reg_0__2__11_ dfcrq2 $PINS D=n298 CP=ZCTSNET_216 CDN=HFSNET_197
+ Q=c_dst[75] VDD=VDD VSS=VSS
Xc_dst_reg_0__2__10_ dfcrq2 $PINS D=n297 CP=ZCTSNET_204 CDN=HFSNET_197
+ Q=c_dst[74] VDD=VDD VSS=VSS
Xc_dst_reg_0__2__9_ dfcrq2 $PINS D=n296 CP=ZCTSNET_204 CDN=HFSNET_197
+ Q=c_dst[73] VDD=VDD VSS=VSS
Xc_dst_reg_0__2__8_ dfcrq2 $PINS D=n295 CP=ZCTSNET_204 CDN=HFSNET_197
+ Q=c_dst[72] VDD=VDD VSS=VSS
Xc_dst_reg_0__2__7_ dfcrq2 $PINS D=n294 CP=ZCTSNET_216 CDN=HFSNET_197
+ Q=c_dst[71] VDD=VDD VSS=VSS
Xc_dst_reg_0__2__6_ dfcrq2 $PINS D=n293 CP=ZCTSNET_204 CDN=HFSNET_191
+ Q=c_dst[70] VDD=VDD VSS=VSS
Xc_dst_reg_0__2__5_ dfcrq2 $PINS D=n292 CP=ZCTSNET_204 CDN=HFSNET_191
+ Q=c_dst[69] VDD=VDD VSS=VSS
Xc_dst_reg_0__2__4_ dfcrq2 $PINS D=n291 CP=ZCTSNET_216 CDN=HFSNET_197
+ Q=c_dst[68] VDD=VDD VSS=VSS
Xc_dst_reg_0__2__3_ dfcrq2 $PINS D=n290 CP=ZCTSNET_216 CDN=HFSNET_195
+ Q=c_dst[67] VDD=VDD VSS=VSS
Xc_dst_reg_0__2__2_ dfcrq2 $PINS D=n289 CP=ZCTSNET_204 CDN=HFSNET_197
+ Q=c_dst[66] VDD=VDD VSS=VSS
Xc_dst_reg_0__2__1_ dfcrq2 $PINS D=n288 CP=ZCTSNET_204 CDN=HFSNET_197
+ Q=c_dst[65] VDD=VDD VSS=VSS
Xc_dst_reg_0__2__0_ dfcrq2 $PINS D=n287 CP=ZCTSNET_216 CDN=HFSNET_197
+ Q=c_dst[64] VDD=VDD VSS=VSS
Xc_dst_reg_0__0__31_ dfcrq2 $PINS D=n254 CP=ZCTSNET_8 CDN=HFSNET_176
+ Q=c_dst[31] VDD=VDD VSS=VSS
Xc_dst_reg_0__0__30_ dfcrq2 $PINS D=n253 CP=ZCTSNET_19 CDN=HFSNET_192
+ Q=c_dst[30] VDD=VDD VSS=VSS
Xc_dst_reg_0__0__29_ dfcrq2 $PINS D=n252 CP=ZCTSNET_19 CDN=HFSNET_192
+ Q=c_dst[29] VDD=VDD VSS=VSS
Xc_dst_reg_0__0__28_ dfcrq2 $PINS D=n251 CP=ZCTSNET_8 CDN=HFSNET_176
+ Q=c_dst[28] VDD=VDD VSS=VSS
Xc_dst_reg_0__0__27_ dfcrq2 $PINS D=n250 CP=ZCTSNET_19 CDN=HFSNET_192
+ Q=c_dst[27] VDD=VDD VSS=VSS
Xc_dst_reg_0__0__26_ dfcrq2 $PINS D=n249 CP=ZCTSNET_19 CDN=HFSNET_192
+ Q=c_dst[26] VDD=VDD VSS=VSS
Xc_dst_reg_0__0__25_ dfcrq2 $PINS D=copt_net_2752 CP=ZCTSNET_8 CDN=HFSNET_176
+ Q=c_dst[25] VDD=VDD VSS=VSS
Xc_dst_reg_0__0__24_ dfcrq2 $PINS D=n247 CP=ZCTSNET_19 CDN=HFSNET_192
+ Q=c_dst[24] VDD=VDD VSS=VSS
Xc_dst_reg_0__0__23_ dfcrq2 $PINS D=n246 CP=ZCTSNET_202 CDN=HFSNET_174
+ Q=c_dst[23] VDD=VDD VSS=VSS
Xc_dst_reg_0__0__22_ dfcrq2 $PINS D=n245 CP=ZCTSNET_202 CDN=HFSNET_188
+ Q=c_dst[22] VDD=VDD VSS=VSS
Xc_dst_reg_0__0__21_ dfcrq2 $PINS D=n244 CP=ZCTSNET_18 CDN=HFSNET_188
+ Q=c_dst[21] VDD=VDD VSS=VSS
Xc_dst_reg_0__0__20_ dfcrq2 $PINS D=n243 CP=ZCTSNET_18 CDN=HFSNET_188
+ Q=c_dst[20] VDD=VDD VSS=VSS
Xc_dst_reg_0__0__19_ dfcrq2 $PINS D=n242 CP=ZCTSNET_202 CDN=HFSNET_188
+ Q=c_dst[19] VDD=VDD VSS=VSS
Xc_dst_reg_0__0__18_ dfcrq2 $PINS D=n241 CP=ZCTSNET_202 CDN=HFSNET_188
+ Q=c_dst[18] VDD=VDD VSS=VSS
Xc_dst_reg_0__0__17_ dfcrq2 $PINS D=n240 CP=ZCTSNET_19 CDN=HFSNET_174
+ Q=c_dst[17] VDD=VDD VSS=VSS
Xc_dst_reg_0__0__16_ dfcrq2 $PINS D=n239 CP=ZCTSNET_202 CDN=HFSNET_174
+ Q=c_dst[16] VDD=VDD VSS=VSS
Xc_dst_reg_0__0__15_ dfcrq2 $PINS D=n238 CP=ZCTSNET_202 CDN=HFSNET_174
+ Q=c_dst[15] VDD=VDD VSS=VSS
Xc_dst_reg_0__0__14_ dfcrq2 $PINS D=n237 CP=ZCTSNET_202 CDN=HFSNET_174
+ Q=c_dst[14] VDD=VDD VSS=VSS
Xc_dst_reg_0__0__13_ dfcrq2 $PINS D=n236 CP=ZCTSNET_202 CDN=HFSNET_174
+ Q=c_dst[13] VDD=VDD VSS=VSS
Xc_dst_reg_0__0__12_ dfcrq2 $PINS D=n235 CP=ZCTSNET_202 CDN=HFSNET_174
+ Q=c_dst[12] VDD=VDD VSS=VSS
Xc_dst_reg_0__0__11_ dfcrq2 $PINS D=n234 CP=ZCTSNET_202 CDN=HFSNET_174
+ Q=c_dst[11] VDD=VDD VSS=VSS
Xc_dst_reg_0__0__10_ dfcrq2 $PINS D=n233 CP=ZCTSNET_202 CDN=HFSNET_174
+ Q=c_dst[10] VDD=VDD VSS=VSS
Xc_dst_reg_0__0__9_ dfcrq2 $PINS D=n232 CP=ZCTSNET_202 CDN=HFSNET_174
+ Q=c_dst[9] VDD=VDD VSS=VSS
Xc_dst_reg_0__0__8_ dfcrq2 $PINS D=n231 CP=ZCTSNET_202 CDN=HFSNET_174
+ Q=c_dst[8] VDD=VDD VSS=VSS
Xc_dst_reg_0__0__7_ dfcrq2 $PINS D=n230 CP=ZCTSNET_202 CDN=HFSNET_174
+ Q=c_dst[7] VDD=VDD VSS=VSS
Xc_dst_reg_0__0__6_ dfcrq2 $PINS D=n229 CP=ZCTSNET_202 CDN=HFSNET_174
+ Q=c_dst[6] VDD=VDD VSS=VSS
Xc_dst_reg_0__0__5_ dfcrq2 $PINS D=n228 CP=ZCTSNET_202 CDN=HFSNET_188
+ Q=c_dst[5] VDD=VDD VSS=VSS
Xc_dst_reg_0__0__4_ dfcrq2 $PINS D=n227 CP=ZCTSNET_202 CDN=HFSNET_190
+ Q=c_dst[4] VDD=VDD VSS=VSS
Xc_dst_reg_0__0__3_ dfcrq2 $PINS D=n226 CP=ZCTSNET_17 CDN=HFSNET_188 Q=c_dst[3]
+ VDD=VDD VSS=VSS
Xc_dst_reg_0__0__2_ dfcrq2 $PINS D=n225 CP=ZCTSNET_202 CDN=HFSNET_188
+ Q=c_dst[2] VDD=VDD VSS=VSS
Xc_dst_reg_0__0__1_ dfcrq2 $PINS D=n224 CP=ZCTSNET_19 CDN=HFSNET_190 Q=c_dst[1]
+ VDD=VDD VSS=VSS
Xc_dst_reg_0__0__0_ dfcrq2 $PINS D=n223 CP=ZCTSNET_18 CDN=HFSNET_190 Q=c_dst[0]
+ VDD=VDD VSS=VSS
Xc_dst_reg_3__2__31_ dfcrq2 $PINS D=n702 CP=ZCTSNET_6 CDN=HFSNET_181
+ Q=c_dst[479] VDD=VDD VSS=VSS
Xc_dst_reg_3__2__30_ dfcrq2 $PINS D=n701 CP=ZCTSNET_10 CDN=HFSNET_182
+ Q=c_dst[478] VDD=VDD VSS=VSS
Xc_dst_reg_3__2__29_ dfcrq2 $PINS D=n700 CP=ZCTSNET_11 CDN=HFSNET_181
+ Q=c_dst[477] VDD=VDD VSS=VSS
Xc_dst_reg_3__2__28_ dfcrq2 $PINS D=n699 CP=ZCTSNET_4 CDN=HFSNET_200
+ Q=c_dst[476] VDD=VDD VSS=VSS
Xc_dst_reg_3__2__27_ dfcrq2 $PINS D=n698 CP=ZCTSNET_6 CDN=HFSNET_181
+ Q=c_dst[475] VDD=VDD VSS=VSS
Xc_dst_reg_3__2__26_ dfcrq2 $PINS D=n697 CP=ZCTSNET_6 CDN=HFSNET_182
+ Q=c_dst[474] VDD=VDD VSS=VSS
Xc_dst_reg_3__2__25_ dfcrq2 $PINS D=n696 CP=ZCTSNET_1 CDN=HFSNET_172
+ Q=c_dst[473] VDD=VDD VSS=VSS
Xc_dst_reg_3__2__24_ dfcrq2 $PINS D=n695 CP=ZCTSNET_1 CDN=HFSNET_172
+ Q=c_dst[472] VDD=VDD VSS=VSS
Xc_dst_reg_3__2__23_ dfcrq2 $PINS D=n694 CP=ZCTSNET_221 CDN=HFSNET_179
+ Q=c_dst[471] VDD=VDD VSS=VSS
Xc_dst_reg_3__2__22_ dfcrq2 $PINS D=n693 CP=ZCTSNET_18 CDN=HFSNET_195
+ Q=c_dst[470] VDD=VDD VSS=VSS
Xc_dst_reg_3__2__21_ dfcrq2 $PINS D=n692 CP=ZCTSNET_221 CDN=HFSNET_179
+ Q=c_dst[469] VDD=VDD VSS=VSS
Xc_dst_reg_3__2__20_ dfcrq2 $PINS D=n691 CP=ZCTSNET_221 CDN=HFSNET_179
+ Q=c_dst[468] VDD=VDD VSS=VSS
Xc_dst_reg_3__2__19_ dfcrq2 $PINS D=n690 CP=ZCTSNET_10 CDN=HFSNET_182
+ Q=c_dst[467] VDD=VDD VSS=VSS
Xc_dst_reg_3__2__18_ dfcrq2 $PINS D=n689 CP=ZCTSNET_212 CDN=HFSNET_181
+ Q=c_dst[466] VDD=VDD VSS=VSS
Xc_dst_reg_3__2__17_ dfcrq2 $PINS D=n688 CP=ZCTSNET_6 CDN=HFSNET_187
+ Q=c_dst[465] VDD=VDD VSS=VSS
Xc_dst_reg_3__2__16_ dfcrq2 $PINS D=copt_net_2753 CP=ZCTSNET_221 CDN=HFSNET_179
+ Q=c_dst[464] VDD=VDD VSS=VSS
Xc_dst_reg_3__2__15_ dfcrq2 $PINS D=n686 CP=ZCTSNET_221 CDN=HFSNET_175
+ Q=c_dst[463] VDD=VDD VSS=VSS
Xc_dst_reg_3__2__14_ dfcrq2 $PINS D=n685 CP=ZCTSNET_207 CDN=HFSNET_192
+ Q=c_dst[462] VDD=VDD VSS=VSS
Xc_dst_reg_3__2__13_ dfcrq2 $PINS D=n684 CP=ZCTSNET_19 CDN=HFSNET_192
+ Q=c_dst[461] VDD=VDD VSS=VSS
Xc_dst_reg_3__2__12_ dfcrq2 $PINS D=n683 CP=ZCTSNET_19 CDN=HFSNET_190
+ Q=c_dst[460] VDD=VDD VSS=VSS
Xc_dst_reg_3__2__11_ dfcrq2 $PINS D=n682 CP=ZCTSNET_19 CDN=HFSNET_192
+ Q=c_dst[459] VDD=VDD VSS=VSS
Xc_dst_reg_3__2__10_ dfcrq2 $PINS D=n681 CP=ZCTSNET_216 CDN=HFSNET_193
+ Q=c_dst[458] VDD=VDD VSS=VSS
Xc_dst_reg_3__2__9_ dfcrq2 $PINS D=n680 CP=ZCTSNET_4 CDN=HFSNET_201
+ Q=c_dst[457] VDD=VDD VSS=VSS
Xc_dst_reg_3__2__8_ dfcrq2 $PINS D=n679 CP=ZCTSNET_217 CDN=HFSNET_172
+ Q=c_dst[456] VDD=VDD VSS=VSS
Xc_dst_reg_3__2__7_ dfcrq2 $PINS D=n678 CP=ZCTSNET_220 CDN=HFSNET_186
+ Q=c_dst[455] VDD=VDD VSS=VSS
Xc_dst_reg_3__2__6_ dfcrq2 $PINS D=n677 CP=ZCTSNET_204 CDN=HFSNET_197
+ Q=c_dst[454] VDD=VDD VSS=VSS
Xc_dst_reg_3__2__5_ dfcrq2 $PINS D=n676 CP=ZCTSNET_220 CDN=HFSNET_187
+ Q=c_dst[453] VDD=VDD VSS=VSS
Xc_dst_reg_3__2__4_ dfcrq2 $PINS D=n675 CP=ZCTSNET_9 CDN=HFSNET_193
+ Q=c_dst[452] VDD=VDD VSS=VSS
Xc_dst_reg_3__2__3_ dfcrq2 $PINS D=n674 CP=ZCTSNET_9 CDN=HFSNET_187
+ Q=c_dst[451] VDD=VDD VSS=VSS
Xc_dst_reg_3__2__2_ dfcrq2 $PINS D=n673 CP=ZCTSNET_9 CDN=HFSNET_187
+ Q=c_dst[450] VDD=VDD VSS=VSS
Xc_dst_reg_3__2__1_ dfcrq2 $PINS D=n672 CP=ZCTSNET_9 CDN=HFSNET_187
+ Q=c_dst[449] VDD=VDD VSS=VSS
Xc_dst_reg_3__2__0_ dfcrq2 $PINS D=n671 CP=ZCTSNET_19 CDN=HFSNET_190
+ Q=c_dst[448] VDD=VDD VSS=VSS
Xc_dst_reg_2__3__31_ dfcrq2 $PINS D=n606 CP=ZCTSNET_6 CDN=HFSNET_182
+ Q=c_dst[383] VDD=VDD VSS=VSS
Xc_dst_reg_2__3__30_ dfcrq2 $PINS D=n605 CP=ZCTSNET_6 CDN=HFSNET_187
+ Q=c_dst[382] VDD=VDD VSS=VSS
Xc_dst_reg_2__3__29_ dfcrq2 $PINS D=n604 CP=ZCTSNET_212 CDN=HFSNET_182
+ Q=c_dst[381] VDD=VDD VSS=VSS
Xc_dst_reg_2__3__28_ dfcrq2 $PINS D=n603 CP=ZCTSNET_212 CDN=HFSNET_182
+ Q=c_dst[380] VDD=VDD VSS=VSS
Xc_dst_reg_2__3__27_ dfcrq2 $PINS D=n602 CP=ZCTSNET_6 CDN=HFSNET_182
+ Q=c_dst[379] VDD=VDD VSS=VSS
Xc_dst_reg_2__3__26_ dfcrq2 $PINS D=n601 CP=ZCTSNET_217 CDN=HFSNET_199
+ Q=c_dst[378] VDD=VDD VSS=VSS
Xc_dst_reg_2__3__25_ dfcrq2 $PINS D=n600 CP=ZCTSNET_217 CDN=HFSNET_200
+ Q=c_dst[377] VDD=VDD VSS=VSS
Xc_dst_reg_2__3__24_ dfcrq2 $PINS D=n599 CP=ZCTSNET_217 CDN=HFSNET_200
+ Q=c_dst[376] VDD=VDD VSS=VSS
Xc_dst_reg_2__3__23_ dfcrq2 $PINS D=n598 CP=ZCTSNET_19 CDN=HFSNET_192
+ Q=c_dst[375] VDD=VDD VSS=VSS
Xc_dst_reg_2__3__22_ dfcrq2 $PINS D=n597 CP=ZCTSNET_1 CDN=HFSNET_172
+ Q=c_dst[374] VDD=VDD VSS=VSS
Xc_dst_reg_2__3__21_ dfcrq2 $PINS D=n596 CP=ZCTSNET_208 CDN=HFSNET_200
+ Q=c_dst[373] VDD=VDD VSS=VSS
Xc_dst_reg_2__3__20_ dfcrq2 $PINS D=n595 CP=ZCTSNET_6 CDN=HFSNET_193
+ Q=c_dst[372] VDD=VDD VSS=VSS
Xc_dst_reg_2__3__19_ dfcrq2 $PINS D=n594 CP=ZCTSNET_4 CDN=HFSNET_200
+ Q=c_dst[371] VDD=VDD VSS=VSS
Xc_dst_reg_2__3__18_ dfcrq2 $PINS D=copt_net_2756 CP=ZCTSNET_221 CDN=HFSNET_179
+ Q=c_dst[370] VDD=VDD VSS=VSS
Xc_dst_reg_2__3__17_ dfcrq2 $PINS D=n592 CP=ZCTSNET_217 CDN=HFSNET_200
+ Q=c_dst[369] VDD=VDD VSS=VSS
Xc_dst_reg_2__3__16_ dfcrq2 $PINS D=n591 CP=ZCTSNET_211 CDN=HFSNET_200
+ Q=c_dst[368] VDD=VDD VSS=VSS
Xc_dst_reg_2__3__15_ dfcrq2 $PINS D=n590 CP=ZCTSNET_6 CDN=HFSNET_173
+ Q=c_dst[367] VDD=VDD VSS=VSS
Xc_dst_reg_2__3__14_ dfcrq2 $PINS D=n589 CP=ZCTSNET_208 CDN=HFSNET_200
+ Q=c_dst[366] VDD=VDD VSS=VSS
Xc_dst_reg_2__3__13_ dfcrq2 $PINS D=n588 CP=ZCTSNET_6 CDN=HFSNET_181
+ Q=c_dst[365] VDD=VDD VSS=VSS
Xc_dst_reg_2__3__12_ dfcrq2 $PINS D=n587 CP=ZCTSNET_221 CDN=HFSNET_179
+ Q=c_dst[364] VDD=VDD VSS=VSS
Xc_dst_reg_2__3__11_ dfcrq2 $PINS D=n586 CP=ZCTSNET_6 CDN=HFSNET_172
+ Q=c_dst[363] VDD=VDD VSS=VSS
Xc_dst_reg_2__3__10_ dfcrq2 $PINS D=n585 CP=ZCTSNET_6 CDN=HFSNET_173
+ Q=c_dst[362] VDD=VDD VSS=VSS
Xc_dst_reg_2__3__9_ dfcrq2 $PINS D=n584 CP=ZCTSNET_212 CDN=HFSNET_181
+ Q=c_dst[361] VDD=VDD VSS=VSS
Xc_dst_reg_2__3__8_ dfcrq2 $PINS D=n583 CP=ZCTSNET_11 CDN=HFSNET_181
+ Q=c_dst[360] VDD=VDD VSS=VSS
Xc_dst_reg_2__3__7_ dfcrq2 $PINS D=n582 CP=ZCTSNET_6 CDN=HFSNET_200
+ Q=c_dst[359] VDD=VDD VSS=VSS
Xc_dst_reg_2__3__6_ dfcrq2 $PINS D=n581 CP=ZCTSNET_6 CDN=HFSNET_173
+ Q=c_dst[358] VDD=VDD VSS=VSS
Xc_dst_reg_2__3__5_ dfcrq2 $PINS D=copt_net_2751 CP=ZCTSNET_211 CDN=HFSNET_200
+ Q=c_dst[357] VDD=VDD VSS=VSS
Xc_dst_reg_2__3__4_ dfcrq2 $PINS D=n579 CP=ZCTSNET_208 CDN=HFSNET_200
+ Q=c_dst[356] VDD=VDD VSS=VSS
Xc_dst_reg_2__3__3_ dfcrq2 $PINS D=n578 CP=ZCTSNET_6 CDN=HFSNET_173
+ Q=c_dst[355] VDD=VDD VSS=VSS
Xc_dst_reg_2__3__2_ dfcrq2 $PINS D=n577 CP=ZCTSNET_212 CDN=HFSNET_181
+ Q=c_dst[354] VDD=VDD VSS=VSS
Xc_dst_reg_2__3__1_ dfcrq2 $PINS D=n576 CP=ZCTSNET_221 CDN=HFSNET_175
+ Q=c_dst[353] VDD=VDD VSS=VSS
Xc_dst_reg_2__3__0_ dfcrq2 $PINS D=n575 CP=ZCTSNET_216 CDN=HFSNET_198
+ Q=c_dst[352] VDD=VDD VSS=VSS
Xc_dst_reg_3__0__31_ dfcrq2 $PINS D=n638 CP=ZCTSNET_6 CDN=HFSNET_181
+ Q=c_dst[415] VDD=VDD VSS=VSS
Xc_dst_reg_3__0__30_ dfcrq2 $PINS D=n637 CP=ZCTSNET_4 CDN=HFSNET_201
+ Q=c_dst[414] VDD=VDD VSS=VSS
Xc_dst_reg_3__0__29_ dfcrq2 $PINS D=n636 CP=ZCTSNET_19 CDN=HFSNET_174
+ Q=c_dst[413] VDD=VDD VSS=VSS
Xc_dst_reg_3__0__28_ dfcrq2 $PINS D=n635 CP=ZCTSNET_9 CDN=HFSNET_193
+ Q=c_dst[412] VDD=VDD VSS=VSS
Xc_dst_reg_3__0__27_ dfcrq2 $PINS D=n634 CP=ZCTSNET_216 CDN=HFSNET_198
+ Q=c_dst[411] VDD=VDD VSS=VSS
Xc_dst_reg_3__0__26_ dfcrq2 $PINS D=n633 CP=ZCTSNET_216 CDN=HFSNET_198
+ Q=c_dst[410] VDD=VDD VSS=VSS
Xc_dst_reg_3__0__25_ dfcrq2 $PINS D=n632 CP=ZCTSNET_6 CDN=HFSNET_173
+ Q=c_dst[409] VDD=VDD VSS=VSS
Xc_dst_reg_3__0__24_ dfcrq2 $PINS D=n631 CP=ZCTSNET_18 CDN=HFSNET_195
+ Q=c_dst[408] VDD=VDD VSS=VSS
Xc_dst_reg_3__0__23_ dfcrq2 $PINS D=n630 CP=ZCTSNET_207 CDN=HFSNET_175
+ Q=c_dst[407] VDD=VDD VSS=VSS
Xc_dst_reg_3__0__22_ dfcrq2 $PINS D=n629 CP=ZCTSNET_19 CDN=HFSNET_190
+ Q=c_dst[406] VDD=VDD VSS=VSS
Xc_dst_reg_3__0__21_ dfcrq2 $PINS D=n628 CP=ZCTSNET_18 CDN=HFSNET_197
+ Q=c_dst[405] VDD=VDD VSS=VSS
Xc_dst_reg_3__0__20_ dfcrq2 $PINS D=n627 CP=ZCTSNET_202 CDN=HFSNET_174
+ Q=c_dst[404] VDD=VDD VSS=VSS
Xc_dst_reg_3__0__19_ dfcrq2 $PINS D=n626 CP=ZCTSNET_17 CDN=HFSNET_195
+ Q=c_dst[403] VDD=VDD VSS=VSS
Xc_dst_reg_3__0__18_ dfcrq2 $PINS D=n625 CP=ZCTSNET_9 CDN=HFSNET_193
+ Q=c_dst[402] VDD=VDD VSS=VSS
Xc_dst_reg_3__0__17_ dfcrq2 $PINS D=n624 CP=ZCTSNET_207 CDN=HFSNET_189
+ Q=c_dst[401] VDD=VDD VSS=VSS
Xc_dst_reg_3__0__16_ dfcrq2 $PINS D=n623 CP=ZCTSNET_19 CDN=HFSNET_195
+ Q=c_dst[400] VDD=VDD VSS=VSS
Xc_dst_reg_3__0__15_ dfcrq2 $PINS D=n622 CP=ZCTSNET_9 CDN=HFSNET_187
+ Q=c_dst[399] VDD=VDD VSS=VSS
Xc_dst_reg_3__0__14_ dfcrq2 $PINS D=n621 CP=ZCTSNET_207 CDN=HFSNET_189
+ Q=c_dst[398] VDD=VDD VSS=VSS
Xc_dst_reg_3__0__13_ dfcrq2 $PINS D=n620 CP=ZCTSNET_4 CDN=HFSNET_201
+ Q=c_dst[397] VDD=VDD VSS=VSS
Xc_dst_reg_3__0__12_ dfcrq2 $PINS D=n619 CP=ZCTSNET_9 CDN=HFSNET_187
+ Q=c_dst[396] VDD=VDD VSS=VSS
Xc_dst_reg_3__0__11_ dfcrq2 $PINS D=n618 CP=ZCTSNET_207 CDN=HFSNET_189
+ Q=c_dst[395] VDD=VDD VSS=VSS
Xc_dst_reg_3__0__10_ dfcrq2 $PINS D=n617 CP=ZCTSNET_221 CDN=rst_n Q=c_dst[394]
+ VDD=VDD VSS=VSS
Xc_dst_reg_3__0__9_ dfcrq2 $PINS D=n616 CP=ZCTSNET_9 CDN=HFSNET_187
+ Q=c_dst[393] VDD=VDD VSS=VSS
Xc_dst_reg_3__0__8_ dfcrq2 $PINS D=n615 CP=ZCTSNET_221 CDN=rst_n Q=c_dst[392]
+ VDD=VDD VSS=VSS
Xc_dst_reg_3__0__7_ dfcrq2 $PINS D=n614 CP=ZCTSNET_221 CDN=HFSNET_172
+ Q=c_dst[391] VDD=VDD VSS=VSS
Xc_dst_reg_3__0__6_ dfcrq2 $PINS D=n613 CP=ZCTSNET_221 CDN=HFSNET_179
+ Q=c_dst[390] VDD=VDD VSS=VSS
Xc_dst_reg_3__0__5_ dfcrq2 $PINS D=n612 CP=ZCTSNET_207 CDN=HFSNET_179
+ Q=c_dst[389] VDD=VDD VSS=VSS
Xc_dst_reg_3__0__4_ dfcrq2 $PINS D=n611 CP=ZCTSNET_17 CDN=HFSNET_188
+ Q=c_dst[388] VDD=VDD VSS=VSS
Xc_dst_reg_3__0__3_ dfcrq2 $PINS D=n610 CP=ZCTSNET_19 CDN=HFSNET_190
+ Q=c_dst[387] VDD=VDD VSS=VSS
Xc_dst_reg_3__0__2_ dfcrq2 $PINS D=n609 CP=ZCTSNET_17 CDN=HFSNET_195
+ Q=c_dst[386] VDD=VDD VSS=VSS
Xc_dst_reg_3__0__1_ dfcrq2 $PINS D=n608 CP=ZCTSNET_19 CDN=HFSNET_195
+ Q=c_dst[385] VDD=VDD VSS=VSS
Xc_dst_reg_3__0__0_ dfcrq2 $PINS D=n607 CP=ZCTSNET_207 CDN=HFSNET_175
+ Q=c_dst[384] VDD=VDD VSS=VSS
Xc_dst_reg_1__2__31_ dfcrq2 $PINS D=n446 CP=ZCTSNET_221 CDN=HFSNET_172
+ Q=c_dst[223] VDD=VDD VSS=VSS
Xc_dst_reg_1__2__30_ dfcrq2 $PINS D=n445 CP=ZCTSNET_4 CDN=HFSNET_172
+ Q=c_dst[222] VDD=VDD VSS=VSS
Xc_dst_reg_1__2__29_ dfcrq2 $PINS D=copt_net_2748 CP=ZCTSNET_221 CDN=HFSNET_179
+ Q=c_dst[221] VDD=VDD VSS=VSS
Xc_dst_reg_1__2__28_ dfcrq2 $PINS D=copt_net_2749 CP=ZCTSNET_221 CDN=HFSNET_179
+ Q=c_dst[220] VDD=VDD VSS=VSS
Xc_dst_reg_1__2__27_ dfcrq2 $PINS D=n442 CP=ZCTSNET_6 CDN=HFSNET_181
+ Q=c_dst[219] VDD=VDD VSS=VSS
Xc_dst_reg_1__2__26_ dfcrq2 $PINS D=n441 CP=ZCTSNET_221 CDN=HFSNET_173
+ Q=c_dst[218] VDD=VDD VSS=VSS
Xc_dst_reg_1__2__25_ dfcrq2 $PINS D=n440 CP=ZCTSNET_6 CDN=HFSNET_181
+ Q=c_dst[217] VDD=VDD VSS=VSS
Xc_dst_reg_1__2__24_ dfcrq2 $PINS D=n439 CP=ZCTSNET_217 CDN=HFSNET_173
+ Q=c_dst[216] VDD=VDD VSS=VSS
Xc_dst_reg_1__2__23_ dfcrq2 $PINS D=n438 CP=ZCTSNET_207 CDN=HFSNET_189
+ Q=c_dst[215] VDD=VDD VSS=VSS
Xc_dst_reg_1__2__22_ dfcrq2 $PINS D=n437 CP=ZCTSNET_216 CDN=HFSNET_194
+ Q=c_dst[214] VDD=VDD VSS=VSS
Xc_dst_reg_1__2__21_ dfcrq2 $PINS D=n436 CP=ZCTSNET_6 CDN=HFSNET_182
+ Q=c_dst[213] VDD=VDD VSS=VSS
Xc_dst_reg_1__2__20_ dfcrq2 $PINS D=n435 CP=ZCTSNET_217 CDN=HFSNET_179
+ Q=c_dst[212] VDD=VDD VSS=VSS
Xc_dst_reg_1__2__19_ dfcrq2 $PINS D=n434 CP=ZCTSNET_221 CDN=HFSNET_173
+ Q=c_dst[211] VDD=VDD VSS=VSS
Xc_dst_reg_1__2__18_ dfcrq2 $PINS D=n433 CP=ZCTSNET_6 CDN=HFSNET_200
+ Q=c_dst[210] VDD=VDD VSS=VSS
Xc_dst_reg_1__2__17_ dfcrq2 $PINS D=n432 CP=ZCTSNET_10 CDN=HFSNET_182
+ Q=c_dst[209] VDD=VDD VSS=VSS
Xc_dst_reg_1__2__16_ dfcrq2 $PINS D=n431 CP=ZCTSNET_6 CDN=HFSNET_181
+ Q=c_dst[208] VDD=VDD VSS=VSS
Xc_dst_reg_1__2__15_ dfcrq2 $PINS D=n430 CP=ZCTSNET_216 CDN=HFSNET_182
+ Q=c_dst[207] VDD=VDD VSS=VSS
Xc_dst_reg_1__2__14_ dfcrq2 $PINS D=n429 CP=ZCTSNET_216 CDN=HFSNET_198
+ Q=c_dst[206] VDD=VDD VSS=VSS
Xc_dst_reg_1__2__13_ dfcrq2 $PINS D=n428 CP=ZCTSNET_9 CDN=HFSNET_193
+ Q=c_dst[205] VDD=VDD VSS=VSS
Xc_dst_reg_1__2__12_ dfcrq2 $PINS D=n427 CP=ZCTSNET_216 CDN=HFSNET_189
+ Q=c_dst[204] VDD=VDD VSS=VSS
Xc_dst_reg_1__2__11_ dfcrq2 $PINS D=n426 CP=ZCTSNET_6 CDN=HFSNET_187
+ Q=c_dst[203] VDD=VDD VSS=VSS
Xc_dst_reg_1__2__10_ dfcrq2 $PINS D=n425 CP=ZCTSNET_204 CDN=HFSNET_197
+ Q=c_dst[202] VDD=VDD VSS=VSS
Xc_dst_reg_1__2__9_ dfcrq2 $PINS D=n424 CP=ZCTSNET_9 CDN=HFSNET_193
+ Q=c_dst[201] VDD=VDD VSS=VSS
Xc_dst_reg_1__2__8_ dfcrq2 $PINS D=n423 CP=ZCTSNET_9 CDN=HFSNET_187
+ Q=c_dst[200] VDD=VDD VSS=VSS
Xc_dst_reg_1__2__7_ dfcrq2 $PINS D=n422 CP=ZCTSNET_18 CDN=HFSNET_195
+ Q=c_dst[199] VDD=VDD VSS=VSS
Xc_dst_reg_1__2__6_ dfcrq2 $PINS D=n421 CP=ZCTSNET_216 CDN=HFSNET_189
+ Q=c_dst[198] VDD=VDD VSS=VSS
Xc_dst_reg_1__2__5_ dfcrq2 $PINS D=n420 CP=ZCTSNET_10 CDN=HFSNET_182
+ Q=c_dst[197] VDD=VDD VSS=VSS
Xc_dst_reg_1__2__4_ dfcrq2 $PINS D=n419 CP=ZCTSNET_216 CDN=HFSNET_197
+ Q=c_dst[196] VDD=VDD VSS=VSS
Xc_dst_reg_1__2__3_ dfcrq2 $PINS D=n418 CP=ZCTSNET_202 CDN=HFSNET_188
+ Q=c_dst[195] VDD=VDD VSS=VSS
Xc_dst_reg_1__2__2_ dfcrq2 $PINS D=n417 CP=ZCTSNET_204 CDN=HFSNET_191
+ Q=c_dst[194] VDD=VDD VSS=VSS
Xc_dst_reg_1__2__1_ dfcrq2 $PINS D=n416 CP=ZCTSNET_216 CDN=HFSNET_189
+ Q=c_dst[193] VDD=VDD VSS=VSS
Xc_dst_reg_1__2__0_ dfcrq2 $PINS D=n415 CP=ZCTSNET_216 CDN=HFSNET_197
+ Q=c_dst[192] VDD=VDD VSS=VSS
Xc_dst_reg_2__1__31_ dfcrq2 $PINS D=n542 CP=ZCTSNET_207 CDN=HFSNET_192
+ Q=c_dst[319] VDD=VDD VSS=VSS
Xc_dst_reg_2__1__30_ dfcrq2 $PINS D=n541 CP=ZCTSNET_19 CDN=HFSNET_190
+ Q=c_dst[318] VDD=VDD VSS=VSS
Xc_dst_reg_2__1__29_ dfcrq2 $PINS D=n540 CP=ZCTSNET_202 CDN=HFSNET_188
+ Q=c_dst[317] VDD=VDD VSS=VSS
Xc_dst_reg_2__1__28_ dfcrq2 $PINS D=n539 CP=ZCTSNET_202 CDN=HFSNET_174
+ Q=c_dst[316] VDD=VDD VSS=VSS
Xc_dst_reg_2__1__27_ dfcrq2 $PINS D=n538 CP=ZCTSNET_19 CDN=HFSNET_192
+ Q=c_dst[315] VDD=VDD VSS=VSS
Xc_dst_reg_2__1__26_ dfcrq2 $PINS D=n537 CP=ZCTSNET_202 CDN=HFSNET_188
+ Q=c_dst[314] VDD=VDD VSS=VSS
Xc_dst_reg_2__1__25_ dfcrq2 $PINS D=n536 CP=ZCTSNET_19 CDN=HFSNET_190
+ Q=c_dst[313] VDD=VDD VSS=VSS
Xc_dst_reg_2__1__24_ dfcrq2 $PINS D=n535 CP=ZCTSNET_204 CDN=HFSNET_197
+ Q=c_dst[312] VDD=VDD VSS=VSS
Xc_dst_reg_2__1__23_ dfcrq2 $PINS D=n534 CP=ZCTSNET_207 CDN=HFSNET_175
+ Q=c_dst[311] VDD=VDD VSS=VSS
Xc_dst_reg_2__1__22_ dfcrq2 $PINS D=n533 CP=ZCTSNET_18 CDN=HFSNET_195
+ Q=c_dst[310] VDD=VDD VSS=VSS
Xc_dst_reg_2__1__21_ dfcrq2 $PINS D=n532 CP=ZCTSNET_216 CDN=HFSNET_189
+ Q=c_dst[309] VDD=VDD VSS=VSS
Xc_dst_reg_2__1__20_ dfcrq2 $PINS D=n531 CP=ZCTSNET_216 CDN=HFSNET_189
+ Q=c_dst[308] VDD=VDD VSS=VSS
Xc_dst_reg_2__1__19_ dfcrq2 $PINS D=n530 CP=ZCTSNET_207 CDN=HFSNET_175
+ Q=c_dst[307] VDD=VDD VSS=VSS
Xc_dst_reg_2__1__18_ dfcrq2 $PINS D=n529 CP=ZCTSNET_207 CDN=HFSNET_175
+ Q=c_dst[306] VDD=VDD VSS=VSS
Xc_dst_reg_2__1__17_ dfcrq2 $PINS D=n528 CP=ZCTSNET_207 CDN=HFSNET_189
+ Q=c_dst[305] VDD=VDD VSS=VSS
Xc_dst_reg_2__1__16_ dfcrq2 $PINS D=n527 CP=ZCTSNET_216 CDN=HFSNET_193
+ Q=c_dst[304] VDD=VDD VSS=VSS
Xc_dst_reg_2__1__15_ dfcrq2 $PINS D=n526 CP=ZCTSNET_6 CDN=HFSNET_182
+ Q=c_dst[303] VDD=VDD VSS=VSS
Xc_dst_reg_2__1__14_ dfcrq2 $PINS D=n525 CP=ZCTSNET_216 CDN=HFSNET_193
+ Q=c_dst[302] VDD=VDD VSS=VSS
Xc_dst_reg_2__1__13_ dfcrq2 $PINS D=n524 CP=ZCTSNET_6 CDN=HFSNET_182
+ Q=c_dst[301] VDD=VDD VSS=VSS
Xc_dst_reg_2__1__12_ dfcrq2 $PINS D=n523 CP=ZCTSNET_221 CDN=HFSNET_173
+ Q=c_dst[300] VDD=VDD VSS=VSS
Xc_dst_reg_2__1__11_ dfcrq2 $PINS D=n522 CP=ZCTSNET_221 CDN=HFSNET_173
+ Q=c_dst[299] VDD=VDD VSS=VSS
Xc_dst_reg_2__1__10_ dfcrq2 $PINS D=n521 CP=ZCTSNET_207 CDN=HFSNET_189
+ Q=c_dst[298] VDD=VDD VSS=VSS
Xc_dst_reg_2__1__9_ dfcrq2 $PINS D=n520 CP=ZCTSNET_207 CDN=HFSNET_175
+ Q=c_dst[297] VDD=VDD VSS=VSS
Xc_dst_reg_2__1__8_ dfcrq2 $PINS D=n519 CP=ZCTSNET_207 CDN=HFSNET_175
+ Q=c_dst[296] VDD=VDD VSS=VSS
Xc_dst_reg_2__1__7_ dfcrq2 $PINS D=copt_net_2737 CP=ZCTSNET_216 CDN=HFSNET_198
+ Q=c_dst[295] VDD=VDD VSS=VSS
Xc_dst_reg_2__1__6_ dfcrq2 $PINS D=n517 CP=ZCTSNET_207 CDN=HFSNET_175
+ Q=c_dst[294] VDD=VDD VSS=VSS
Xc_dst_reg_2__1__5_ dfcrq2 $PINS D=n516 CP=ZCTSNET_207 CDN=HFSNET_175
+ Q=c_dst[293] VDD=VDD VSS=VSS
Xc_dst_reg_2__1__4_ dfcrq2 $PINS D=n515 CP=ZCTSNET_207 CDN=HFSNET_189
+ Q=c_dst[292] VDD=VDD VSS=VSS
Xc_dst_reg_2__1__3_ dfcrq2 $PINS D=n514 CP=ZCTSNET_207 CDN=HFSNET_175
+ Q=c_dst[291] VDD=VDD VSS=VSS
Xc_dst_reg_2__1__2_ dfcrq2 $PINS D=n513 CP=ZCTSNET_204 CDN=HFSNET_197
+ Q=c_dst[290] VDD=VDD VSS=VSS
Xc_dst_reg_2__1__1_ dfcrq2 $PINS D=n512 CP=ZCTSNET_207 CDN=HFSNET_175
+ Q=c_dst[289] VDD=VDD VSS=VSS
Xc_dst_reg_2__1__0_ dfcrq2 $PINS D=n511 CP=ZCTSNET_18 CDN=HFSNET_195
+ Q=c_dst[288] VDD=VDD VSS=VSS
Xc_dst_reg_0__3__31_ dfcrq2 $PINS D=n350 CP=ZCTSNET_6 CDN=HFSNET_193
+ Q=c_dst[127] VDD=VDD VSS=VSS
Xc_dst_reg_0__3__30_ dfcrq2 $PINS D=n349 CP=ZCTSNET_204 CDN=HFSNET_197
+ Q=c_dst[126] VDD=VDD VSS=VSS
Xc_dst_reg_0__3__29_ dfcrq2 $PINS D=n348 CP=ZCTSNET_216 CDN=HFSNET_193
+ Q=c_dst[125] VDD=VDD VSS=VSS
Xc_dst_reg_0__3__28_ dfcrq2 $PINS D=n347 CP=ZCTSNET_204 CDN=HFSNET_197
+ Q=c_dst[124] VDD=VDD VSS=VSS
Xc_dst_reg_0__3__27_ dfcrq2 $PINS D=n346 CP=ZCTSNET_216 CDN=HFSNET_193
+ Q=c_dst[123] VDD=VDD VSS=VSS
Xc_dst_reg_0__3__26_ dfcrq2 $PINS D=n345 CP=ZCTSNET_4 CDN=HFSNET_201
+ Q=c_dst[122] VDD=VDD VSS=VSS
Xc_dst_reg_0__3__25_ dfcrq2 $PINS D=n344 CP=ZCTSNET_206 CDN=HFSNET_201
+ Q=c_dst[121] VDD=VDD VSS=VSS
Xc_dst_reg_0__3__24_ dfcrq2 $PINS D=n343 CP=ZCTSNET_206 CDN=HFSNET_201
+ Q=c_dst[120] VDD=VDD VSS=VSS
Xc_dst_reg_0__3__23_ dfcrq2 $PINS D=n342 CP=ZCTSNET_4 CDN=HFSNET_172
+ Q=c_dst[119] VDD=VDD VSS=VSS
Xc_dst_reg_0__3__22_ dfcrq2 $PINS D=copt_net_476 CP=ZCTSNET_210 CDN=HFSNET_201
+ Q=c_dst[118] VDD=VDD VSS=VSS
Xc_dst_reg_0__3__21_ dfcrq2 $PINS D=n340 CP=ZCTSNET_4 CDN=HFSNET_201
+ Q=c_dst[117] VDD=VDD VSS=VSS
Xc_dst_reg_0__3__20_ dfcrq2 $PINS D=n339 CP=ZCTSNET_4 CDN=HFSNET_201
+ Q=c_dst[116] VDD=VDD VSS=VSS
Xc_dst_reg_0__3__19_ dfcrq2 $PINS D=n338 CP=ZCTSNET_210 CDN=HFSNET_201
+ Q=c_dst[115] VDD=VDD VSS=VSS
Xc_dst_reg_0__3__18_ dfcrq2 $PINS D=n337 CP=ZCTSNET_210 CDN=HFSNET_201
+ Q=c_dst[114] VDD=VDD VSS=VSS
Xc_dst_reg_0__3__17_ dfcrq2 $PINS D=n336 CP=ZCTSNET_1 CDN=HFSNET_172
+ Q=c_dst[113] VDD=VDD VSS=VSS
Xc_dst_reg_0__3__16_ dfcrq2 $PINS D=n335 CP=ZCTSNET_1 CDN=HFSNET_172
+ Q=c_dst[112] VDD=VDD VSS=VSS
Xc_dst_reg_0__3__15_ dfcrq2 $PINS D=n334 CP=ZCTSNET_210 CDN=HFSNET_172
+ Q=c_dst[111] VDD=VDD VSS=VSS
Xc_dst_reg_0__3__14_ dfcrq2 $PINS D=n333 CP=ZCTSNET_4 CDN=HFSNET_172
+ Q=c_dst[110] VDD=VDD VSS=VSS
Xc_dst_reg_0__3__13_ dfcrq2 $PINS D=n332 CP=ZCTSNET_206 CDN=HFSNET_201
+ Q=c_dst[109] VDD=VDD VSS=VSS
Xc_dst_reg_0__3__12_ dfcrq2 $PINS D=n331 CP=ZCTSNET_4 CDN=HFSNET_172
+ Q=c_dst[108] VDD=VDD VSS=VSS
Xc_dst_reg_0__3__11_ dfcrq2 $PINS D=n330 CP=ZCTSNET_210 CDN=HFSNET_201
+ Q=c_dst[107] VDD=VDD VSS=VSS
Xc_dst_reg_0__3__10_ dfcrq2 $PINS D=ropt_net_3205 CP=ZCTSNET_1 CDN=HFSNET_172
+ Q=c_dst[106] VDD=VDD VSS=VSS
Xc_dst_reg_0__3__9_ dfcrq2 $PINS D=n328 CP=ZCTSNET_1 CDN=rst_n Q=c_dst[105]
+ VDD=VDD VSS=VSS
Xc_dst_reg_0__3__8_ dfcrq2 $PINS D=n327 CP=ZCTSNET_210 CDN=HFSNET_172
+ Q=c_dst[104] VDD=VDD VSS=VSS
Xc_dst_reg_0__3__7_ dfcrq2 $PINS D=copt_net_2761 CP=ZCTSNET_1 CDN=HFSNET_172
+ Q=c_dst[103] VDD=VDD VSS=VSS
Xc_dst_reg_0__3__6_ dfcrq2 $PINS D=n325 CP=ZCTSNET_1 CDN=HFSNET_172
+ Q=c_dst[102] VDD=VDD VSS=VSS
Xc_dst_reg_0__3__5_ dfcrq2 $PINS D=n324 CP=ZCTSNET_1 CDN=rst_n Q=c_dst[101]
+ VDD=VDD VSS=VSS
Xc_dst_reg_0__3__4_ dfcrq2 $PINS D=n323 CP=ZCTSNET_210 CDN=rst_n Q=c_dst[100]
+ VDD=VDD VSS=VSS
Xc_dst_reg_0__3__3_ dfcrq2 $PINS D=n322 CP=ZCTSNET_1 CDN=HFSNET_172 Q=c_dst[99]
+ VDD=VDD VSS=VSS
Xc_dst_reg_0__3__2_ dfcrq2 $PINS D=n321 CP=ZCTSNET_1 CDN=HFSNET_172 Q=c_dst[98]
+ VDD=VDD VSS=VSS
Xc_dst_reg_0__3__1_ dfcrq2 $PINS D=n320 CP=ZCTSNET_1 CDN=HFSNET_172 Q=c_dst[97]
+ VDD=VDD VSS=VSS
Xc_dst_reg_0__3__0_ dfcrq2 $PINS D=copt_net_2754 CP=ZCTSNET_221 CDN=HFSNET_172
+ Q=c_dst[96] VDD=VDD VSS=VSS
Xc_dst_reg_1__0__31_ dfcrq2 $PINS D=copt_net_2739 CP=ZCTSNET_8 CDN=HFSNET_176
+ Q=c_dst[159] VDD=VDD VSS=VSS
Xc_dst_reg_1__0__30_ dfcrq2 $PINS D=n381 CP=ZCTSNET_19 CDN=HFSNET_192
+ Q=c_dst[158] VDD=VDD VSS=VSS
Xc_dst_reg_1__0__29_ dfcrq2 $PINS D=n380 CP=ZCTSNET_19 CDN=HFSNET_192
+ Q=c_dst[157] VDD=VDD VSS=VSS
Xc_dst_reg_1__0__28_ dfcrq2 $PINS D=n379 CP=ZCTSNET_19 CDN=HFSNET_192
+ Q=c_dst[156] VDD=VDD VSS=VSS
Xc_dst_reg_1__0__27_ dfcrq2 $PINS D=n378 CP=ZCTSNET_19 CDN=HFSNET_192
+ Q=c_dst[155] VDD=VDD VSS=VSS
Xc_dst_reg_1__0__26_ dfcrq2 $PINS D=n377 CP=ZCTSNET_19 CDN=HFSNET_192
+ Q=c_dst[154] VDD=VDD VSS=VSS
Xc_dst_reg_1__0__25_ dfcrq2 $PINS D=n376 CP=ZCTSNET_19 CDN=HFSNET_192
+ Q=c_dst[153] VDD=VDD VSS=VSS
Xc_dst_reg_1__0__24_ dfcrq2 $PINS D=n375 CP=ZCTSNET_19 CDN=HFSNET_192
+ Q=c_dst[152] VDD=VDD VSS=VSS
Xc_dst_reg_1__0__23_ dfcrq2 $PINS D=n374 CP=ZCTSNET_19 CDN=HFSNET_192
+ Q=c_dst[151] VDD=VDD VSS=VSS
Xc_dst_reg_1__0__22_ dfcrq2 $PINS D=n373 CP=ZCTSNET_19 CDN=HFSNET_192
+ Q=c_dst[150] VDD=VDD VSS=VSS
Xc_dst_reg_1__0__21_ dfcrq2 $PINS D=n372 CP=ZCTSNET_18 CDN=HFSNET_188
+ Q=c_dst[149] VDD=VDD VSS=VSS
Xc_dst_reg_1__0__20_ dfcrq2 $PINS D=n371 CP=ZCTSNET_202 CDN=HFSNET_188
+ Q=c_dst[148] VDD=VDD VSS=VSS
Xc_dst_reg_1__0__19_ dfcrq2 $PINS D=n370 CP=ZCTSNET_202 CDN=HFSNET_188
+ Q=c_dst[147] VDD=VDD VSS=VSS
Xc_dst_reg_1__0__18_ dfcrq2 $PINS D=n369 CP=ZCTSNET_202 CDN=HFSNET_188
+ Q=c_dst[146] VDD=VDD VSS=VSS
Xc_dst_reg_1__0__17_ dfcrq2 $PINS D=n368 CP=ZCTSNET_202 CDN=HFSNET_190
+ Q=c_dst[145] VDD=VDD VSS=VSS
Xc_dst_reg_1__0__16_ dfcrq2 $PINS D=n367 CP=ZCTSNET_19 CDN=HFSNET_190
+ Q=c_dst[144] VDD=VDD VSS=VSS
Xc_dst_reg_1__0__15_ dfcrq2 $PINS D=n366 CP=ZCTSNET_202 CDN=HFSNET_190
+ Q=c_dst[143] VDD=VDD VSS=VSS
Xc_dst_reg_1__0__14_ dfcrq2 $PINS D=n365 CP=ZCTSNET_202 CDN=HFSNET_188
+ Q=c_dst[142] VDD=VDD VSS=VSS
Xc_dst_reg_1__0__13_ dfcrq2 $PINS D=n364 CP=ZCTSNET_202 CDN=HFSNET_188
+ Q=c_dst[141] VDD=VDD VSS=VSS
Xc_dst_reg_1__0__12_ dfcrq2 $PINS D=n363 CP=ZCTSNET_202 CDN=HFSNET_174
+ Q=c_dst[140] VDD=VDD VSS=VSS
Xc_dst_reg_1__0__11_ dfcrq2 $PINS D=n362 CP=ZCTSNET_202 CDN=HFSNET_174
+ Q=c_dst[139] VDD=VDD VSS=VSS
Xc_dst_reg_1__0__10_ dfcrq2 $PINS D=n361 CP=ZCTSNET_202 CDN=HFSNET_174
+ Q=c_dst[138] VDD=VDD VSS=VSS
Xc_dst_reg_1__0__9_ dfcrq2 $PINS D=n360 CP=ZCTSNET_202 CDN=HFSNET_174
+ Q=c_dst[137] VDD=VDD VSS=VSS
Xc_dst_reg_1__0__8_ dfcrq2 $PINS D=n359 CP=ZCTSNET_202 CDN=HFSNET_174
+ Q=c_dst[136] VDD=VDD VSS=VSS
Xc_dst_reg_1__0__7_ dfcrq2 $PINS D=n358 CP=ZCTSNET_19 CDN=HFSNET_190
+ Q=c_dst[135] VDD=VDD VSS=VSS
Xc_dst_reg_1__0__6_ dfcrq2 $PINS D=n357 CP=ZCTSNET_202 CDN=HFSNET_174
+ Q=c_dst[134] VDD=VDD VSS=VSS
Xc_dst_reg_1__0__5_ dfcrq2 $PINS D=n356 CP=ZCTSNET_19 CDN=HFSNET_190
+ Q=c_dst[133] VDD=VDD VSS=VSS
Xc_dst_reg_1__0__4_ dfcrq2 $PINS D=n355 CP=ZCTSNET_19 CDN=HFSNET_190
+ Q=c_dst[132] VDD=VDD VSS=VSS
Xc_dst_reg_1__0__3_ dfcrq2 $PINS D=n354 CP=ZCTSNET_17 CDN=HFSNET_195
+ Q=c_dst[131] VDD=VDD VSS=VSS
Xc_dst_reg_1__0__2_ dfcrq2 $PINS D=n353 CP=ZCTSNET_17 CDN=HFSNET_195
+ Q=c_dst[130] VDD=VDD VSS=VSS
Xc_dst_reg_1__0__1_ dfcrq2 $PINS D=n352 CP=ZCTSNET_18 CDN=HFSNET_195
+ Q=c_dst[129] VDD=VDD VSS=VSS
Xc_dst_reg_1__0__0_ dfcrq2 $PINS D=n351 CP=ZCTSNET_18 CDN=HFSNET_195
+ Q=c_dst[128] VDD=VDD VSS=VSS
Xc_dst_reg_0__1__31_ dfcrq2 $PINS D=n286 CP=ZCTSNET_18 CDN=HFSNET_195
+ Q=c_dst[63] VDD=VDD VSS=VSS
Xc_dst_reg_0__1__30_ dfcrq2 $PINS D=n285 CP=ZCTSNET_204 CDN=HFSNET_197
+ Q=c_dst[62] VDD=VDD VSS=VSS
Xc_dst_reg_0__1__29_ dfcrq2 $PINS D=n284 CP=ZCTSNET_216 CDN=HFSNET_197
+ Q=c_dst[61] VDD=VDD VSS=VSS
Xc_dst_reg_0__1__28_ dfcrq2 $PINS D=n283 CP=ZCTSNET_18 CDN=HFSNET_195
+ Q=c_dst[60] VDD=VDD VSS=VSS
Xc_dst_reg_0__1__27_ dfcrq2 $PINS D=n282 CP=ZCTSNET_18 CDN=HFSNET_195
+ Q=c_dst[59] VDD=VDD VSS=VSS
Xc_dst_reg_0__1__26_ dfcrq2 $PINS D=n281 CP=ZCTSNET_17 CDN=HFSNET_195
+ Q=c_dst[58] VDD=VDD VSS=VSS
Xc_dst_reg_0__1__25_ dfcrq2 $PINS D=n280 CP=ZCTSNET_17 CDN=HFSNET_195
+ Q=c_dst[57] VDD=VDD VSS=VSS
Xc_dst_reg_0__1__24_ dfcrq2 $PINS D=n279 CP=ZCTSNET_18 CDN=HFSNET_195
+ Q=c_dst[56] VDD=VDD VSS=VSS
Xc_dst_reg_0__1__23_ dfcrq2 $PINS D=n278 CP=ZCTSNET_17 CDN=HFSNET_195
+ Q=c_dst[55] VDD=VDD VSS=VSS
Xc_dst_reg_0__1__22_ dfcrq2 $PINS D=n277 CP=ZCTSNET_19 CDN=HFSNET_195
+ Q=c_dst[54] VDD=VDD VSS=VSS
Xc_dst_reg_0__1__21_ dfcrq2 $PINS D=n276 CP=ZCTSNET_19 CDN=HFSNET_195
+ Q=c_dst[53] VDD=VDD VSS=VSS
Xc_dst_reg_0__1__20_ dfcrq2 $PINS D=n275 CP=ZCTSNET_19 CDN=HFSNET_195
+ Q=c_dst[52] VDD=VDD VSS=VSS
Xc_dst_reg_0__1__19_ dfcrq2 $PINS D=n274 CP=ZCTSNET_19 CDN=HFSNET_195
+ Q=c_dst[51] VDD=VDD VSS=VSS
Xc_dst_reg_0__1__18_ dfcrq2 $PINS D=n273 CP=ZCTSNET_207 CDN=HFSNET_177
+ Q=c_dst[50] VDD=VDD VSS=VSS
Xc_dst_reg_0__1__17_ dfcrq2 $PINS D=n272 CP=ZCTSNET_8 CDN=HFSNET_177
+ Q=c_dst[49] VDD=VDD VSS=VSS
Xc_dst_reg_0__1__16_ dfcrq2 $PINS D=n271 CP=ZCTSNET_207 CDN=HFSNET_177
+ Q=c_dst[48] VDD=VDD VSS=VSS
Xc_dst_reg_0__1__15_ dfcrq2 $PINS D=n270 CP=ZCTSNET_8 CDN=HFSNET_177
+ Q=c_dst[47] VDD=VDD VSS=VSS
Xc_dst_reg_0__1__14_ dfcrq2 $PINS D=n269 CP=ZCTSNET_207 CDN=HFSNET_177
+ Q=c_dst[46] VDD=VDD VSS=VSS
Xc_dst_reg_0__1__13_ dfcrq2 $PINS D=n268 CP=ZCTSNET_207 CDN=HFSNET_177
+ Q=c_dst[45] VDD=VDD VSS=VSS
Xc_dst_reg_0__1__12_ dfcrq2 $PINS D=n267 CP=ZCTSNET_207 CDN=HFSNET_177
+ Q=c_dst[44] VDD=VDD VSS=VSS
Xc_dst_reg_0__1__11_ dfcrq2 $PINS D=n266 CP=ZCTSNET_207 CDN=HFSNET_177
+ Q=c_dst[43] VDD=VDD VSS=VSS
Xc_dst_reg_0__1__10_ dfcrq2 $PINS D=n265 CP=ZCTSNET_221 CDN=HFSNET_179
+ Q=c_dst[42] VDD=VDD VSS=VSS
Xc_dst_reg_0__1__9_ dfcrq2 $PINS D=n264 CP=ZCTSNET_8 CDN=HFSNET_177 Q=c_dst[41]
+ VDD=VDD VSS=VSS
Xc_dst_reg_0__1__8_ dfcrq2 $PINS D=copt_net_587 CP=ZCTSNET_8 CDN=HFSNET_177
+ Q=c_dst[40] VDD=VDD VSS=VSS
Xc_dst_reg_0__1__7_ dfcrq2 $PINS D=copt_net_287 CP=ZCTSNET_8 CDN=HFSNET_177
+ Q=c_dst[39] VDD=VDD VSS=VSS
Xc_dst_reg_0__1__6_ dfcrq2 $PINS D=n261 CP=ZCTSNET_8 CDN=HFSNET_177 Q=c_dst[38]
+ VDD=VDD VSS=VSS
Xc_dst_reg_0__1__5_ dfcrq2 $PINS D=n260 CP=ZCTSNET_207 CDN=HFSNET_177
+ Q=c_dst[37] VDD=VDD VSS=VSS
Xc_dst_reg_0__1__4_ dfcrq2 $PINS D=n259 CP=ZCTSNET_8 CDN=HFSNET_176 Q=c_dst[36]
+ VDD=VDD VSS=VSS
Xc_dst_reg_0__1__3_ dfcrq2 $PINS D=copt_net_2782 CP=ZCTSNET_8 CDN=HFSNET_177
+ Q=c_dst[35] VDD=VDD VSS=VSS
Xc_dst_reg_0__1__2_ dfcrq2 $PINS D=n257 CP=ZCTSNET_8 CDN=HFSNET_177 Q=c_dst[34]
+ VDD=VDD VSS=VSS
Xc_dst_reg_0__1__1_ dfcrq2 $PINS D=n256 CP=ZCTSNET_8 CDN=HFSNET_177 Q=c_dst[33]
+ VDD=VDD VSS=VSS
Xc_dst_reg_0__1__0_ dfcrq2 $PINS D=n255 CP=ZCTSNET_19 CDN=HFSNET_192
+ Q=c_dst[32] VDD=VDD VSS=VSS
Xc_dst_reg_3__3__31_ dfcrq2 $PINS D=n734 CP=ZCTSNET_6 CDN=HFSNET_187
+ Q=c_dst[511] VDD=VDD VSS=VSS
Xc_dst_reg_3__3__30_ dfcrq2 $PINS D=n733 CP=ZCTSNET_6 CDN=HFSNET_187
+ Q=c_dst[510] VDD=VDD VSS=VSS
Xc_dst_reg_3__3__29_ dfcrq2 $PINS D=n732 CP=ZCTSNET_11 CDN=HFSNET_181
+ Q=c_dst[509] VDD=VDD VSS=VSS
Xc_dst_reg_3__3__28_ dfcrq2 $PINS D=n731 CP=ZCTSNET_212 CDN=HFSNET_181
+ Q=c_dst[508] VDD=VDD VSS=VSS
Xc_dst_reg_3__3__27_ dfcrq2 $PINS D=n730 CP=ZCTSNET_11 CDN=HFSNET_181
+ Q=c_dst[507] VDD=VDD VSS=VSS
Xc_dst_reg_3__3__26_ dfcrq2 $PINS D=n729 CP=ZCTSNET_217 CDN=HFSNET_199
+ Q=c_dst[506] VDD=VDD VSS=VSS
Xc_dst_reg_3__3__25_ dfcrq2 $PINS D=n728 CP=ZCTSNET_6 CDN=HFSNET_181
+ Q=c_dst[505] VDD=VDD VSS=VSS
Xc_dst_reg_3__3__24_ dfcrq2 $PINS D=n727 CP=ZCTSNET_6 CDN=HFSNET_181
+ Q=c_dst[504] VDD=VDD VSS=VSS
Xc_dst_reg_3__3__23_ dfcrq2 $PINS D=n726 CP=ZCTSNET_217 CDN=HFSNET_199
+ Q=c_dst[503] VDD=VDD VSS=VSS
Xc_dst_reg_3__3__22_ dfcrq2 $PINS D=n725 CP=ZCTSNET_217 CDN=HFSNET_199
+ Q=c_dst[502] VDD=VDD VSS=VSS
Xc_dst_reg_3__3__21_ dfcrq2 $PINS D=n724 CP=ZCTSNET_6 CDN=HFSNET_199
+ Q=c_dst[501] VDD=VDD VSS=VSS
Xc_dst_reg_3__3__20_ dfcrq2 $PINS D=n723 CP=ZCTSNET_208 CDN=HFSNET_200
+ Q=c_dst[500] VDD=VDD VSS=VSS
Xc_dst_reg_3__3__19_ dfcrq2 $PINS D=n722 CP=ZCTSNET_4 CDN=HFSNET_200
+ Q=c_dst[499] VDD=VDD VSS=VSS
Xc_dst_reg_3__3__18_ dfcrq2 $PINS D=n721 CP=ZCTSNET_217 CDN=HFSNET_201
+ Q=c_dst[498] VDD=VDD VSS=VSS
Xc_dst_reg_3__3__17_ dfcrq2 $PINS D=copt_net_360 CP=ZCTSNET_4 CDN=HFSNET_201
+ Q=c_dst[497] VDD=VDD VSS=VSS
Xc_dst_reg_3__3__16_ dfcrq2 $PINS D=n719 CP=ZCTSNET_208 CDN=HFSNET_200
+ Q=c_dst[496] VDD=VDD VSS=VSS
Xc_dst_reg_3__3__15_ dfcrq2 $PINS D=n718 CP=ZCTSNET_4 CDN=HFSNET_200
+ Q=c_dst[495] VDD=VDD VSS=VSS
Xc_dst_reg_3__3__14_ dfcrq2 $PINS D=n717 CP=ZCTSNET_208 CDN=HFSNET_200
+ Q=c_dst[494] VDD=VDD VSS=VSS
Xc_dst_reg_3__3__13_ dfcrq2 $PINS D=n716 CP=ZCTSNET_208 CDN=HFSNET_200
+ Q=c_dst[493] VDD=VDD VSS=VSS
Xc_dst_reg_3__3__12_ dfcrq2 $PINS D=n715 CP=ZCTSNET_4 CDN=HFSNET_200
+ Q=c_dst[492] VDD=VDD VSS=VSS
Xc_dst_reg_3__3__11_ dfcrq2 $PINS D=n714 CP=ZCTSNET_211 CDN=HFSNET_200
+ Q=c_dst[491] VDD=VDD VSS=VSS
Xc_dst_reg_3__3__10_ dfcrq2 $PINS D=n713 CP=ZCTSNET_6 CDN=HFSNET_181
+ Q=c_dst[490] VDD=VDD VSS=VSS
Xc_dst_reg_3__3__9_ dfcrq2 $PINS D=n712 CP=ZCTSNET_11 CDN=HFSNET_181
+ Q=c_dst[489] VDD=VDD VSS=VSS
Xc_dst_reg_3__3__8_ dfcrq2 $PINS D=n711 CP=ZCTSNET_217 CDN=HFSNET_199
+ Q=c_dst[488] VDD=VDD VSS=VSS
Xc_dst_reg_3__3__7_ dfcrq2 $PINS D=n710 CP=ZCTSNET_6 CDN=HFSNET_199
+ Q=c_dst[487] VDD=VDD VSS=VSS
Xc_dst_reg_3__3__6_ dfcrq2 $PINS D=copt_net_2750 CP=ZCTSNET_208 CDN=HFSNET_200
+ Q=c_dst[486] VDD=VDD VSS=VSS
Xc_dst_reg_3__3__5_ dfcrq2 $PINS D=n708 CP=ZCTSNET_217 CDN=HFSNET_199
+ Q=c_dst[485] VDD=VDD VSS=VSS
Xc_dst_reg_3__3__4_ dfcrq2 $PINS D=n707 CP=ZCTSNET_217 CDN=HFSNET_200
+ Q=c_dst[484] VDD=VDD VSS=VSS
Xc_dst_reg_3__3__3_ dfcrq2 $PINS D=n706 CP=ZCTSNET_217 CDN=HFSNET_200
+ Q=c_dst[483] VDD=VDD VSS=VSS
Xc_dst_reg_3__3__2_ dfcrq2 $PINS D=n705 CP=ZCTSNET_212 CDN=HFSNET_181
+ Q=c_dst[482] VDD=VDD VSS=VSS
Xc_dst_reg_3__3__1_ dfcrq2 $PINS D=n704 CP=ZCTSNET_10 CDN=HFSNET_182
+ Q=c_dst[481] VDD=VDD VSS=VSS
Xc_dst_reg_3__3__0_ dfcrq2 $PINS D=n703 CP=ZCTSNET_10 CDN=HFSNET_182
+ Q=c_dst[480] VDD=VDD VSS=VSS
Xc_dst_reg_3__1__31_ dfcrq2 $PINS D=n670 CP=ZCTSNET_202 CDN=HFSNET_188
+ Q=c_dst[447] VDD=VDD VSS=VSS
Xc_dst_reg_3__1__30_ dfcrq2 $PINS D=n669 CP=ZCTSNET_216 CDN=HFSNET_189
+ Q=c_dst[446] VDD=VDD VSS=VSS
Xc_dst_reg_3__1__29_ dfcrq2 $PINS D=n668 CP=ZCTSNET_220 CDN=HFSNET_186
+ Q=c_dst[445] VDD=VDD VSS=VSS
Xc_dst_reg_3__1__28_ dfcrq2 $PINS D=n667 CP=ZCTSNET_220 CDN=HFSNET_186
+ Q=c_dst[444] VDD=VDD VSS=VSS
Xc_dst_reg_3__1__27_ dfcrq2 $PINS D=n666 CP=ZCTSNET_9 CDN=HFSNET_187
+ Q=c_dst[443] VDD=VDD VSS=VSS
Xc_dst_reg_3__1__26_ dfcrq2 $PINS D=n665 CP=ZCTSNET_9 CDN=HFSNET_187
+ Q=c_dst[442] VDD=VDD VSS=VSS
Xc_dst_reg_3__1__25_ dfcrq2 $PINS D=n664 CP=ZCTSNET_220 CDN=HFSNET_186
+ Q=c_dst[441] VDD=VDD VSS=VSS
Xc_dst_reg_3__1__24_ dfcrq2 $PINS D=copt_net_2891 CP=ZCTSNET_220 CDN=HFSNET_186
+ Q=c_dst[440] VDD=VDD VSS=VSS
Xc_dst_reg_3__1__23_ dfcrq2 $PINS D=n662 CP=ZCTSNET_220 CDN=HFSNET_197
+ Q=c_dst[439] VDD=VDD VSS=VSS
Xc_dst_reg_3__1__22_ dfcrq2 $PINS D=n661 CP=ZCTSNET_220 CDN=HFSNET_187
+ Q=c_dst[438] VDD=VDD VSS=VSS
Xc_dst_reg_3__1__21_ dfcrq2 $PINS D=n660 CP=ZCTSNET_207 CDN=HFSNET_189
+ Q=c_dst[437] VDD=VDD VSS=VSS
Xc_dst_reg_3__1__20_ dfcrq2 $PINS D=n659 CP=ZCTSNET_207 CDN=HFSNET_189
+ Q=c_dst[436] VDD=VDD VSS=VSS
Xc_dst_reg_3__1__19_ dfcrq2 $PINS D=copt_net_2740 CP=ZCTSNET_207 CDN=HFSNET_189
+ Q=c_dst[435] VDD=VDD VSS=VSS
Xc_dst_reg_3__1__18_ dfcrq2 $PINS D=n657 CP=ZCTSNET_207 CDN=HFSNET_189
+ Q=c_dst[434] VDD=VDD VSS=VSS
Xc_dst_reg_3__1__17_ dfcrq2 $PINS D=n656 CP=ZCTSNET_207 CDN=HFSNET_175
+ Q=c_dst[433] VDD=VDD VSS=VSS
Xc_dst_reg_3__1__16_ dfcrq2 $PINS D=n655 CP=ZCTSNET_216 CDN=HFSNET_189
+ Q=c_dst[432] VDD=VDD VSS=VSS
Xc_dst_reg_3__1__15_ dfcrq2 $PINS D=n654 CP=ZCTSNET_207 CDN=HFSNET_189
+ Q=c_dst[431] VDD=VDD VSS=VSS
Xc_dst_reg_3__1__14_ dfcrq2 $PINS D=n653 CP=ZCTSNET_216 CDN=HFSNET_189
+ Q=c_dst[430] VDD=VDD VSS=VSS
Xc_dst_reg_3__1__13_ dfcrq2 $PINS D=n652 CP=ZCTSNET_207 CDN=HFSNET_189
+ Q=c_dst[429] VDD=VDD VSS=VSS
Xc_dst_reg_3__1__12_ dfcrq2 $PINS D=n651 CP=ZCTSNET_216 CDN=HFSNET_198
+ Q=c_dst[428] VDD=VDD VSS=VSS
Xc_dst_reg_3__1__11_ dfcrq2 $PINS D=n650 CP=ZCTSNET_221 CDN=HFSNET_179
+ Q=c_dst[427] VDD=VDD VSS=VSS
Xc_dst_reg_3__1__10_ dfcrq2 $PINS D=n649 CP=ZCTSNET_19 CDN=HFSNET_192
+ Q=c_dst[426] VDD=VDD VSS=VSS
Xc_dst_reg_3__1__9_ dfcrq2 $PINS D=n648 CP=ZCTSNET_207 CDN=HFSNET_175
+ Q=c_dst[425] VDD=VDD VSS=VSS
Xc_dst_reg_3__1__8_ dfcrq2 $PINS D=n647 CP=ZCTSNET_207 CDN=HFSNET_189
+ Q=c_dst[424] VDD=VDD VSS=VSS
Xc_dst_reg_3__1__7_ dfcrq2 $PINS D=copt_net_2338 CP=ZCTSNET_221 CDN=HFSNET_173
+ Q=c_dst[423] VDD=VDD VSS=VSS
Xc_dst_reg_3__1__6_ dfcrq2 $PINS D=n645 CP=ZCTSNET_207 CDN=HFSNET_175
+ Q=c_dst[422] VDD=VDD VSS=VSS
Xc_dst_reg_3__1__5_ dfcrq2 $PINS D=n644 CP=ZCTSNET_207 CDN=HFSNET_175
+ Q=c_dst[421] VDD=VDD VSS=VSS
Xc_dst_reg_3__1__4_ dfcrq2 $PINS D=n643 CP=ZCTSNET_216 CDN=HFSNET_189
+ Q=c_dst[420] VDD=VDD VSS=VSS
Xc_dst_reg_3__1__3_ dfcrq2 $PINS D=n642 CP=ZCTSNET_6 CDN=HFSNET_198
+ Q=c_dst[419] VDD=VDD VSS=VSS
Xc_dst_reg_3__1__2_ dfcrq2 $PINS D=n641 CP=ZCTSNET_10 CDN=HFSNET_181
+ Q=c_dst[418] VDD=VDD VSS=VSS
Xc_dst_reg_3__1__1_ dfcrq2 $PINS D=n640 CP=ZCTSNET_221 CDN=rst_n Q=c_dst[417]
+ VDD=VDD VSS=VSS
Xc_dst_reg_3__1__0_ dfcrq2 $PINS D=n639 CP=ZCTSNET_216 CDN=HFSNET_194
+ Q=c_dst[416] VDD=VDD VSS=VSS
Xc_dst_reg_1__3__31_ dfcrq2 $PINS D=n478 CP=ZCTSNET_207 CDN=HFSNET_189
+ Q=c_dst[255] VDD=VDD VSS=VSS
Xc_dst_reg_1__3__30_ dfcrq2 $PINS D=n477 CP=ZCTSNET_204 CDN=HFSNET_197
+ Q=c_dst[254] VDD=VDD VSS=VSS
Xc_dst_reg_1__3__29_ dfcrq2 $PINS D=n476 CP=ZCTSNET_216 CDN=HFSNET_198
+ Q=c_dst[253] VDD=VDD VSS=VSS
Xc_dst_reg_1__3__28_ dfcrq2 $PINS D=n475 CP=ZCTSNET_220 CDN=HFSNET_187
+ Q=c_dst[252] VDD=VDD VSS=VSS
Xc_dst_reg_1__3__27_ dfcrq2 $PINS D=n474 CP=ZCTSNET_216 CDN=HFSNET_193
+ Q=c_dst[251] VDD=VDD VSS=VSS
Xc_dst_reg_1__3__26_ dfcrq2 $PINS D=n473 CP=ZCTSNET_1 CDN=HFSNET_179
+ Q=c_dst[250] VDD=VDD VSS=VSS
Xc_dst_reg_1__3__25_ dfcrq2 $PINS D=n472 CP=ZCTSNET_6 CDN=HFSNET_182
+ Q=c_dst[249] VDD=VDD VSS=VSS
Xc_dst_reg_1__3__24_ dfcrq2 $PINS D=n471 CP=ZCTSNET_6 CDN=HFSNET_173
+ Q=c_dst[248] VDD=VDD VSS=VSS
Xc_dst_reg_1__3__23_ dfcrq2 $PINS D=n470 CP=ZCTSNET_221 CDN=HFSNET_179
+ Q=c_dst[247] VDD=VDD VSS=VSS
Xc_dst_reg_1__3__22_ dfcrq2 $PINS D=n469 CP=ZCTSNET_217 CDN=HFSNET_172
+ Q=c_dst[246] VDD=VDD VSS=VSS
Xc_dst_reg_1__3__21_ dfcrq2 $PINS D=n468 CP=ZCTSNET_6 CDN=HFSNET_173
+ Q=c_dst[245] VDD=VDD VSS=VSS
Xc_dst_reg_1__3__20_ dfcrq2 $PINS D=n467 CP=ZCTSNET_6 CDN=HFSNET_173
+ Q=c_dst[244] VDD=VDD VSS=VSS
Xc_dst_reg_1__3__19_ dfcrq2 $PINS D=n466 CP=ZCTSNET_210 CDN=HFSNET_172
+ Q=c_dst[243] VDD=VDD VSS=VSS
Xc_dst_reg_1__3__18_ dfcrq2 $PINS D=n465 CP=ZCTSNET_217 CDN=HFSNET_172
+ Q=c_dst[242] VDD=VDD VSS=VSS
Xc_dst_reg_1__3__17_ dfcrq2 $PINS D=n464 CP=ZCTSNET_217 CDN=HFSNET_173
+ Q=c_dst[241] VDD=VDD VSS=VSS
Xc_dst_reg_1__3__16_ dfcrq2 $PINS D=n463 CP=ZCTSNET_217 CDN=HFSNET_172
+ Q=c_dst[240] VDD=VDD VSS=VSS
Xc_dst_reg_1__3__15_ dfcrq2 $PINS D=n462 CP=ZCTSNET_6 CDN=HFSNET_198
+ Q=c_dst[239] VDD=VDD VSS=VSS
Xc_dst_reg_1__3__14_ dfcrq2 $PINS D=n461 CP=ZCTSNET_208 CDN=HFSNET_200
+ Q=c_dst[238] VDD=VDD VSS=VSS
Xc_dst_reg_1__3__13_ dfcrq2 $PINS D=n460 CP=ZCTSNET_208 CDN=HFSNET_172
+ Q=c_dst[237] VDD=VDD VSS=VSS
Xc_dst_reg_1__3__12_ dfcrq2 $PINS D=n459 CP=ZCTSNET_6 CDN=HFSNET_198
+ Q=c_dst[236] VDD=VDD VSS=VSS
Xc_dst_reg_1__3__11_ dfcrq2 $PINS D=n458 CP=ZCTSNET_6 CDN=HFSNET_173
+ Q=c_dst[235] VDD=VDD VSS=VSS
Xc_dst_reg_1__3__10_ dfcrq2 $PINS D=n457 CP=ZCTSNET_6 CDN=HFSNET_198
+ Q=c_dst[234] VDD=VDD VSS=VSS
Xc_dst_reg_1__3__9_ dfcrq2 $PINS D=n456 CP=ZCTSNET_221 CDN=HFSNET_179
+ Q=c_dst[233] VDD=VDD VSS=VSS
Xc_dst_reg_1__3__8_ dfcrq2 $PINS D=n455 CP=ZCTSNET_6 CDN=HFSNET_173
+ Q=c_dst[232] VDD=VDD VSS=VSS
Xc_dst_reg_1__3__7_ dfcrq2 $PINS D=n454 CP=ZCTSNET_217 CDN=HFSNET_173
+ Q=c_dst[231] VDD=VDD VSS=VSS
Xc_dst_reg_1__3__6_ dfcrq2 $PINS D=n453 CP=ZCTSNET_221 CDN=HFSNET_179
+ Q=c_dst[230] VDD=VDD VSS=VSS
Xc_dst_reg_1__3__5_ dfcrq2 $PINS D=n452 CP=ZCTSNET_221 CDN=HFSNET_175
+ Q=c_dst[229] VDD=VDD VSS=VSS
Xc_dst_reg_1__3__4_ dfcrq2 $PINS D=n451 CP=ZCTSNET_217 CDN=HFSNET_173
+ Q=c_dst[228] VDD=VDD VSS=VSS
Xc_dst_reg_1__3__3_ dfcrq2 $PINS D=n450 CP=ZCTSNET_217 CDN=HFSNET_172
+ Q=c_dst[227] VDD=VDD VSS=VSS
Xc_dst_reg_1__3__2_ dfcrq2 $PINS D=n449 CP=ZCTSNET_221 CDN=HFSNET_175
+ Q=c_dst[226] VDD=VDD VSS=VSS
Xc_dst_reg_1__3__1_ dfcrq2 $PINS D=n448 CP=ZCTSNET_221 CDN=HFSNET_179
+ Q=c_dst[225] VDD=VDD VSS=VSS
Xc_dst_reg_1__3__0_ dfcrq2 $PINS D=n447 CP=ZCTSNET_221 CDN=HFSNET_179
+ Q=c_dst[224] VDD=VDD VSS=VSS
Xc_dst_reg_1__1__31_ dfcrq2 $PINS D=n414 CP=ZCTSNET_18 CDN=HFSNET_195
+ Q=c_dst[191] VDD=VDD VSS=VSS
Xc_dst_reg_1__1__30_ dfcrq2 $PINS D=n413 CP=ZCTSNET_9 CDN=HFSNET_193
+ Q=c_dst[190] VDD=VDD VSS=VSS
Xc_dst_reg_1__1__29_ dfcrq2 $PINS D=n412 CP=ZCTSNET_204 CDN=HFSNET_197
+ Q=c_dst[189] VDD=VDD VSS=VSS
Xc_dst_reg_1__1__28_ dfcrq2 $PINS D=n411 CP=ZCTSNET_18 CDN=HFSNET_197
+ Q=c_dst[188] VDD=VDD VSS=VSS
Xc_dst_reg_1__1__27_ dfcrq2 $PINS D=n410 CP=ZCTSNET_18 CDN=HFSNET_195
+ Q=c_dst[187] VDD=VDD VSS=VSS
Xc_dst_reg_1__1__26_ dfcrq2 $PINS D=n409 CP=ZCTSNET_216 CDN=HFSNET_197
+ Q=c_dst[186] VDD=VDD VSS=VSS
Xc_dst_reg_1__1__25_ dfcrq2 $PINS D=n408 CP=ZCTSNET_8 CDN=HFSNET_176
+ Q=c_dst[185] VDD=VDD VSS=VSS
Xc_dst_reg_1__1__24_ dfcrq2 $PINS D=n407 CP=ZCTSNET_221 CDN=HFSNET_175
+ Q=c_dst[184] VDD=VDD VSS=VSS
Xc_dst_reg_1__1__23_ dfcrq2 $PINS D=n406 CP=ZCTSNET_8 CDN=HFSNET_175
+ Q=c_dst[183] VDD=VDD VSS=VSS
Xc_dst_reg_1__1__22_ dfcrq2 $PINS D=n405 CP=ZCTSNET_8 CDN=HFSNET_176
+ Q=c_dst[182] VDD=VDD VSS=VSS
Xc_dst_reg_1__1__21_ dfcrq2 $PINS D=n404 CP=ZCTSNET_8 CDN=HFSNET_176
+ Q=c_dst[181] VDD=VDD VSS=VSS
Xc_dst_reg_1__1__20_ dfcrq2 $PINS D=n403 CP=ZCTSNET_19 CDN=HFSNET_190
+ Q=c_dst[180] VDD=VDD VSS=VSS
Xc_dst_reg_1__1__19_ dfcrq2 $PINS D=copt_net_288 CP=ZCTSNET_8 CDN=HFSNET_176
+ Q=c_dst[179] VDD=VDD VSS=VSS
Xc_dst_reg_1__1__18_ dfcrq2 $PINS D=n401 CP=ZCTSNET_202 CDN=HFSNET_174
+ Q=c_dst[178] VDD=VDD VSS=VSS
Xc_dst_reg_1__1__17_ dfcrq2 $PINS D=n400 CP=ZCTSNET_8 CDN=HFSNET_175
+ Q=c_dst[177] VDD=VDD VSS=VSS
Xc_dst_reg_1__1__16_ dfcrq2 $PINS D=n399 CP=ZCTSNET_202 CDN=HFSNET_174
+ Q=c_dst[176] VDD=VDD VSS=VSS
Xc_dst_reg_1__1__15_ dfcrq2 $PINS D=n398 CP=ZCTSNET_8 CDN=HFSNET_175
+ Q=c_dst[175] VDD=VDD VSS=VSS
Xc_dst_reg_1__1__14_ dfcrq2 $PINS D=n397 CP=ZCTSNET_216 CDN=HFSNET_197
+ Q=c_dst[174] VDD=VDD VSS=VSS
Xc_dst_reg_1__1__13_ dfcrq2 $PINS D=n396 CP=ZCTSNET_221 CDN=HFSNET_179
+ Q=c_dst[173] VDD=VDD VSS=VSS
Xc_dst_reg_1__1__12_ dfcrq2 $PINS D=n395 CP=ZCTSNET_6 CDN=HFSNET_182
+ Q=c_dst[172] VDD=VDD VSS=VSS
Xc_dst_reg_1__1__11_ dfcrq2 $PINS D=n394 CP=ZCTSNET_221 CDN=HFSNET_173
+ Q=c_dst[171] VDD=VDD VSS=VSS
Xc_dst_reg_1__1__10_ dfcrq2 $PINS D=n393 CP=ZCTSNET_207 CDN=HFSNET_175
+ Q=c_dst[170] VDD=VDD VSS=VSS
Xc_dst_reg_1__1__9_ dfcrq2 $PINS D=n392 CP=ZCTSNET_6 CDN=HFSNET_181
+ Q=c_dst[169] VDD=VDD VSS=VSS
Xc_dst_reg_1__1__8_ dfcrq2 $PINS D=n391 CP=ZCTSNET_216 CDN=HFSNET_198
+ Q=c_dst[168] VDD=VDD VSS=VSS
Xc_dst_reg_1__1__7_ dfcrq2 $PINS D=n390 CP=ZCTSNET_6 CDN=HFSNET_182
+ Q=c_dst[167] VDD=VDD VSS=VSS
Xc_dst_reg_1__1__6_ dfcrq2 $PINS D=n389 CP=ZCTSNET_207 CDN=HFSNET_175
+ Q=c_dst[166] VDD=VDD VSS=VSS
Xc_dst_reg_1__1__5_ dfcrq2 $PINS D=n388 CP=ZCTSNET_207 CDN=HFSNET_179
+ Q=c_dst[165] VDD=VDD VSS=VSS
Xc_dst_reg_1__1__4_ dfcrq2 $PINS D=n387 CP=ZCTSNET_216 CDN=HFSNET_193
+ Q=c_dst[164] VDD=VDD VSS=VSS
Xc_dst_reg_1__1__3_ dfcrq2 $PINS D=n386 CP=ZCTSNET_216 CDN=HFSNET_198
+ Q=c_dst[163] VDD=VDD VSS=VSS
Xc_dst_reg_1__1__2_ dfcrq2 $PINS D=n385 CP=ZCTSNET_8 CDN=HFSNET_176
+ Q=c_dst[162] VDD=VDD VSS=VSS
Xc_dst_reg_1__1__1_ dfcrq2 $PINS D=n384 CP=ZCTSNET_8 CDN=HFSNET_175
+ Q=c_dst[161] VDD=VDD VSS=VSS
Xc_dst_reg_1__1__0_ dfcrq2 $PINS D=n383 CP=ZCTSNET_216 CDN=HFSNET_197
+ Q=c_dst[160] VDD=VDD VSS=VSS
Xmode_lat_reg dfcrq2 $PINS D=n837 CP=ZCTSNET_9 CDN=HFSNET_186 Q=HFSNET_171
+ VDD=VDD VSS=VSS
XHFSINV_4_298 inv0d0 $PINS I=dest_c[20] ZN=HFSNET_22 VDD=VDD VSS=VSS
XHFSINV_11_299 inv0d0 $PINS I=src_a[10] ZN=HFSNET_23 VDD=VDD VSS=VSS
XU16 oaim22d1 $PINS A1=HFSNET_92 A2=HFSNET_142 B1=copt_net_1423 B2=HFSNET_142
+ ZN=n537 VDD=VDD VSS=VSS
XU45 mx02d1 $PINS I0=copt_net_2286 I1=copt_net_1958 S=HFSNET_150 Z=n416 VDD=VDD
+ VSS=VSS
XU97 mx02d1 $PINS I0=copt_net_2256 I1=copt_net_1993 S=HFSNET_137 Z=n594 VDD=VDD
+ VSS=VSS
XU98 mx02d1 $PINS I0=c_in[113] I1=c_dst[497] S=HFSNET_163 Z=n720 VDD=VDD
+ VSS=VSS
XU99 mx02d0 $PINS I0=c_in[35] I1=copt_net_2495 S=HFSNET_155 Z=n258 VDD=VDD
+ VSS=VSS
XU105 mx02d1 $PINS I0=copt_net_1663 I1=copt_net_2221 S=HFSNET_149 Z=n375
+ VDD=VDD VSS=VSS
XU125 mx02d1 $PINS I0=c_in[69] I1=copt_net_1574 S=HFSNET_150 Z=n420 VDD=VDD
+ VSS=VSS
XU128 mx02d1 $PINS I0=c_in[31] I1=c_dst[287] S=HFSNET_141 Z=n510 VDD=VDD
+ VSS=VSS
XU135 mx02d1 $PINS I0=copt_net_2256 I1=copt_net_1974 S=HFSNET_163 Z=n722
+ VDD=VDD VSS=VSS
XU138 oaim22d1 $PINS A1=HFSNET_113 A2=HFSNET_147 B1=copt_net_1249 B2=HFSNET_147
+ ZN=n436 VDD=VDD VSS=VSS
XU163 oaim22d1 $PINS A1=HFSNET_159 A2=n852 B1=copt_net_1499 B2=HFSNET_159
+ ZN=n310 VDD=VDD VSS=VSS
XU204 mx02d1 $PINS I0=copt_net_2332 I1=copt_net_1252 S=HFSNET_138 Z=n551
+ VDD=VDD VSS=VSS
XU208 mx02d1 $PINS I0=copt_net_2264 I1=copt_net_1884 S=HFSNET_164 Z=n726
+ VDD=VDD VSS=VSS
XU224 mx02d1 $PINS I0=copt_net_2366 I1=copt_net_2061 S=n40 Z=n348 VDD=VDD
+ VSS=VSS
XU231 mx02d0 $PINS I0=c_in[92] I1=copt_net_2225 S=HFSNET_146 Z=n443 VDD=VDD
+ VSS=VSS
XU232 oaim22d1 $PINS A1=HFSNET_159 A2=HFSNET_115 B1=copt_net_1919 B2=HFSNET_159
+ ZN=n311 VDD=VDD VSS=VSS
XU247 mx02d0 $PINS I0=copt_net_2590 I1=copt_net_1392 S=HFSNET_141 Z=n496
+ VDD=VDD VSS=VSS
XU266 mx02d0 $PINS I0=copt_net_2284 I1=copt_net_1268 S=HFSNET_138 Z=n552
+ VDD=VDD VSS=VSS
XU267 mx02d1 $PINS I0=copt_net_2435 I1=copt_net_1430 S=HFSNET_147 Z=n459
+ VDD=VDD VSS=VSS
XU285 mx02d0 $PINS I0=copt_net_2611 I1=copt_net_2187 S=HFSNET_163 Z=n709
+ VDD=VDD VSS=VSS
XU299 mx02d0 $PINS I0=copt_net_2256 I1=copt_net_1929 S=HFSNET_157 Z=n338
+ VDD=VDD VSS=VSS
XU326 mx02d1 $PINS I0=c_in[118] I1=c_dst[118] S=HFSNET_157 Z=n341 VDD=VDD
+ VSS=VSS
XU329 mx02d0 $PINS I0=copt_net_2172 I1=copt_net_1868 S=HFSNET_142 Z=n540
+ VDD=VDD VSS=VSS
XU340 mx02d0 $PINS I0=copt_net_2639 I1=c_dst[221] S=HFSNET_145 Z=n444 VDD=VDD
+ VSS=VSS
XU341 mx02d1 $PINS I0=copt_net_2293 I1=copt_net_1305 S=HFSNET_153 Z=n228
+ VDD=VDD VSS=VSS
XU344 mx02d0 $PINS I0=c_in[89] I1=copt_net_2677 S=HFSNET_159 Z=n312 VDD=VDD
+ VSS=VSS
XU355 mx02d0 $PINS I0=copt_net_2323 I1=copt_net_2032 S=HFSNET_136 Z=n555
+ VDD=VDD VSS=VSS
XU383 mx02d0 $PINS I0=copt_net_2700 I1=copt_net_2130 S=HFSNET_145 Z=n478
+ VDD=VDD VSS=VSS
XU385 mx02d1 $PINS I0=copt_net_2294 I1=copt_net_1395 S=HFSNET_168 Z=n612
+ VDD=VDD VSS=VSS
XU396 mx02d1 $PINS I0=copt_net_2358 I1=copt_net_2047 S=HFSNET_137 Z=n596
+ VDD=VDD VSS=VSS
XU398 mx02d1 $PINS I0=c_in[6] I1=copt_net_1413 S=HFSNET_156 Z=n229 VDD=VDD
+ VSS=VSS
XU400 oaim22d1 $PINS A1=HFSNET_159 A2=HFSNET_120 B1=copt_net_1565 B2=HFSNET_159
+ ZN=n318 VDD=VDD VSS=VSS
XU402 mx02d0 $PINS I0=c_in[87] I1=copt_net_2230 S=HFSNET_141 Z=n566 VDD=VDD
+ VSS=VSS
XHFSINV_101_487 inv0d1 $PINS I=HFSNET_143 ZN=HFSNET_135 VDD=VDD VSS=VSS
XU406 nr03d1 $PINS A1=n950 A2=state[1] A3=n955 ZN=n197 VDD=VDD VSS=VSS
XU407 nr03d1 $PINS A1=n211 A2=state[0] A3=n953 ZN=n960 VDD=VDD VSS=VSS
XHFSBUF_498_496 buffd1 $PINS I=HFSNET_146 Z=HFSNET_144 VDD=VDD VSS=VSS
XHFSBUF_137_513 buffd1 $PINS I=HFSNET_169 Z=HFSNET_161 VDD=VDD VSS=VSS
XHFSBUF_731_497 buffd1 $PINS I=HFSNET_146 Z=HFSNET_145 VDD=VDD VSS=VSS
XHFSBUF_820_498 buffd1 $PINS I=HFSNET_150 Z=HFSNET_146 VDD=VDD VSS=VSS
XHFSBUF_355_499 buffd1 $PINS I=HFSNET_150 Z=HFSNET_147 VDD=VDD VSS=VSS
XHFSBUF_1368_500 buffd1 $PINS I=HFSNET_150 Z=HFSNET_148 VDD=VDD VSS=VSS
XHFSBUF_1504_501 buffd1 $PINS I=HFSNET_150 Z=HFSNET_149 VDD=VDD VSS=VSS
XHFSBUF_2292_502 buffd3 $PINS I=n171 Z=HFSNET_150 VDD=VDD VSS=VSS
Xgre_a_INV_58_inst_5795 inv0d0 $PINS I=src_b[18] ZN=gre_a_INV_58_3 VDD=VDD
+ VSS=VSS
XHFSBUF_140_504 buffd1 $PINS I=n40 Z=HFSNET_152 VDD=VDD VSS=VSS
XHFSBUF_1292_514 buffd1 $PINS I=HFSNET_169 Z=HFSNET_162 VDD=VDD VSS=VSS
XHFSBUF_1565_515 buffd1 $PINS I=HFSNET_169 Z=HFSNET_163 VDD=VDD VSS=VSS
XHFSBUF_1702_516 buffd1 $PINS I=HFSNET_169 Z=HFSNET_164 VDD=VDD VSS=VSS
XHFSBUF_664_517 buffd1 $PINS I=HFSNET_168 Z=HFSNET_165 VDD=VDD VSS=VSS
XHFSBUF_595_518 buffd1 $PINS I=HFSNET_168 Z=HFSNET_166 VDD=VDD VSS=VSS
XHFSBUF_805_519 buffd1 $PINS I=HFSNET_168 Z=HFSNET_167 VDD=VDD VSS=VSS
XHFSBUF_2165_520 buffd3 $PINS I=HFSNET_169 Z=HFSNET_168 VDD=VDD VSS=VSS
XHFSBUF_2851_521 bufbd1 $PINS I=n174 Z=HFSNET_169 VDD=VDD VSS=VSS
XHFSBUF_770_505 buffd1 $PINS I=n40 Z=HFSNET_153 VDD=VDD VSS=VSS
XZCTSBUF_75677_2546 buffd3 $PINS I=ZCTSNET_6 Z=ZCTSNET_9 VDD=VDD VSS=VSS
XHFSINV_8645_615 inv0d2 $PINS I=HFSNET_178 ZN=HFSNET_172 VDD=VDD VSS=VSS
XHFSINV_8391_616 inv0d2 $PINS I=HFSNET_178 ZN=HFSNET_173 VDD=VDD VSS=VSS
XHFSINV_7523_618 inv0d2 $PINS I=HFSNET_178 ZN=HFSNET_175 VDD=VDD VSS=VSS
XHFSINV_7373_622 inv0d2 $PINS I=HFSNET_178 ZN=HFSNET_179 VDD=VDD VSS=VSS
XHFSINV_8848_624 inv0d2 $PINS I=HFSNET_196 ZN=HFSNET_181 VDD=VDD VSS=VSS
XHFSINV_11830_625 inv0d2 $PINS I=HFSNET_196 ZN=HFSNET_182 VDD=VDD VSS=VSS
XHFSINV_11975_631 inv0d2 $PINS I=HFSNET_196 ZN=HFSNET_187 VDD=VDD VSS=VSS
XHFSINV_10190_633 inv0d2 $PINS I=HFSNET_196 ZN=HFSNET_189 VDD=VDD VSS=VSS
XHFSINV_10413_634 inv0d2 $PINS I=HFSNET_196 ZN=HFSNET_190 VDD=VDD VSS=VSS
XHFSINV_10300_636 inv0d2 $PINS I=HFSNET_196 ZN=HFSNET_192 VDD=VDD VSS=VSS
XHFSINV_8955_637 inv0d2 $PINS I=HFSNET_196 ZN=HFSNET_193 VDD=VDD VSS=VSS
XHFSINV_9096_643 inv0d2 $PINS I=HFSNET_196 ZN=HFSNET_197 VDD=VDD VSS=VSS
XHFSINV_10889_644 inv0d1 $PINS I=HFSNET_196 ZN=HFSNET_198 VDD=VDD VSS=VSS
XctmTdsLR_1_1240 oaim22d1 $PINS A1=dim_n[2] A2=n207 B1=dim_n[2] B2=n207 ZN=n204
+ VDD=VDD VSS=VSS
XctmTdsLR_2_1241 oaim22d1 $PINS A1=dim_k[2] A2=n208 B1=dim_k[2] B2=n208 ZN=n203
+ VDD=VDD VSS=VSS
XctmTdsLR_3_1242 aoim22d1 $PINS A1=n957 A2=n206 B1=n957 B2=n206 Z=n205 VDD=VDD
+ VSS=VSS
XZCTSBUF_70914_2547 buffd7 $PINS I=ZCTSNET_6 Z=ZCTSNET_10 VDD=VDD VSS=VSS
XZCTSBUF_116928_2559 buffda $PINS I=ZCTSNET_18 Z=ZCTSNET_19 VDD=VDD VSS=VSS
Xcopt_h_inst_3117 dl02d1 $PINS I=n262 Z=copt_net_287 VDD=VDD VSS=VSS
Xcopt_h_inst_3118 dl02d1 $PINS I=n402 Z=copt_net_288 VDD=VDD VSS=VSS
Xcopt_h_inst_3171 dl02d1 $PINS I=n510 Z=copt_net_341 VDD=VDD VSS=VSS
Xcopt_h_inst_3186 dl02d1 $PINS I=n839 Z=copt_net_356 VDD=VDD VSS=VSS
Xcopt_h_inst_3190 dl02d1 $PINS I=n720 Z=copt_net_360 VDD=VDD VSS=VSS
Xcopt_h_inst_3220 dl02d1 $PINS I=c_in[50] Z=copt_net_390 VDD=VDD VSS=VSS
Xcopt_h_inst_3306 dl02d1 $PINS I=n341 Z=copt_net_476 VDD=VDD VSS=VSS
Xcopt_h_inst_3417 dl02d1 $PINS I=n263 Z=copt_net_587 VDD=VDD VSS=VSS
Xcopt_h_inst_3440 dl02d1 $PINS I=n843 Z=copt_net_610 VDD=VDD VSS=VSS
Xcopt_h_inst_3443 dl02d1 $PINS I=job_k[2] Z=copt_net_613 VDD=VDD VSS=VSS
Xcopt_h_inst_3522 dl02d1 $PINS I=c_in[57] Z=copt_net_692 VDD=VDD VSS=VSS
Xcopt_h_inst_3578 dl02d1 $PINS I=c_dst[505] Z=copt_net_747 VDD=VDD VSS=VSS
Xcopt_h_inst_3585 dl02d1 $PINS I=c_dst[477] Z=copt_net_754 VDD=VDD VSS=VSS
Xcopt_h_inst_3587 dl02d1 $PINS I=c_dst[387] Z=copt_net_756 VDD=VDD VSS=VSS
Xcopt_h_inst_3590 dl02d1 $PINS I=c_dst[134] Z=copt_net_759 VDD=VDD VSS=VSS
Xcopt_h_inst_3591 dl02d1 $PINS I=c_dst[3] Z=copt_net_760 VDD=VDD VSS=VSS
XHFSBUF_367_506 buffd1 $PINS I=n40 Z=HFSNET_154 VDD=VDD VSS=VSS
XHFSBUF_490_507 buffd1 $PINS I=n40 Z=HFSNET_155 VDD=VDD VSS=VSS
Xcopt_h_inst_3592 dl02d1 $PINS I=c_dst[504] Z=copt_net_761 VDD=VDD VSS=VSS
XHFSBUF_254_508 buffd1 $PINS I=n40 Z=HFSNET_156 VDD=VDD VSS=VSS
XHFSBUF_1383_509 buffd1 $PINS I=n40 Z=HFSNET_157 VDD=VDD VSS=VSS
XHFSBUF_1476_510 buffd1 $PINS I=n40 Z=HFSNET_158 VDD=VDD VSS=VSS
XHFSBUF_1618_511 buffd1 $PINS I=n40 Z=HFSNET_159 VDD=VDD VSS=VSS
Xcopt_h_inst_3593 dl02d1 $PINS I=c_dst[349] Z=copt_net_762 VDD=VDD VSS=VSS
Xcopt_h_inst_3595 dl02d1 $PINS I=c_dst[148] Z=copt_net_764 VDD=VDD VSS=VSS
Xcopt_h_inst_3596 dl02d1 $PINS I=c_dst[360] Z=copt_net_765 VDD=VDD VSS=VSS
Xcopt_h_inst_3597 dl02d1 $PINS I=c_dst[258] Z=copt_net_766 VDD=VDD VSS=VSS
Xcopt_h_inst_3598 dl02d1 $PINS I=c_dst[408] Z=copt_net_767 VDD=VDD VSS=VSS
Xcopt_h_inst_3599 dl02d1 $PINS I=c_dst[17] Z=copt_net_768 VDD=VDD VSS=VSS
Xcopt_h_inst_3602 dl02d1 $PINS I=c_dst[217] Z=copt_net_771 VDD=VDD VSS=VSS
Xcopt_h_inst_3603 dl02d1 $PINS I=c_dst[386] Z=copt_net_772 VDD=VDD VSS=VSS
XHFSINV_2002_488 inv0d1 $PINS I=HFSNET_143 ZN=HFSNET_136 VDD=VDD VSS=VSS
XHFSBUF_1163_489 buffd3 $PINS I=HFSNET_138 Z=HFSNET_137 VDD=VDD VSS=VSS
XHFSINV_1394_490 inv0d1 $PINS I=HFSNET_143 ZN=HFSNET_138 VDD=VDD VSS=VSS
XHFSBUF_605_491 buffd1 $PINS I=HFSNET_141 Z=HFSNET_139 VDD=VDD VSS=VSS
XHFSBUF_706_492 buffd1 $PINS I=HFSNET_141 Z=HFSNET_140 VDD=VDD VSS=VSS
XHFSINV_941_493 inv0d2 $PINS I=HFSNET_143 ZN=HFSNET_141 VDD=VDD VSS=VSS
XHFSINV_2494_494 inv0d2 $PINS I=HFSNET_143 ZN=HFSNET_142 VDD=VDD VSS=VSS
Xcopt_h_inst_3605 dl02d1 $PINS I=c_dst[450] Z=copt_net_774 VDD=VDD VSS=VSS
Xcopt_h_inst_3606 dl02d1 $PINS I=c_dst[248] Z=copt_net_775 VDD=VDD VSS=VSS
Xcopt_h_inst_3608 dl02d1 $PINS I=c_dst[227] Z=copt_net_777 VDD=VDD VSS=VSS
Xcopt_h_inst_3609 dl02d1 $PINS I=c_dst[289] Z=copt_net_778 VDD=VDD VSS=VSS
Xcopt_h_inst_3610 dl02d1 $PINS I=c_dst[401] Z=copt_net_779 VDD=VDD VSS=VSS
XHFSBUF_3395_460 buffd1 $PINS I=n177 Z=HFSNET_126 VDD=VDD VSS=VSS
XHFSBUF_8244_461 buffd1 $PINS I=n177 Z=HFSNET_127 VDD=VDD VSS=VSS
XHFSBUF_10125_462 buffd1 $PINS I=n177 Z=HFSNET_128 VDD=VDD VSS=VSS
Xcopt_h_inst_3611 dl02d1 $PINS I=c_dst[66] Z=copt_net_780 VDD=VDD VSS=VSS
Xcopt_h_inst_3612 dl02d1 $PINS I=c_dst[388] Z=copt_net_781 VDD=VDD VSS=VSS
XHFSBUF_8341_465 buffd1 $PINS I=HFSNET_134 Z=HFSNET_131 VDD=VDD VSS=VSS
XHFSBUF_10296_466 buffd1 $PINS I=HFSNET_134 Z=HFSNET_132 VDD=VDD VSS=VSS
XU584 inv0d0 $PINS I=n39 ZN=n948 VDD=VDD VSS=VSS
Xcopt_h_inst_3613 dl02d1 $PINS I=c_dst[0] Z=copt_net_782 VDD=VDD VSS=VSS
Xcopt_h_inst_3614 dl02d1 $PINS I=c_dst[262] Z=copt_net_783 VDD=VDD VSS=VSS
Xcopt_h_inst_3615 dl02d1 $PINS I=c_dst[149] Z=copt_net_784 VDD=VDD VSS=VSS
Xcopt_h_inst_3616 dl02d1 $PINS I=c_dst[363] Z=copt_net_785 VDD=VDD VSS=VSS
Xcopt_h_inst_3617 dl02d1 $PINS I=c_dst[362] Z=copt_net_786 VDD=VDD VSS=VSS
Xcopt_h_inst_3618 dl02d1 $PINS I=c_dst[21] Z=copt_net_787 VDD=VDD VSS=VSS
Xcopt_h_inst_3619 dl02d1 $PINS I=c_dst[259] Z=copt_net_788 VDD=VDD VSS=VSS
Xcopt_h_inst_3620 dl02d1 $PINS I=c_dst[188] Z=copt_net_789 VDD=VDD VSS=VSS
Xcopt_h_inst_3621 dl02d1 $PINS I=c_dst[20] Z=copt_net_790 VDD=VDD VSS=VSS
Xcopt_h_inst_3625 dl02d1 $PINS I=c_dst[254] Z=copt_net_793 VDD=VDD VSS=VSS
Xcopt_h_inst_3626 dl02d1 $PINS I=c_dst[235] Z=copt_net_794 VDD=VDD VSS=VSS
Xcopt_h_inst_3628 dl02d1 $PINS I=c_dst[60] Z=copt_net_796 VDD=VDD VSS=VSS
Xcopt_h_inst_3629 dl02d1 $PINS I=c_dst[488] Z=copt_net_797 VDD=VDD VSS=VSS
XU610 inv0d0 $PINS I=n192 ZN=n947 VDD=VDD VSS=VSS
XU612 nr03d1 $PINS A1=job_kind[0] A2=job_kind[1] A3=n5 ZN=n39 VDD=VDD VSS=VSS
Xcopt_h_inst_3630 dl02d1 $PINS I=c_dst[510] Z=copt_net_798 VDD=VDD VSS=VSS
Xcopt_h_inst_3631 dl02d1 $PINS I=c_dst[194] Z=copt_net_799 VDD=VDD VSS=VSS
Xcopt_h_inst_3634 dl02d1 $PINS I=c_dst[406] Z=copt_net_802 VDD=VDD VSS=VSS
Xcopt_h_inst_3635 dl02d1 $PINS I=c_dst[126] Z=copt_net_803 VDD=VDD VSS=VSS
Xcopt_h_inst_3638 dl02d1 $PINS I=c_dst[355] Z=copt_net_806 VDD=VDD VSS=VSS
Xcopt_h_inst_3639 dl02d1 $PINS I=c_dst[483] Z=copt_net_807 VDD=VDD VSS=VSS
Xcopt_h_inst_3641 dl02d1 $PINS I=c_dst[128] Z=copt_net_809 VDD=VDD VSS=VSS
Xcopt_h_inst_3644 dl02d1 $PINS I=c_dst[490] Z=copt_net_812 VDD=VDD VSS=VSS
Xcopt_h_inst_3647 dl02d1 $PINS I=c_dst[59] Z=copt_net_815 VDD=VDD VSS=VSS
Xcopt_h_inst_3649 dl02d1 $PINS I=c_dst[130] Z=copt_net_817 VDD=VDD VSS=VSS
Xcopt_h_inst_3650 dl02d1 $PINS I=c_dst[232] Z=copt_net_818 VDD=VDD VSS=VSS
Xcopt_h_inst_3651 dl02d1 $PINS I=c_dst[322] Z=copt_net_819 VDD=VDD VSS=VSS
XHFSBUF_16356_467 buffd1 $PINS I=HFSNET_134 Z=HFSNET_133 VDD=VDD VSS=VSS
XHFSINV_17697_468 inv0d1 $PINS I=n177 ZN=HFSNET_134 VDD=VDD VSS=VSS
XU404 or03d1 $PINS A1=n180 A2=state[2] A3=n181 Z=n177 VDD=VDD VSS=VSS
Xcopt_h_inst_3657 dl02d1 $PINS I=c_dst[187] Z=copt_net_825 VDD=VDD VSS=VSS
Xcopt_h_inst_3659 dl02d1 $PINS I=c_dst[376] Z=copt_net_827 VDD=VDD VSS=VSS
XU642 nd12d1 $PINS A1=a_swap A2=n182 ZN=n183 VDD=VDD VSS=VSS
Xcopt_h_inst_3665 dl02d1 $PINS I=c_dst[280] Z=copt_net_833 VDD=VDD VSS=VSS
Xcopt_h_inst_3667 dl02d1 $PINS I=c_dst[260] Z=copt_net_835 VDD=VDD VSS=VSS
Xcopt_h_inst_3674 dl02d1 $PINS I=c_dst[358] Z=copt_net_842 VDD=VDD VSS=VSS
XU650 nr03d2 $PINS A1=n941 A2=n31 A3=n947 ZN=rd_row[0] VDD=VDD VSS=VSS
XU652 nr03d1 $PINS A1=n950 A2=n956 A3=n955 ZN=n192 VDD=VDD VSS=VSS
XU653 inv0d0 $PINS I=n218 ZN=n950 VDD=VDD VSS=VSS
XU654 nd02d1 $PINS A1=n956 A2=n955 ZN=n211 VDD=VDD VSS=VSS
XU655 buffd1 $PINS I=n960 Z=job_kind[1] VDD=VDD VSS=VSS
XU661 nd12d1 $PINS A1=job_kind[1] A2=n219 ZN=array_en VDD=VDD VSS=VSS
XU763 buffd1 $PINS I=n197 Z=n5 VDD=VDD VSS=VSS
XU764 buffd1 $PINS I=n961 Z=job_kind[0] VDD=VDD VSS=VSS
XU767 nr02d1 $PINS A1=n180 A2=n955 ZN=a_swap VDD=VDD VSS=VSS
XU768 inv0d0 $PINS I=n212 ZN=n954 VDD=VDD VSS=VSS
XU770 nd03d2 $PINS A1=n169 A2=n941 A3=n170 ZN=n171 VDD=VDD VSS=VSS
XU774 nr13d1 $PINS A1=n175 A2=n947 A3=n176 ZN=n170 VDD=VDD VSS=VSS
XU776 nd03d0 $PINS A1=n170 A2=n941 A3=n942 ZN=n174 VDD=VDD VSS=VSS
Xcopt_h_inst_3676 dl02d1 $PINS I=c_dst[131] Z=copt_net_844 VDD=VDD VSS=VSS
Xcopt_h_inst_3677 dl02d1 $PINS I=c_dst[127] Z=copt_net_845 VDD=VDD VSS=VSS
Xcopt_h_inst_3680 dl02d1 $PINS I=c_dst[150] Z=copt_net_848 VDD=VDD VSS=VSS
XU782 nr02d1 $PINS A1=n944 A2=n186 ZN=n184 VDD=VDD VSS=VSS
Xcopt_h_inst_3687 dl02d1 $PINS I=c_dst[2] Z=copt_net_855 VDD=VDD VSS=VSS
XU785 inv0d0 $PINS I=n169 ZN=n942 VDD=VDD VSS=VSS
Xcopt_h_inst_3688 dl02d1 $PINS I=c_dst[326] Z=copt_net_856 VDD=VDD VSS=VSS
XU788 inv0d0 $PINS I=n189 ZN=n940 VDD=VDD VSS=VSS
XU789 oai321d1 $PINS C1=n955 C2=n954 C3=n946 B1=n940 B2=n953 A=n202 ZN=n847
+ VDD=VDD VSS=VSS
XU791 nr02d1 $PINS A1=job_kind[1] A2=n38 ZN=n202 VDD=VDD VSS=VSS
XU793 nr02d1 $PINS A1=job_kind[0] A2=n951 ZN=n195 VDD=VDD VSS=VSS
XU794 nd03d1 $PINS A1=n204 A2=n203 A3=n205 ZN=n181 VDD=VDD VSS=VSS
XU796 nd12d1 $PINS A1=n191 A2=n192 ZN=n190 VDD=VDD VSS=VSS
Xcopt_h_inst_3689 dl02d1 $PINS I=c_dst[240] Z=copt_net_857 VDD=VDD VSS=VSS
Xcopt_h_inst_3691 dl02d1 $PINS I=c_dst[511] Z=copt_net_859 VDD=VDD VSS=VSS
XU801 nd02d1 $PINS A1=n192 A2=n191 ZN=n182 VDD=VDD VSS=VSS
XU804 buffd1 $PINS I=n960 Z=n95 VDD=VDD VSS=VSS
XU808 buffd1 $PINS I=n197 Z=n6 VDD=VDD VSS=VSS
XU810 buffd1 $PINS I=n961 Z=n93 VDD=VDD VSS=VSS
XU811 inv0d0 $PINS I=n180 ZN=n951 VDD=VDD VSS=VSS
Xcopt_h_inst_3692 dl02d1 $PINS I=c_dst[132] Z=copt_net_860 VDD=VDD VSS=VSS
XU813 inv0d0 $PINS I=n221 ZN=n943 VDD=VDD VSS=VSS
XU846 nr03d2 $PINS A1=n947 A2=n221 A3=n31 ZN=rd_row[1] VDD=VDD VSS=VSS
XU847 nr02d1 $PINS A1=state[0] A2=state[3] ZN=n218 VDD=VDD VSS=VSS
XU848 inv0d0 $PINS I=cycle[0] ZN=n941 VDD=VDD VSS=VSS
XU849 inv0d0 $PINS I=state[2] ZN=n955 VDD=VDD VSS=VSS
XU850 inv0d0 $PINS I=state[1] ZN=n956 VDD=VDD VSS=VSS
XU851 inv0d0 $PINS I=job_m[2] ZN=n952 VDD=VDD VSS=VSS
XU853 inv0d0 $PINS I=cycle[3] ZN=n945 VDD=VDD VSS=VSS
XU855 nr04d2 $PINS A1=n953 A2=n956 A3=state[0] A4=state[2] ZN=error VDD=VDD
+ VSS=VSS
XU856 inv0d0 $PINS I=state[3] ZN=n953 VDD=VDD VSS=VSS
XU857 nr02d1 $PINS A1=job_issued A2=n39 ZN=job_start VDD=VDD VSS=VSS
XU858 nr03d1 $PINS A1=n956 A2=state[2] A3=n950 ZN=n961 VDD=VDD VSS=VSS
XU859 nd03d1 $PINS A1=n956 A2=n953 A3=state[0] ZN=n180 VDD=VDD VSS=VSS
XU860 nr02d0 $PINS A1=n956 A2=state[3] ZN=n212 VDD=VDD VSS=VSS
XU861 nr03d2 $PINS A1=n954 A2=state[2] A3=n946 ZN=w_swap VDD=VDD VSS=VSS
XU862 inv0d0 $PINS I=state[0] ZN=n946 VDD=VDD VSS=VSS
XU863 nd03d2 $PINS A1=n170 A2=n169 A3=copt_net_2880 ZN=n40 VDD=VDD VSS=VSS
Xcopt_h_inst_3698 dl02d1 $PINS I=c_dst[301] Z=copt_net_866 VDD=VDD VSS=VSS
XU867 nd02d1 $PINS A1=cycle[0] A2=n943 ZN=n186 VDD=VDD VSS=VSS
XU868 inv0d0 $PINS I=job_start ZN=n949 VDD=VDD VSS=VSS
XU869 inv0d0 $PINS I=cycle[2] ZN=n944 VDD=VDD VSS=VSS
XU870 nr02d1 $PINS A1=dim_k[0] A2=dim_k[1] ZN=n208 VDD=VDD VSS=VSS
XU871 nr02d1 $PINS A1=dim_n[0] A2=dim_n[1] ZN=n207 VDD=VDD VSS=VSS
XU872 inv0d0 $PINS I=dim_m[2] ZN=n957 VDD=VDD VSS=VSS
XU873 nr02d1 $PINS A1=dim_m[0] A2=dim_m[1] ZN=n206 VDD=VDD VSS=VSS
XU874 nr02d1 $PINS A1=job_m[1] A2=n217 ZN=n216 VDD=VDD VSS=VSS
XU875 nr03d1 $PINS A1=n953 A2=n946 A3=n211 ZN=done VDD=VDD VSS=VSS
XHFSINV_214_314 inv0d0 $PINS I=c_in[96] ZN=HFSNET_34 VDD=VDD VSS=VSS
XHFSINV_207_317 inv0d0 $PINS I=c_in[97] ZN=HFSNET_37 VDD=VDD VSS=VSS
XHFSINV_215_322 inv0d0 $PINS I=c_in[98] ZN=HFSNET_42 VDD=VDD VSS=VSS
XU879 inv0d0 $PINS I=c_in[99] ZN=n194 VDD=VDD VSS=VSS
XHFSINV_172_323 inv0d0 $PINS I=c_in[100] ZN=HFSNET_43 VDD=VDD VSS=VSS
XHFSINV_310_324 inv0d0 $PINS I=c_in[101] ZN=HFSNET_44 VDD=VDD VSS=VSS
XU882 inv0d0 $PINS I=copt_net_2611 ZN=n185 VDD=VDD VSS=VSS
XHFSINV_164_325 inv0d0 $PINS I=c_in[103] ZN=HFSNET_45 VDD=VDD VSS=VSS
XU884 inv0d0 $PINS I=c_in[104] ZN=n178 VDD=VDD VSS=VSS
XHFSINV_189_326 inv0d0 $PINS I=c_in[105] ZN=HFSNET_46 VDD=VDD VSS=VSS
XU886 inv0d0 $PINS I=c_in[106] ZN=n168 VDD=VDD VSS=VSS
XU887 inv0d0 $PINS I=c_in[107] ZN=n167 VDD=VDD VSS=VSS
XU888 inv0d0 $PINS I=copt_net_2435 ZN=n166 VDD=VDD VSS=VSS
XU889 inv0d0 $PINS I=c_in[109] ZN=n165 VDD=VDD VSS=VSS
XU890 inv0d0 $PINS I=c_in[110] ZN=n164 VDD=VDD VSS=VSS
XHFSINV_193_315 inv0d0 $PINS I=c_in[111] ZN=HFSNET_35 VDD=VDD VSS=VSS
XU892 inv0d0 $PINS I=c_in[112] ZN=n162 VDD=VDD VSS=VSS
XU893 inv0d0 $PINS I=c_in[113] ZN=n161 VDD=VDD VSS=VSS
XHFSINV_229_316 inv0d0 $PINS I=c_in[114] ZN=HFSNET_36 VDD=VDD VSS=VSS
Xcopt_h_inst_3699 dl02d1 $PINS I=c_dst[383] Z=copt_net_867 VDD=VDD VSS=VSS
XHFSINV_245_318 inv0d0 $PINS I=c_in[116] ZN=HFSNET_38 VDD=VDD VSS=VSS
XU897 inv0d0 $PINS I=copt_net_2358 ZN=n157 VDD=VDD VSS=VSS
XU898 inv0d0 $PINS I=c_in[118] ZN=n156 VDD=VDD VSS=VSS
XHFSINV_74_313 inv0d1 $PINS I=copt_net_2264 ZN=HFSNET_33 VDD=VDD VSS=VSS
XU900 inv0d0 $PINS I=c_in[120] ZN=n154 VDD=VDD VSS=VSS
XU901 inv0d0 $PINS I=c_in[121] ZN=n153 VDD=VDD VSS=VSS
XHFSINV_215_319 inv0d0 $PINS I=c_in[122] ZN=HFSNET_39 VDD=VDD VSS=VSS
XHFSINV_206_320 inv0d0 $PINS I=c_in[123] ZN=HFSNET_40 VDD=VDD VSS=VSS
XHFSINV_153_321 inv0d0 $PINS I=c_in[124] ZN=HFSNET_41 VDD=VDD VSS=VSS
XU905 inv0d0 $PINS I=copt_net_2366 ZN=n149 VDD=VDD VSS=VSS
XU906 inv0d0 $PINS I=c_in[126] ZN=n148 VDD=VDD VSS=VSS
XU907 inv0d0 $PINS I=copt_net_2700 ZN=n147 VDD=VDD VSS=VSS
XHFSINV_342_333 inv0d1 $PINS I=c_in[0] ZN=HFSNET_53 VDD=VDD VSS=VSS
XHFSINV_335_344 inv0d1 $PINS I=c_in[1] ZN=HFSNET_64 VDD=VDD VSS=VSS
XU910 inv0d0 $PINS I=c_in[2] ZN=n937 VDD=VDD VSS=VSS
XHFSINV_125_352 inv0d0 $PINS I=c_in[3] ZN=HFSNET_72 VDD=VDD VSS=VSS
XU912 inv0d1 $PINS I=c_in[4] ZN=n935 VDD=VDD VSS=VSS
XU913 inv0d0 $PINS I=copt_net_2293 ZN=n934 VDD=VDD VSS=VSS
XU914 inv0d0 $PINS I=c_in[6] ZN=n933 VDD=VDD VSS=VSS
XHFSINV_128_353 inv0d1 $PINS I=c_in[7] ZN=HFSNET_73 VDD=VDD VSS=VSS
XU916 inv0d0 $PINS I=c_in[8] ZN=n931 VDD=VDD VSS=VSS
XHFSINV_128_354 inv0d1 $PINS I=c_in[9] ZN=HFSNET_74 VDD=VDD VSS=VSS
XHFSINV_297_334 inv0d1 $PINS I=c_in[10] ZN=HFSNET_54 VDD=VDD VSS=VSS
XU919 inv0d0 $PINS I=c_in[11] ZN=n928 VDD=VDD VSS=VSS
XHFSINV_378_335 inv0d1 $PINS I=c_in[12] ZN=HFSNET_55 VDD=VDD VSS=VSS
XHFSINV_127_336 inv0d1 $PINS I=c_in[13] ZN=HFSNET_56 VDD=VDD VSS=VSS
XU922 inv0d0 $PINS I=c_in[14] ZN=n925 VDD=VDD VSS=VSS
XHFSINV_361_337 inv0d1 $PINS I=c_in[15] ZN=HFSNET_57 VDD=VDD VSS=VSS
XHFSINV_127_338 inv0d1 $PINS I=copt_net_2268 ZN=HFSNET_58 VDD=VDD VSS=VSS
XU925 inv0d0 $PINS I=c_in[17] ZN=n922 VDD=VDD VSS=VSS
Xcopt_h_inst_3702 dl02d1 $PINS I=c_dst[382] Z=copt_net_870 VDD=VDD VSS=VSS
XHFSINV_357_343 inv0d1 $PINS I=c_in[19] ZN=HFSNET_63 VDD=VDD VSS=VSS
XU928 inv0d0 $PINS I=c_in[20] ZN=n919 VDD=VDD VSS=VSS
XU929 inv0d0 $PINS I=c_in[21] ZN=n918 VDD=VDD VSS=VSS
XU930 inv0d0 $PINS I=c_in[22] ZN=n917 VDD=VDD VSS=VSS
XHFSINV_293_345 inv0d1 $PINS I=c_in[23] ZN=HFSNET_65 VDD=VDD VSS=VSS
XU932 inv0d0 $PINS I=copt_net_1663 ZN=n915 VDD=VDD VSS=VSS
XHFSINV_123_346 inv0d1 $PINS I=c_in[25] ZN=HFSNET_66 VDD=VDD VSS=VSS
XHFSINV_302_347 inv0d1 $PINS I=c_in[26] ZN=HFSNET_67 VDD=VDD VSS=VSS
XHFSINV_351_348 inv0d1 $PINS I=copt_net_2243 ZN=HFSNET_68 VDD=VDD VSS=VSS
XHFSINV_123_349 inv0d1 $PINS I=c_in[28] ZN=HFSNET_69 VDD=VDD VSS=VSS
XHFSINV_296_350 inv0d1 $PINS I=c_in[29] ZN=HFSNET_70 VDD=VDD VSS=VSS
XHFSINV_310_351 inv0d1 $PINS I=copt_net_2525 ZN=HFSNET_71 VDD=VDD VSS=VSS
XHFSINV_88_327 inv0d0 $PINS I=c_in[31] ZN=HFSNET_47 VDD=VDD VSS=VSS
XHFSINV_141_355 inv0d1 $PINS I=c_in[32] ZN=HFSNET_75 VDD=VDD VSS=VSS
XU941 inv0d0 $PINS I=c_in[33] ZN=n906 VDD=VDD VSS=VSS
XHFSINV_343_375 inv0d1 $PINS I=copt_net_2306 ZN=HFSNET_95 VDD=VDD VSS=VSS
Xcopt_h_inst_3704 dl02d1 $PINS I=c_dst[276] Z=copt_net_872 VDD=VDD VSS=VSS
XHFSINV_357_378 inv0d1 $PINS I=c_in[36] ZN=HFSNET_98 VDD=VDD VSS=VSS
XU945 inv0d0 $PINS I=c_in[37] ZN=n902 VDD=VDD VSS=VSS
XU946 inv0d0 $PINS I=c_in[38] ZN=n901 VDD=VDD VSS=VSS
XHFSINV_121_379 inv0d1 $PINS I=copt_net_2827 ZN=HFSNET_99 VDD=VDD VSS=VSS
XHFSINV_401_380 inv0d0 $PINS I=c_in[40] ZN=HFSNET_100 VDD=VDD VSS=VSS
XHFSINV_358_381 inv0d1 $PINS I=c_in[41] ZN=HFSNET_101 VDD=VDD VSS=VSS
XHFSINV_186_356 inv0d0 $PINS I=c_in[42] ZN=HFSNET_76 VDD=VDD VSS=VSS
XHFSINV_359_357 inv0d0 $PINS I=c_in[43] ZN=HFSNET_77 VDD=VDD VSS=VSS
XHFSINV_288_358 inv0d1 $PINS I=c_in[44] ZN=HFSNET_78 VDD=VDD VSS=VSS
XHFSINV_125_359 inv0d0 $PINS I=c_in[45] ZN=HFSNET_79 VDD=VDD VSS=VSS
XHFSINV_271_360 inv0d1 $PINS I=c_in[46] ZN=HFSNET_80 VDD=VDD VSS=VSS
XHFSINV_119_361 inv0d1 $PINS I=c_in[47] ZN=HFSNET_81 VDD=VDD VSS=VSS
XHFSINV_343_362 inv0d1 $PINS I=copt_net_2342 ZN=HFSNET_82 VDD=VDD VSS=VSS
XHFSINV_337_363 inv0d0 $PINS I=copt_net_239 ZN=HFSNET_83 VDD=VDD VSS=VSS
XHFSINV_390_364 inv0d1 $PINS I=copt_net_390 ZN=HFSNET_84 VDD=VDD VSS=VSS
XHFSINV_399_365 inv0d1 $PINS I=copt_net_2336 ZN=HFSNET_85 VDD=VDD VSS=VSS
XHFSINV_96_366 inv0d1 $PINS I=copt_net_1223 ZN=HFSNET_86 VDD=VDD VSS=VSS
XHFSINV_313_367 inv0d1 $PINS I=c_in[53] ZN=HFSNET_87 VDD=VDD VSS=VSS
XHFSINV_132_368 inv0d1 $PINS I=c_in[54] ZN=HFSNET_88 VDD=VDD VSS=VSS
XHFSINV_128_369 inv0d0 $PINS I=copt_net_2406 ZN=HFSNET_89 VDD=VDD VSS=VSS
XHFSINV_128_370 inv0d0 $PINS I=copt_net_2322 ZN=HFSNET_90 VDD=VDD VSS=VSS
XHFSINV_137_371 inv0d1 $PINS I=copt_net_692 ZN=HFSNET_91 VDD=VDD VSS=VSS
XHFSINV_120_372 inv0d1 $PINS I=c_in[58] ZN=HFSNET_92 VDD=VDD VSS=VSS
XHFSINV_133_373 inv0d1 $PINS I=c_in[59] ZN=HFSNET_93 VDD=VDD VSS=VSS
XHFSINV_136_374 inv0d1 $PINS I=c_in[60] ZN=HFSNET_94 VDD=VDD VSS=VSS
XU969 inv0d0 $PINS I=copt_net_2172 ZN=n878 VDD=VDD VSS=VSS
XHFSINV_277_376 inv0d1 $PINS I=c_in[62] ZN=HFSNET_96 VDD=VDD VSS=VSS
XHFSINV_373_377 inv0d1 $PINS I=c_in[63] ZN=HFSNET_97 VDD=VDD VSS=VSS
XHFSINV_130_382 inv0d1 $PINS I=c_in[64] ZN=HFSNET_102 VDD=VDD VSS=VSS
XU973 inv0d0 $PINS I=copt_net_2286 ZN=n874 VDD=VDD VSS=VSS
XHFSINV_125_398 inv0d0 $PINS I=c_in[66] ZN=HFSNET_118 VDD=VDD VSS=VSS
XHFSINV_131_401 inv0d1 $PINS I=c_in[67] ZN=HFSNET_121 VDD=VDD VSS=VSS
XHFSINV_385_402 inv0d1 $PINS I=c_in[68] ZN=HFSNET_122 VDD=VDD VSS=VSS
XU977 inv0d0 $PINS I=c_in[69] ZN=n870 VDD=VDD VSS=VSS
XHFSINV_112_403 inv0d0 $PINS I=c_in[70] ZN=HFSNET_123 VDD=VDD VSS=VSS
XHFSINV_393_404 inv0d1 $PINS I=c_in[71] ZN=HFSNET_124 VDD=VDD VSS=VSS
XHFSINV_163_331 inv0d1 $PINS I=copt_net_2332 ZN=HFSNET_51 VDD=VDD VSS=VSS
XHFSINV_201_332 inv0d1 $PINS I=copt_net_2284 ZN=HFSNET_52 VDD=VDD VSS=VSS
XHFSINV_334_383 inv0d1 $PINS I=c_in[74] ZN=HFSNET_103 VDD=VDD VSS=VSS
XHFSINV_136_384 inv0d1 $PINS I=c_in[75] ZN=HFSNET_104 VDD=VDD VSS=VSS
XU984 inv0d0 $PINS I=copt_net_2323 ZN=n863 VDD=VDD VSS=VSS
XHFSINV_287_385 inv0d1 $PINS I=c_in[77] ZN=HFSNET_105 VDD=VDD VSS=VSS
XHFSINV_135_386 inv0d1 $PINS I=c_in[78] ZN=HFSNET_106 VDD=VDD VSS=VSS
XHFSINV_136_387 inv0d0 $PINS I=c_in[79] ZN=HFSNET_107 VDD=VDD VSS=VSS
XHFSINV_132_388 inv0d0 $PINS I=c_in[80] ZN=HFSNET_108 VDD=VDD VSS=VSS
XHFSINV_128_389 inv0d1 $PINS I=c_in[81] ZN=HFSNET_109 VDD=VDD VSS=VSS
XHFSINV_238_390 inv0d1 $PINS I=c_in[82] ZN=HFSNET_110 VDD=VDD VSS=VSS
XHFSINV_274_391 inv0d1 $PINS I=c_in[83] ZN=HFSNET_111 VDD=VDD VSS=VSS
XHFSINV_124_392 inv0d1 $PINS I=c_in[84] ZN=HFSNET_112 VDD=VDD VSS=VSS
XHFSINV_386_393 inv0d1 $PINS I=c_in[85] ZN=HFSNET_113 VDD=VDD VSS=VSS
XHFSINV_321_394 inv0d1 $PINS I=c_in[86] ZN=HFSNET_114 VDD=VDD VSS=VSS
XU995 inv0d0 $PINS I=c_in[87] ZN=n852 VDD=VDD VSS=VSS
XHFSINV_123_395 inv0d0 $PINS I=c_in[88] ZN=HFSNET_115 VDD=VDD VSS=VSS
XU997 inv0d0 $PINS I=c_in[89] ZN=n850 VDD=VDD VSS=VSS
XHFSINV_119_396 inv0d1 $PINS I=copt_net_2259 ZN=HFSNET_116 VDD=VDD VSS=VSS
XHFSINV_128_397 inv0d1 $PINS I=copt_net_2298 ZN=HFSNET_117 VDD=VDD VSS=VSS
XU1000 inv0d0 $PINS I=c_in[92] ZN=n210 VDD=VDD VSS=VSS
XU1001 inv0d1 $PINS I=copt_net_2639 ZN=n209 VDD=VDD VSS=VSS
XHFSINV_341_399 inv0d1 $PINS I=copt_net_2313 ZN=HFSNET_119 VDD=VDD VSS=VSS
XHFSINV_313_400 inv0d1 $PINS I=c_in[95] ZN=HFSNET_120 VDD=VDD VSS=VSS
Xcopt_h_inst_3707 dl02d1 $PINS I=c_dst[345] Z=copt_net_875 VDD=VDD VSS=VSS
Xcopt_h_inst_3709 dl02d1 $PINS I=c_dst[145] Z=copt_net_877 VDD=VDD VSS=VSS
Xcopt_h_inst_3713 dl02d1 $PINS I=c_dst[277] Z=copt_net_881 VDD=VDD VSS=VSS
Xcopt_h_inst_3716 dl02d1 $PINS I=c_dst[454] Z=copt_net_884 VDD=VDD VSS=VSS
Xcopt_h_inst_3718 dl02d1 $PINS I=c_dst[129] Z=copt_net_886 VDD=VDD VSS=VSS
XHFSINV_11_300 inv0d0 $PINS I=src_a[12] ZN=HFSNET_24 VDD=VDD VSS=VSS
XHFSINV_11_301 inv0d0 $PINS I=src_a[14] ZN=HFSNET_25 VDD=VDD VSS=VSS
XHFSINV_11_302 inv0d0 $PINS I=src_a[16] ZN=HFSNET_26 VDD=VDD VSS=VSS
XHFSINV_11_303 inv0d0 $PINS I=src_a[18] ZN=HFSNET_27 VDD=VDD VSS=VSS
XHFSINV_11_304 inv0d0 $PINS I=src_b[14] ZN=HFSNET_28 VDD=VDD VSS=VSS
XHFSINV_4_305 inv0d0 $PINS I=src_b[16] ZN=HFSNET_29 VDD=VDD VSS=VSS
Xropt_mt_inst_5860 buffd1 $PINS I=n168 Z=ropt_net_3204 VDD=VDD VSS=VSS
XHFSINV_4_307 inv0d0 $PINS I=src_b[20] ZN=HFSNET_31 VDD=VDD VSS=VSS
XHFSINV_4_308 inv0d0 $PINS I=src_b[22] ZN=HFSNET_32 VDD=VDD VSS=VSS
Xcopt_h_inst_3720 dl02d1 $PINS I=c_dst[365] Z=copt_net_888 VDD=VDD VSS=VSS
Xcopt_h_inst_3733 dl02d1 $PINS I=c_dst[278] Z=copt_net_901 VDD=VDD VSS=VSS
Xcopt_h_inst_3734 dl02d1 $PINS I=c_dst[198] Z=copt_net_902 VDD=VDD VSS=VSS
Xcopt_h_inst_3748 dl02d1 $PINS I=c_dst[405] Z=copt_net_916 VDD=VDD VSS=VSS
Xcopt_h_inst_3751 dl02d1 $PINS I=c_dst[70] Z=copt_net_919 VDD=VDD VSS=VSS
Xcopt_h_inst_3759 dl02d1 $PINS I=c_dst[288] Z=copt_net_927 VDD=VDD VSS=VSS
Xcopt_h_inst_3767 dl02d1 $PINS I=c_dst[444] Z=copt_net_935 VDD=VDD VSS=VSS
Xcopt_h_inst_3773 dl02d1 $PINS I=c_dst[189] Z=copt_net_941 VDD=VDD VSS=VSS
Xcopt_h_inst_3779 dl02d1 $PINS I=c_dst[418] Z=copt_net_947 VDD=VDD VSS=VSS
Xcopt_h_inst_3781 dl02d1 $PINS I=c_dst[377] Z=copt_net_949 VDD=VDD VSS=VSS
Xcopt_h_inst_3783 dl02d1 $PINS I=c_dst[4] Z=copt_net_951 VDD=VDD VSS=VSS
Xcopt_h_inst_3786 dl02d1 $PINS I=c_dst[172] Z=copt_net_954 VDD=VDD VSS=VSS
Xcopt_h_inst_3787 dl02d1 $PINS I=c_dst[398] Z=copt_net_955 VDD=VDD VSS=VSS
Xropt_h_inst_5861 dl01d1 $PINS I=n329 Z=ropt_net_3205 VDD=VDD VSS=VSS
Xcopt_h_inst_3794 dl02d1 $PINS I=c_dst[303] Z=copt_net_962 VDD=VDD VSS=VSS
Xcopt_h_inst_3803 dl02d1 $PINS I=dest_c[4] Z=copt_net_971 VDD=VDD VSS=VSS
Xcopt_h_inst_3806 dl02d1 $PINS I=c_dst[22] Z=copt_net_974 VDD=VDD VSS=VSS
Xcopt_h_inst_3807 dl02d1 $PINS I=c_dst[234] Z=copt_net_975 VDD=VDD VSS=VSS
Xcopt_h_inst_3815 dl02d1 $PINS I=c_dst[404] Z=copt_net_983 VDD=VDD VSS=VSS
Xcopt_h_inst_3817 dl02d1 $PINS I=c_dst[286] Z=copt_net_985 VDD=VDD VSS=VSS
Xcopt_h_inst_3819 dl02d1 $PINS I=c_dst[245] Z=copt_net_987 VDD=VDD VSS=VSS
Xcopt_h_inst_3821 dl02d1 $PINS I=c_dst[381] Z=copt_net_989 VDD=VDD VSS=VSS
Xcopt_h_inst_3822 dl02d1 $PINS I=c_dst[93] Z=copt_net_990 VDD=VDD VSS=VSS
Xcopt_h_inst_3828 dl02d1 $PINS I=c_dst[142] Z=copt_net_996 VDD=VDD VSS=VSS
Xcopt_h_inst_3830 dl02d1 $PINS I=c_dst[330] Z=copt_net_998 VDD=VDD VSS=VSS
Xcopt_h_inst_3832 dl02d1 $PINS I=c_dst[104] Z=copt_net_1000 VDD=VDD VSS=VSS
Xcopt_h_inst_3833 dl02d1 $PINS I=c_dst[491] Z=copt_net_1001 VDD=VDD VSS=VSS
Xcopt_h_inst_3836 dl02d1 $PINS I=c_dst[61] Z=copt_net_1004 VDD=VDD VSS=VSS
Xcopt_h_inst_3837 dl02d1 $PINS I=c_dst[106] Z=copt_net_1005 VDD=VDD VSS=VSS
Xcopt_h_inst_3839 dl02d1 $PINS I=c_dst[456] Z=copt_net_1007 VDD=VDD VSS=VSS
Xcopt_h_inst_3842 dl02d1 $PINS I=c_dst[501] Z=copt_net_1010 VDD=VDD VSS=VSS
Xcopt_h_inst_3843 dl02d1 $PINS I=src_b_lat[6] Z=copt_net_1011 VDD=VDD VSS=VSS
Xcopt_h_inst_3848 dl02d1 $PINS I=c_dst[417] Z=copt_net_1016 VDD=VDD VSS=VSS
Xcopt_h_inst_3849 dl02d1 $PINS I=c_dst[270] Z=copt_net_1017 VDD=VDD VSS=VSS
Xcopt_h_inst_3852 dl02d1 $PINS I=c_dst[476] Z=copt_net_1020 VDD=VDD VSS=VSS
Xcopt_h_inst_3854 dl02d1 $PINS I=c_dst[199] Z=copt_net_1022 VDD=VDD VSS=VSS
Xcopt_h_inst_3855 dl02d1 $PINS I=c_dst[443] Z=copt_net_1023 VDD=VDD VSS=VSS
Xcopt_h_inst_3858 dl02d1 $PINS I=c_dst[256] Z=copt_net_1026 VDD=VDD VSS=VSS
Xcopt_h_inst_3862 dl02d1 $PINS I=c_dst[316] Z=copt_net_1030 VDD=VDD VSS=VSS
Xcopt_h_inst_3865 dl02d1 $PINS I=c_dst[249] Z=copt_net_1033 VDD=VDD VSS=VSS
Xcopt_h_inst_3866 dl02d1 $PINS I=c_dst[284] Z=copt_net_1034 VDD=VDD VSS=VSS
Xcopt_h_inst_3867 dl02d1 $PINS I=c_dst[107] Z=copt_net_1035 VDD=VDD VSS=VSS
Xcopt_h_inst_3869 dl02d1 $PINS I=c_dst[315] Z=copt_net_1037 VDD=VDD VSS=VSS
Xcopt_h_inst_3873 dl02d1 $PINS I=c_dst[384] Z=copt_net_1041 VDD=VDD VSS=VSS
Xcopt_h_inst_3874 dl02d1 $PINS I=c_dst[65] Z=copt_net_1042 VDD=VDD VSS=VSS
Xcopt_h_inst_3875 dl02d1 $PINS I=c_dst[203] Z=copt_net_1043 VDD=VDD VSS=VSS
Xcopt_h_inst_3876 dl02d1 $PINS I=c_dst[24] Z=copt_net_1044 VDD=VDD VSS=VSS
Xcopt_h_inst_3877 dl02d1 $PINS I=c_dst[445] Z=copt_net_1045 VDD=VDD VSS=VSS
Xcopt_h_inst_3879 dl02d1 $PINS I=job_k[0] Z=copt_net_1047 VDD=VDD VSS=VSS
Xcopt_h_inst_3882 dl02d1 $PINS I=c_dst[267] Z=copt_net_1050 VDD=VDD VSS=VSS
Xcopt_h_inst_3884 dl02d1 $PINS I=c_dst[416] Z=copt_net_1052 VDD=VDD VSS=VSS
Xcopt_h_inst_3885 dl02d1 $PINS I=c_dst[99] Z=copt_net_1053 VDD=VDD VSS=VSS
Xcopt_h_inst_3887 dl02d1 $PINS I=c_dst[409] Z=copt_net_1055 VDD=VDD VSS=VSS
Xcopt_h_inst_3889 dl02d1 $PINS I=c_dst[271] Z=copt_net_1057 VDD=VDD VSS=VSS
Xcopt_h_inst_3890 dl02d1 $PINS I=c_dst[165] Z=copt_net_1058 VDD=VDD VSS=VSS
Xcopt_h_inst_3891 dl02d1 $PINS I=c_dst[160] Z=copt_net_1059 VDD=VDD VSS=VSS
Xcopt_h_inst_3894 dl02d1 $PINS I=c_dst[14] Z=copt_net_1062 VDD=VDD VSS=VSS
Xcopt_h_inst_3895 dl02d1 $PINS I=error_code[0] Z=copt_net_1063 VDD=VDD VSS=VSS
Xcopt_h_inst_3896 dl02d1 $PINS I=c_dst[509] Z=copt_net_1064 VDD=VDD VSS=VSS
Xcopt_h_inst_3897 dl02d1 $PINS I=c_dst[395] Z=copt_net_1065 VDD=VDD VSS=VSS
Xcopt_h_inst_3898 dl02d1 $PINS I=c_dst[143] Z=copt_net_1066 VDD=VDD VSS=VSS
Xcopt_h_inst_3899 dl02d1 $PINS I=c_dst[290] Z=copt_net_1067 VDD=VDD VSS=VSS
Xcopt_h_inst_3901 dl02d1 $PINS I=c_dst[169] Z=copt_net_1069 VDD=VDD VSS=VSS
Xcopt_h_inst_3902 dl02d1 $PINS I=c_dst[421] Z=copt_net_1070 VDD=VDD VSS=VSS
Xcopt_h_inst_3903 dl02d1 $PINS I=c_dst[158] Z=copt_net_1071 VDD=VDD VSS=VSS
Xcopt_h_inst_3909 dl02d1 $PINS I=c_dst[321] Z=copt_net_1077 VDD=VDD VSS=VSS
Xcopt_h_inst_3910 dl02d1 $PINS I=c_dst[30] Z=copt_net_1078 VDD=VDD VSS=VSS
Xcopt_h_inst_3911 dl02d1 $PINS I=c_dst[432] Z=copt_net_1079 VDD=VDD VSS=VSS
Xcopt_h_inst_3916 dl02d1 $PINS I=c_dst[139] Z=copt_net_1084 VDD=VDD VSS=VSS
Xcopt_h_inst_3920 dl02d1 $PINS I=c_dst[285] Z=copt_net_1088 VDD=VDD VSS=VSS
Xcopt_h_inst_3921 dl02d1 $PINS I=c_dst[219] Z=copt_net_1089 VDD=VDD VSS=VSS
Xcopt_h_inst_3923 dl02d1 $PINS I=c_dst[204] Z=copt_net_1091 VDD=VDD VSS=VSS
Xcopt_h_inst_3924 dl02d1 $PINS I=src_b_lat[10] Z=copt_net_1092 VDD=VDD VSS=VSS
Xcopt_h_inst_3925 dl02d1 $PINS I=c_dst[293] Z=copt_net_1093 VDD=VDD VSS=VSS
Xcopt_h_inst_3926 dl02d1 $PINS I=c_dst[257] Z=copt_net_1094 VDD=VDD VSS=VSS
Xcopt_h_inst_3927 dl02d1 $PINS I=c_dst[399] Z=copt_net_1095 VDD=VDD VSS=VSS
Xcopt_h_inst_3930 dl02d1 $PINS I=c_dst[304] Z=copt_net_1098 VDD=VDD VSS=VSS
Xcopt_h_inst_3931 dl02d1 $PINS I=c_dst[15] Z=copt_net_1099 VDD=VDD VSS=VSS
Xcopt_h_inst_3932 dl01d1 $PINS I=c_dst[261] Z=copt_net_1100 VDD=VDD VSS=VSS
Xcopt_h_inst_3933 dl02d1 $PINS I=c_dst[133] Z=copt_net_1101 VDD=VDD VSS=VSS
Xcopt_h_inst_3936 dl02d1 $PINS I=c_dst[449] Z=copt_net_1104 VDD=VDD VSS=VSS
Xcopt_h_inst_3937 dl02d1 $PINS I=c_dst[37] Z=copt_net_1105 VDD=VDD VSS=VSS
Xcopt_h_inst_3938 dl02d1 $PINS I=c_dst[496] Z=copt_net_1106 VDD=VDD VSS=VSS
Xcopt_h_inst_3939 dl01d1 $PINS I=c_dst[414] Z=copt_net_1107 VDD=VDD VSS=VSS
Xcopt_h_inst_3940 dl02d1 $PINS I=c_dst[475] Z=copt_net_1108 VDD=VDD VSS=VSS
Xcopt_h_inst_3946 dl02d1 $PINS I=c_dst[473] Z=copt_net_1114 VDD=VDD VSS=VSS
Xcopt_h_inst_3951 dl02d1 $PINS I=c_dst[210] Z=copt_net_1119 VDD=VDD VSS=VSS
Xcopt_h_inst_3952 dl02d1 $PINS I=c_dst[161] Z=copt_net_1120 VDD=VDD VSS=VSS
Xcopt_h_inst_3953 dl02d1 $PINS I=c_dst[420] Z=copt_net_1121 VDD=VDD VSS=VSS
Xcopt_h_inst_3956 dl02d1 $PINS I=c_dst[431] Z=copt_net_1124 VDD=VDD VSS=VSS
Xcopt_h_inst_3959 dl02d1 $PINS I=c_dst[428] Z=copt_net_1127 VDD=VDD VSS=VSS
Xcopt_h_inst_3962 dl02d1 $PINS I=src_a_lat[31] Z=copt_net_1130 VDD=VDD VSS=VSS
Xcopt_h_inst_3963 dl02d1 $PINS I=c_dst[465] Z=copt_net_1131 VDD=VDD VSS=VSS
Xcopt_h_inst_3964 dl02d1 $PINS I=c_dst[415] Z=copt_net_1132 VDD=VDD VSS=VSS
Xcopt_h_inst_3965 dl02d1 $PINS I=src_a_lat[6] Z=copt_net_1133 VDD=VDD VSS=VSS
Xcopt_h_inst_3966 dl02d1 $PINS I=c_dst[348] Z=copt_net_1134 VDD=VDD VSS=VSS
Xcopt_h_inst_3967 dl02d1 $PINS I=c_dst[76] Z=copt_net_1135 VDD=VDD VSS=VSS
Xcopt_h_inst_3968 dl02d1 $PINS I=c_dst[292] Z=copt_net_1136 VDD=VDD VSS=VSS
Xcopt_h_inst_3970 dl02d1 $PINS I=c_dst[460] Z=copt_net_1138 VDD=VDD VSS=VSS
Xcopt_h_inst_3971 dl02d1 $PINS I=c_dst[11] Z=copt_net_1139 VDD=VDD VSS=VSS
Xcopt_h_inst_3972 dl02d1 $PINS I=c_dst[385] Z=copt_net_1140 VDD=VDD VSS=VSS
Xcopt_h_inst_3973 dl02d1 $PINS I=c_dst[176] Z=copt_net_1141 VDD=VDD VSS=VSS
Xcopt_h_inst_3976 dl02d1 $PINS I=c_dst[69] Z=copt_net_1144 VDD=VDD VSS=VSS
Xcopt_h_inst_3978 dl02d1 $PINS I=c_dst[397] Z=copt_net_1146 VDD=VDD VSS=VSS
Xcopt_h_inst_3979 dl02d1 $PINS I=c_dst[246] Z=copt_net_1147 VDD=VDD VSS=VSS
Xcopt_h_inst_3980 dl02d1 $PINS I=c_dst[253] Z=copt_net_1148 VDD=VDD VSS=VSS
Xcopt_h_inst_3981 dl02d1 $PINS I=c_dst[479] Z=copt_net_1149 VDD=VDD VSS=VSS
Xcopt_h_inst_3982 dl02d1 $PINS I=c_dst[241] Z=copt_net_1150 VDD=VDD VSS=VSS
Xcopt_h_inst_3983 dl02d1 $PINS I=c_dst[264] Z=copt_net_1151 VDD=VDD VSS=VSS
Xcopt_h_inst_3984 dl02d1 $PINS I=c_dst[474] Z=copt_net_1152 VDD=VDD VSS=VSS
Xcopt_h_inst_3985 dl02d1 $PINS I=c_dst[48] Z=copt_net_1153 VDD=VDD VSS=VSS
Xcopt_h_inst_3989 dl02d1 $PINS I=c_dst[407] Z=copt_net_1157 VDD=VDD VSS=VSS
Xcopt_h_inst_3991 dl02d1 $PINS I=c_dst[429] Z=copt_net_1159 VDD=VDD VSS=VSS
Xcopt_h_inst_3992 dl02d1 $PINS I=c_dst[369] Z=copt_net_1160 VDD=VDD VSS=VSS
Xcopt_h_inst_3996 dl02d1 $PINS I=c_dst[136] Z=copt_net_1164 VDD=VDD VSS=VSS
Xcopt_h_inst_3997 dl02d1 $PINS I=c_dst[164] Z=copt_net_1165 VDD=VDD VSS=VSS
Xcopt_h_inst_3998 dl02d1 $PINS I=c_dst[368] Z=copt_net_1166 VDD=VDD VSS=VSS
Xcopt_h_inst_3999 dl02d1 $PINS I=c_dst[92] Z=copt_net_1167 VDD=VDD VSS=VSS
Xcopt_h_inst_4000 dl02d1 $PINS I=c_dst[1] Z=copt_net_1168 VDD=VDD VSS=VSS
Xcopt_h_inst_4001 dl02d1 $PINS I=c_dst[351] Z=copt_net_1169 VDD=VDD VSS=VSS
Xcopt_h_inst_4004 dl02d1 $PINS I=c_dst[191] Z=copt_net_1172 VDD=VDD VSS=VSS
Xcopt_h_inst_4007 dl02d1 $PINS I=c_dst[121] Z=copt_net_1175 VDD=VDD VSS=VSS
Xcopt_h_inst_4008 dl02d1 $PINS I=c_dst[269] Z=copt_net_1176 VDD=VDD VSS=VSS
Xcopt_h_inst_4011 dl02d1 $PINS I=c_dst[45] Z=copt_net_1179 VDD=VDD VSS=VSS
Xcopt_h_inst_4012 dl02d1 $PINS I=c_dst[279] Z=copt_net_1180 VDD=VDD VSS=VSS
Xcopt_h_inst_4014 dl02d1 $PINS I=c_dst[237] Z=copt_net_1182 VDD=VDD VSS=VSS
Xcopt_h_inst_4015 dl01d1 $PINS I=c_dst[390] Z=copt_net_1183 VDD=VDD VSS=VSS
Xcopt_h_inst_4016 dl02d1 $PINS I=c_dst[493] Z=copt_net_1184 VDD=VDD VSS=VSS
Xcopt_h_inst_4019 dl02d1 $PINS I=c_dst[492] Z=copt_net_1187 VDD=VDD VSS=VSS
Xcopt_h_inst_4022 dl02d1 $PINS I=c_dst[108] Z=copt_net_1190 VDD=VDD VSS=VSS
Xcopt_h_inst_4025 dl02d1 $PINS I=c_dst[173] Z=copt_net_1193 VDD=VDD VSS=VSS
Xcopt_h_inst_4026 dl02d1 $PINS I=c_dst[112] Z=copt_net_1194 VDD=VDD VSS=VSS
Xcopt_h_inst_4027 dl02d1 $PINS I=c_dst[470] Z=copt_net_1195 VDD=VDD VSS=VSS
Xcopt_h_inst_4028 dl02d1 $PINS I=c_dst[63] Z=copt_net_1196 VDD=VDD VSS=VSS
Xcopt_h_inst_4030 dl02d1 $PINS I=c_dst[33] Z=copt_net_1198 VDD=VDD VSS=VSS
Xcopt_h_inst_4031 dl02d1 $PINS I=c_dst[8] Z=copt_net_1199 VDD=VDD VSS=VSS
Xcopt_h_inst_4034 dl02d1 $PINS I=c_dst[340] Z=copt_net_1202 VDD=VDD VSS=VSS
Xcopt_h_inst_4035 dl02d1 $PINS I=dest_c_lat[16] Z=copt_net_1203 VDD=VDD VSS=VSS
Xcopt_h_inst_4037 dl02d1 $PINS I=c_dst[212] Z=copt_net_1205 VDD=VDD VSS=VSS
Xcopt_h_inst_4039 dl02d1 $PINS I=c_dst[23] Z=copt_net_1207 VDD=VDD VSS=VSS
Xcopt_h_inst_4042 dl02d1 $PINS I=c_dst[274] Z=copt_net_1210 VDD=VDD VSS=VSS
Xcopt_h_inst_4045 dl02d1 $PINS I=c_dst[32] Z=copt_net_1213 VDD=VDD VSS=VSS
Xcopt_h_inst_4046 dl02d1 $PINS I=c_dst[392] Z=copt_net_1214 VDD=VDD VSS=VSS
Xcopt_h_inst_4047 dl02d1 $PINS I=c_dst[102] Z=copt_net_1215 VDD=VDD VSS=VSS
Xcopt_h_inst_4048 dl02d1 $PINS I=c_dst[151] Z=copt_net_1216 VDD=VDD VSS=VSS
Xcopt_h_inst_4052 dl02d1 $PINS I=c_dst[502] Z=copt_net_1220 VDD=VDD VSS=VSS
Xcopt_h_inst_4054 dl02d1 $PINS I=c_dst[453] Z=copt_net_1222 VDD=VDD VSS=VSS
Xcopt_h_inst_4055 dl02d1 $PINS I=c_in[52] Z=copt_net_1223 VDD=VDD VSS=VSS
Xcopt_h_inst_4067 dl02d1 $PINS I=c_dst[43] Z=copt_net_1235 VDD=VDD VSS=VSS
Xcopt_h_inst_4071 dl02d1 $PINS I=c_dst[44] Z=copt_net_1239 VDD=VDD VSS=VSS
Xcopt_h_inst_4072 dl02d1 $PINS I=c_dst[208] Z=copt_net_1240 VDD=VDD VSS=VSS
Xcopt_h_inst_4075 dl02d1 $PINS I=c_dst[230] Z=copt_net_1243 VDD=VDD VSS=VSS
Xcopt_h_inst_4078 dl02d1 $PINS I=c_dst[216] Z=copt_net_1246 VDD=VDD VSS=VSS
Xcopt_h_inst_4079 dl02d1 $PINS I=src_a_lat[30] Z=copt_net_1247 VDD=VDD VSS=VSS
Xcopt_h_inst_4080 dl02d1 $PINS I=src_a_lat[30] Z=copt_net_1248 VDD=VDD VSS=VSS
Xcopt_h_inst_4081 dl02d1 $PINS I=c_dst[213] Z=copt_net_1249 VDD=VDD VSS=VSS
Xcopt_h_inst_4082 dl02d1 $PINS I=c_dst[244] Z=copt_net_1250 VDD=VDD VSS=VSS
Xcopt_h_inst_4084 dl02d1 $PINS I=c_dst[328] Z=copt_net_1252 VDD=VDD VSS=VSS
Xcopt_h_inst_4094 dl02d1 $PINS I=c_dst[344] Z=copt_net_1262 VDD=VDD VSS=VSS
Xcopt_h_inst_4096 dl02d1 $PINS I=c_dst[427] Z=copt_net_1264 VDD=VDD VSS=VSS
Xcopt_h_inst_4097 dl02d1 $PINS I=src_a_lat[7] Z=copt_net_1265 VDD=VDD VSS=VSS
Xcopt_h_inst_4098 dl02d1 $PINS I=c_dst[228] Z=copt_net_1266 VDD=VDD VSS=VSS
Xcopt_h_inst_4099 dl02d1 $PINS I=c_dst[300] Z=copt_net_1267 VDD=VDD VSS=VSS
Xcopt_h_inst_4100 dl02d1 $PINS I=c_dst[329] Z=copt_net_1268 VDD=VDD VSS=VSS
Xcopt_h_inst_4102 dl02d1 $PINS I=c_dst[141] Z=copt_net_1270 VDD=VDD VSS=VSS
Xcopt_h_inst_4103 dl02d1 $PINS I=c_dst[484] Z=copt_net_1271 VDD=VDD VSS=VSS
Xcopt_h_inst_4104 dl02d1 $PINS I=c_dst[379] Z=copt_net_1272 VDD=VDD VSS=VSS
Xcopt_h_inst_4105 dl02d1 $PINS I=dest_c_lat[30] Z=copt_net_1273 VDD=VDD VSS=VSS
Xcopt_h_inst_4107 dl02d1 $PINS I=c_dst[331] Z=copt_net_1275 VDD=VDD VSS=VSS
Xcopt_h_inst_4109 dl02d1 $PINS I=c_dst[109] Z=copt_net_1277 VDD=VDD VSS=VSS
Xcopt_h_inst_4110 dl02d1 $PINS I=c_dst[299] Z=copt_net_1278 VDD=VDD VSS=VSS
Xcopt_h_inst_4113 dl02d1 $PINS I=dest_c_lat[28] Z=copt_net_1281 VDD=VDD VSS=VSS
Xcopt_h_inst_4114 dl02d1 $PINS I=c_dst[117] Z=copt_net_1282 VDD=VDD VSS=VSS
Xcopt_h_inst_4118 dl01d1 $PINS I=c_dst[325] Z=copt_net_1286 VDD=VDD VSS=VSS
Xcopt_h_inst_4119 dl02d1 $PINS I=c_dst[171] Z=copt_net_1287 VDD=VDD VSS=VSS
Xcopt_h_inst_4121 dl02d1 $PINS I=src_a_lat[3] Z=copt_net_1289 VDD=VDD VSS=VSS
Xcopt_h_inst_4127 dl02d1 $PINS I=job_n[0] Z=copt_net_1295 VDD=VDD VSS=VSS
Xcopt_h_inst_4130 dl02d1 $PINS I=c_dst[282] Z=copt_net_1298 VDD=VDD VSS=VSS
Xcopt_h_inst_4132 dl02d1 $PINS I=c_dst[202] Z=copt_net_1300 VDD=VDD VSS=VSS
Xcopt_h_inst_4135 dl01d1 $PINS I=n846 Z=copt_net_1303 VDD=VDD VSS=VSS
Xcopt_h_inst_4136 dl02d1 $PINS I=c_dst[239] Z=copt_net_1304 VDD=VDD VSS=VSS
Xcopt_h_inst_4137 dl02d1 $PINS I=c_dst[5] Z=copt_net_1305 VDD=VDD VSS=VSS
Xcopt_h_inst_4141 dl02d1 $PINS I=c_dst[186] Z=copt_net_1309 VDD=VDD VSS=VSS
Xcopt_h_inst_4142 dl02d1 $PINS I=c_dst[367] Z=copt_net_1310 VDD=VDD VSS=VSS
Xcopt_h_inst_4144 dl02d1 $PINS I=c_dst[13] Z=copt_net_1312 VDD=VDD VSS=VSS
Xcopt_h_inst_4145 dl02d1 $PINS I=c_dst[242] Z=copt_net_1313 VDD=VDD VSS=VSS
Xcopt_h_inst_4146 dl02d1 $PINS I=c_dst[372] Z=copt_net_1314 VDD=VDD VSS=VSS
Xcopt_h_inst_4149 dl02d1 $PINS I=c_dst[74] Z=copt_net_1317 VDD=VDD VSS=VSS
Xcopt_h_inst_4150 dl02d1 $PINS I=c_dst[73] Z=copt_net_1318 VDD=VDD VSS=VSS
Xcopt_h_inst_4152 dl02d1 $PINS I=c_dst[455] Z=copt_net_1320 VDD=VDD VSS=VSS
Xcopt_h_inst_4153 dl02d1 $PINS I=c_dst[72] Z=copt_net_1321 VDD=VDD VSS=VSS
Xcopt_h_inst_4154 dl02d1 $PINS I=c_dst[364] Z=copt_net_1322 VDD=VDD VSS=VSS
Xcopt_h_inst_4155 dl02d1 $PINS I=c_dst[498] Z=copt_net_1323 VDD=VDD VSS=VSS
Xcopt_h_inst_4156 dl02d1 $PINS I=c_dst[281] Z=copt_net_1324 VDD=VDD VSS=VSS
Xcopt_h_inst_4157 dl02d1 $PINS I=c_dst[231] Z=copt_net_1325 VDD=VDD VSS=VSS
Xcopt_h_inst_4162 dl02d1 $PINS I=c_dst[359] Z=copt_net_1330 VDD=VDD VSS=VSS
Xcopt_h_inst_4165 dl02d1 $PINS I=c_dst[215] Z=copt_net_1333 VDD=VDD VSS=VSS
Xcopt_h_inst_4166 dl02d1 $PINS I=c_dst[466] Z=copt_net_1334 VDD=VDD VSS=VSS
Xcopt_h_inst_4168 dl02d1 $PINS I=c_dst[494] Z=copt_net_1336 VDD=VDD VSS=VSS
Xcopt_h_inst_4171 dl02d1 $PINS I=c_dst[478] Z=copt_net_1339 VDD=VDD VSS=VSS
Xcopt_h_inst_4172 dl02d1 $PINS I=c_dst[209] Z=copt_net_1340 VDD=VDD VSS=VSS
Xcopt_h_inst_4173 dl02d1 $PINS I=c_dst[238] Z=copt_net_1341 VDD=VDD VSS=VSS
Xcopt_h_inst_4174 dl02d1 $PINS I=c_dst[350] Z=copt_net_1342 VDD=VDD VSS=VSS
Xcopt_h_inst_4177 dl02d1 $PINS I=src_a_lat[2] Z=copt_net_1345 VDD=VDD VSS=VSS
Xcopt_h_inst_4178 dl02d1 $PINS I=c_dst[458] Z=copt_net_1346 VDD=VDD VSS=VSS
Xcopt_h_inst_4179 dl02d1 $PINS I=c_dst[366] Z=copt_net_1347 VDD=VDD VSS=VSS
Xcopt_h_inst_4181 dl02d1 $PINS I=c_dst[58] Z=copt_net_1349 VDD=VDD VSS=VSS
Xcopt_h_inst_4182 dl02d1 $PINS I=c_dst[487] Z=copt_net_1350 VDD=VDD VSS=VSS
Xcopt_h_inst_4183 dl02d1 $PINS I=c_dst[457] Z=copt_net_1351 VDD=VDD VSS=VSS
Xcopt_h_inst_4184 dl02d1 $PINS I=src_a_lat[28] Z=copt_net_1352 VDD=VDD VSS=VSS
Xcopt_h_inst_4185 dl02d1 $PINS I=c_dst[327] Z=copt_net_1353 VDD=VDD VSS=VSS
Xcopt_h_inst_4186 dl02d1 $PINS I=c_dst[71] Z=copt_net_1354 VDD=VDD VSS=VSS
Xcopt_h_inst_4190 dl02d1 $PINS I=c_dst[380] Z=copt_net_1358 VDD=VDD VSS=VSS
Xcopt_h_inst_4192 dl02d1 $PINS I=c_dst[419] Z=copt_net_1360 VDD=VDD VSS=VSS
Xcopt_h_inst_4193 dl02d1 $PINS I=src_a_lat[9] Z=copt_net_1361 VDD=VDD VSS=VSS
Xcopt_h_inst_4194 dl02d1 $PINS I=c_dst[62] Z=copt_net_1362 VDD=VDD VSS=VSS
Xcopt_h_inst_4196 dl02d1 $PINS I=c_dst[120] Z=copt_net_1364 VDD=VDD VSS=VSS
Xcopt_h_inst_4198 dl02d1 $PINS I=c_dst[442] Z=copt_net_1366 VDD=VDD VSS=VSS
Xcopt_h_inst_4199 dl02d1 $PINS I=c_dst[338] Z=copt_net_1367 VDD=VDD VSS=VSS
Xcopt_h_inst_4201 dl02d1 $PINS I=c_dst[446] Z=copt_net_1369 VDD=VDD VSS=VSS
Xcopt_h_inst_4202 dl02d1 $PINS I=c_dst[110] Z=copt_net_1370 VDD=VDD VSS=VSS
Xcopt_h_inst_4203 dl02d1 $PINS I=c_dst[485] Z=copt_net_1371 VDD=VDD VSS=VSS
Xcopt_h_inst_4206 dl02d1 $PINS I=c_dst[508] Z=copt_net_1374 VDD=VDD VSS=VSS
Xcopt_h_inst_4209 dl02d1 $PINS I=src_b_lat[4] Z=copt_net_1377 VDD=VDD VSS=VSS
Xcopt_h_inst_4210 dl02d1 $PINS I=dest_c_lat[15] Z=copt_net_1378 VDD=VDD VSS=VSS
Xcopt_h_inst_4213 dl02d1 $PINS I=c_dst[320] Z=copt_net_1381 VDD=VDD VSS=VSS
Xcopt_h_inst_4214 dl02d1 $PINS I=c_dst[265] Z=copt_net_1382 VDD=VDD VSS=VSS
Xcopt_h_inst_4215 dl02d1 $PINS I=c_dst[378] Z=copt_net_1383 VDD=VDD VSS=VSS
Xcopt_h_inst_4216 dl02d1 $PINS I=c_dst[347] Z=copt_net_1384 VDD=VDD VSS=VSS
Xcopt_h_inst_4219 dl02d1 $PINS I=dest_c_lat[18] Z=copt_net_1387 VDD=VDD VSS=VSS
Xcopt_h_inst_4220 dl02d1 $PINS I=src_a_lat[11] Z=copt_net_1388 VDD=VDD VSS=VSS
Xcopt_h_inst_4221 dl02d1 $PINS I=c_dst[467] Z=copt_net_1389 VDD=VDD VSS=VSS
Xcopt_h_inst_4223 dl02d1 $PINS I=src_b_lat[7] Z=copt_net_1391 VDD=VDD VSS=VSS
Xcopt_h_inst_4224 dl02d1 $PINS I=c_dst[273] Z=copt_net_1392 VDD=VDD VSS=VSS
Xcopt_h_inst_4226 dl02d1 $PINS I=src_b_lat[15] Z=copt_net_1394 VDD=VDD VSS=VSS
Xcopt_h_inst_4227 dl02d1 $PINS I=c_dst[389] Z=copt_net_1395 VDD=VDD VSS=VSS
Xcopt_h_inst_4229 dl01d1 $PINS I=c_dst[339] Z=copt_net_1397 VDD=VDD VSS=VSS
Xcopt_h_inst_4230 dl02d1 $PINS I=src_b_lat[3] Z=copt_net_1398 VDD=VDD VSS=VSS
Xcopt_h_inst_4231 dl01d1 $PINS I=HFSNET_89 Z=copt_net_1399 VDD=VDD VSS=VSS
Xcopt_h_inst_4232 dl02d1 $PINS I=c_dst[354] Z=copt_net_1400 VDD=VDD VSS=VSS
Xcopt_h_inst_4233 dl02d1 $PINS I=src_b_lat[31] Z=copt_net_1401 VDD=VDD VSS=VSS
Xcopt_h_inst_4237 dl02d1 $PINS I=src_a_lat[12] Z=copt_net_1405 VDD=VDD VSS=VSS
Xcopt_h_inst_4242 dl02d1 $PINS I=c_dst[67] Z=copt_net_1410 VDD=VDD VSS=VSS
Xcopt_h_inst_4243 dl02d1 $PINS I=dest_c_lat[29] Z=copt_net_1411 VDD=VDD VSS=VSS
Xcopt_h_inst_4244 dl02d1 $PINS I=c_dst[393] Z=copt_net_1412 VDD=VDD VSS=VSS
Xcopt_h_inst_4245 dl02d1 $PINS I=c_dst[6] Z=copt_net_1413 VDD=VDD VSS=VSS
Xcopt_h_inst_4247 dl02d1 $PINS I=c_dst[506] Z=copt_net_1415 VDD=VDD VSS=VSS
Xcopt_h_inst_4250 dl02d1 $PINS I=aps_rename_23_ Z=job_n[2] VDD=VDD VSS=VSS
Xcopt_h_inst_4251 dl01d1 $PINS I=c_dst[482] Z=copt_net_1419 VDD=VDD VSS=VSS
Xcopt_h_inst_4252 dl02d1 $PINS I=c_dst[410] Z=copt_net_1420 VDD=VDD VSS=VSS
Xcopt_h_inst_4253 dl02d1 $PINS I=c_dst[361] Z=copt_net_1421 VDD=VDD VSS=VSS
Xcopt_h_inst_4255 dl02d1 $PINS I=c_dst[314] Z=copt_net_1423 VDD=VDD VSS=VSS
Xcopt_h_inst_4256 dl01d1 $PINS I=c_dst[333] Z=copt_net_1424 VDD=VDD VSS=VSS
Xcopt_h_inst_4257 dl02d1 $PINS I=c_dst[471] Z=copt_net_1425 VDD=VDD VSS=VSS
Xcopt_h_inst_4259 dl02d1 $PINS I=c_dst[196] Z=copt_net_1427 VDD=VDD VSS=VSS
Xcopt_h_inst_4262 dl02d1 $PINS I=c_dst[236] Z=copt_net_1430 VDD=VDD VSS=VSS
Xcopt_h_inst_4263 dl02d1 $PINS I=c_dst[268] Z=copt_net_1431 VDD=VDD VSS=VSS
Xcopt_h_inst_4265 dl02d1 $PINS I=c_dst[140] Z=copt_net_1433 VDD=VDD VSS=VSS
Xcopt_h_inst_4266 dl02d1 $PINS I=c_dst[137] Z=copt_net_1434 VDD=VDD VSS=VSS
Xcopt_h_inst_4270 dl02d1 $PINS I=c_dst[201] Z=copt_net_1438 VDD=VDD VSS=VSS
Xcopt_h_inst_4271 dl02d1 $PINS I=src_b_lat[9] Z=copt_net_1439 VDD=VDD VSS=VSS
Xcopt_h_inst_4275 dl02d1 $PINS I=c_dst[190] Z=copt_net_1443 VDD=VDD VSS=VSS
Xcopt_h_inst_4276 dl02d1 $PINS I=c_dst[342] Z=copt_net_1444 VDD=VDD VSS=VSS
Xcopt_h_inst_4278 dl02d1 $PINS I=c_dst[481] Z=copt_net_1446 VDD=VDD VSS=VSS
Xcopt_h_inst_4279 dl02d1 $PINS I=c_dst[205] Z=copt_net_1447 VDD=VDD VSS=VSS
Xcopt_h_inst_4280 dl02d1 $PINS I=c_dst[200] Z=copt_net_1448 VDD=VDD VSS=VSS
Xcopt_h_inst_4283 dl02d1 $PINS I=c_dst[77] Z=copt_net_1451 VDD=VDD VSS=VSS
Xcopt_h_inst_4285 dl02d1 $PINS I=c_dst[324] Z=copt_net_1453 VDD=VDD VSS=VSS
Xcopt_h_inst_4288 dl02d1 $PINS I=c_dst[56] Z=copt_net_1456 VDD=VDD VSS=VSS
Xcopt_h_inst_4289 dl02d1 $PINS I=c_dst[222] Z=copt_net_1457 VDD=VDD VSS=VSS
Xcopt_h_inst_4292 dl02d1 $PINS I=c_dst[412] Z=copt_net_1460 VDD=VDD VSS=VSS
Xcopt_h_inst_4293 dl02d1 $PINS I=c_dst[12] Z=copt_net_1461 VDD=VDD VSS=VSS
Xcopt_h_inst_4295 dl02d1 $PINS I=c_dst[68] Z=copt_net_1463 VDD=VDD VSS=VSS
Xcopt_h_inst_4297 dl02d1 $PINS I=src_b_lat[12] Z=copt_net_1465 VDD=VDD VSS=VSS
Xcopt_h_inst_4301 dl02d1 $PINS I=c_dst[266] Z=copt_net_1469 VDD=VDD VSS=VSS
Xcopt_h_inst_4302 dl02d1 $PINS I=c_dst[192] Z=copt_net_1470 VDD=VDD VSS=VSS
Xcopt_h_inst_4305 dl02d1 $PINS I=src_a_lat[29] Z=copt_net_1473 VDD=VDD VSS=VSS
Xcopt_h_inst_4306 dl02d1 $PINS I=c_dst[97] Z=copt_net_1474 VDD=VDD VSS=VSS
Xcopt_h_inst_4309 dl02d1 $PINS I=c_dst[452] Z=copt_net_1477 VDD=VDD VSS=VSS
Xcopt_h_inst_4313 dl02d1 $PINS I=src_a_lat[0] Z=copt_net_1481 VDD=VDD VSS=VSS
Xcopt_h_inst_4316 dl02d1 $PINS I=c_dst[157] Z=copt_net_1484 VDD=VDD VSS=VSS
Xcopt_h_inst_4317 dl02d1 $PINS I=c_dst[156] Z=copt_net_1485 VDD=VDD VSS=VSS
Xcopt_h_inst_4320 dl02d1 $PINS I=src_a_lat[22] Z=copt_net_1488 VDD=VDD VSS=VSS
Xcopt_h_inst_4321 dl02d1 $PINS I=c_dst[64] Z=copt_net_1489 VDD=VDD VSS=VSS
Xcopt_h_inst_4325 dl02d1 $PINS I=src_b_lat[29] Z=copt_net_1493 VDD=VDD VSS=VSS
Xcopt_h_inst_4327 dl02d1 $PINS I=c_dst[413] Z=copt_net_1495 VDD=VDD VSS=VSS
Xcopt_h_inst_4329 dl02d1 $PINS I=c_dst[451] Z=copt_net_1497 VDD=VDD VSS=VSS
Xcopt_h_inst_4331 dl02d1 $PINS I=c_dst[87] Z=copt_net_1499 VDD=VDD VSS=VSS
Xcopt_h_inst_4333 dl02d1 $PINS I=c_dst[425] Z=copt_net_1501 VDD=VDD VSS=VSS
Xcopt_h_inst_4336 dl02d1 $PINS I=c_dst[124] Z=copt_net_1504 VDD=VDD VSS=VSS
Xcopt_h_inst_4339 dl02d1 $PINS I=c_dst[7] Z=copt_net_1507 VDD=VDD VSS=VSS
Xcopt_h_inst_4342 dl02d1 $PINS I=c_dst[135] Z=copt_net_1510 VDD=VDD VSS=VSS
Xcopt_h_inst_4345 dl02d1 $PINS I=c_dst[480] Z=copt_net_1513 VDD=VDD VSS=VSS
Xcopt_h_inst_4349 dl02d1 $PINS I=c_dst[9] Z=copt_net_1517 VDD=VDD VSS=VSS
Xcopt_h_inst_4352 dl02d1 $PINS I=c_dst[75] Z=copt_net_1520 VDD=VDD VSS=VSS
Xcopt_h_inst_4353 dl02d1 $PINS I=c_dst[396] Z=copt_net_1521 VDD=VDD VSS=VSS
Xcopt_h_inst_4365 dl02d1 $PINS I=c_dst[430] Z=copt_net_1533 VDD=VDD VSS=VSS
Xcopt_h_inst_4367 dl02d1 $PINS I=dest_c_lat[11] Z=copt_net_1535 VDD=VDD VSS=VSS
Xcopt_h_inst_4369 dl02d1 $PINS I=c_dst[323] Z=copt_net_1537 VDD=VDD VSS=VSS
Xcopt_h_inst_4374 dl02d1 $PINS I=c_dst[489] Z=copt_net_1542 VDD=VDD VSS=VSS
Xcopt_h_inst_4377 dl02d1 $PINS I=src_a_lat[15] Z=copt_net_1545 VDD=VDD VSS=VSS
Xcopt_h_inst_4378 dl02d1 $PINS I=c_dst[318] Z=copt_net_1546 VDD=VDD VSS=VSS
Xcopt_h_inst_4379 dl02d1 $PINS I=c_dst[461] Z=copt_net_1547 VDD=VDD VSS=VSS
Xcopt_h_inst_4380 dl02d1 $PINS I=c_dst[195] Z=copt_net_1548 VDD=VDD VSS=VSS
Xcopt_h_inst_4386 dl02d1 $PINS I=c_dst[154] Z=copt_net_1554 VDD=VDD VSS=VSS
Xcopt_h_inst_4390 dl02d1 $PINS I=c_dst[302] Z=copt_net_1558 VDD=VDD VSS=VSS
Xcopt_h_inst_4391 dl02d1 $PINS I=c_dst[448] Z=copt_net_1559 VDD=VDD VSS=VSS
Xcopt_h_inst_4397 dl02d1 $PINS I=c_dst[95] Z=copt_net_1565 VDD=VDD VSS=VSS
Xcopt_h_inst_4401 dl02d1 $PINS I=c_dst[138] Z=copt_net_1569 VDD=VDD VSS=VSS
Xcopt_h_inst_4402 dl02d1 $PINS I=src_a_lat[20] Z=copt_net_1570 VDD=VDD VSS=VSS
Xcopt_h_inst_4403 dl02d1 $PINS I=c_dst[297] Z=copt_net_1571 VDD=VDD VSS=VSS
Xcopt_h_inst_4404 dl02d1 $PINS I=dest_c_lat[14] Z=copt_net_1572 VDD=VDD VSS=VSS
Xcopt_h_inst_4406 dl02d1 $PINS I=c_dst[197] Z=copt_net_1574 VDD=VDD VSS=VSS
Xcopt_h_inst_4409 dl02d1 $PINS I=c_dst[29] Z=copt_net_1577 VDD=VDD VSS=VSS
Xcopt_h_inst_4413 dl02d1 $PINS I=c_dst[263] Z=copt_net_1581 VDD=VDD VSS=VSS
Xcopt_h_inst_4418 dl02d1 $PINS I=src_b_lat[11] Z=copt_net_1586 VDD=VDD VSS=VSS
Xcopt_h_inst_4419 dl01d1 $PINS I=src_b_lat[11] Z=copt_net_1587 VDD=VDD VSS=VSS
Xcopt_h_inst_4421 dl02d1 $PINS I=c_dst[26] Z=copt_net_1589 VDD=VDD VSS=VSS
Xcopt_h_inst_4429 dl02d1 $PINS I=c_dst[174] Z=copt_net_1597 VDD=VDD VSS=VSS
Xcopt_h_inst_4442 dl02d1 $PINS I=c_dst[447] Z=copt_net_1610 VDD=VDD VSS=VSS
Xcopt_h_inst_4447 dl02d1 $PINS I=c_dst[153] Z=copt_net_1615 VDD=VDD VSS=VSS
Xcopt_h_inst_4448 dl02d1 $PINS I=c_dst[10] Z=copt_net_1616 VDD=VDD VSS=VSS
Xcopt_h_inst_4456 dl02d1 $PINS I=c_dst[391] Z=copt_net_1624 VDD=VDD VSS=VSS
Xcopt_h_inst_4457 dl02d1 $PINS I=src_b_lat[14] Z=copt_net_1625 VDD=VDD VSS=VSS
Xcopt_h_inst_4458 dl02d1 $PINS I=src_a_lat[8] Z=copt_net_1626 VDD=VDD VSS=VSS
Xcopt_h_inst_4465 dl02d1 $PINS I=c_dst[119] Z=copt_net_1633 VDD=VDD VSS=VSS
Xcopt_h_inst_4469 dl02d1 $PINS I=c_dst[162] Z=copt_net_1637 VDD=VDD VSS=VSS
Xcopt_h_inst_4471 dl02d1 $PINS I=c_dst[459] Z=copt_net_1639 VDD=VDD VSS=VSS
Xcopt_h_inst_4476 dl02d1 $PINS I=src_b_lat[16] Z=copt_net_1644 VDD=VDD VSS=VSS
Xcopt_h_inst_4480 dl02d1 $PINS I=c_dst[337] Z=copt_net_1648 VDD=VDD VSS=VSS
Xcopt_h_inst_4489 dl02d1 $PINS I=c_dst[252] Z=copt_net_1657 VDD=VDD VSS=VSS
Xcopt_h_inst_4494 dl02d1 $PINS I=dest_c_lat[22] Z=copt_net_1662 VDD=VDD VSS=VSS
Xcopt_h_inst_4495 dl02d1 $PINS I=c_in[24] Z=copt_net_1663 VDD=VDD VSS=VSS
Xcopt_h_inst_4500 dl02d1 $PINS I=dest_c_lat[17] Z=copt_net_1668 VDD=VDD VSS=VSS
Xcopt_h_inst_4502 dl02d1 $PINS I=c_dst[310] Z=copt_net_1670 VDD=VDD VSS=VSS
Xcopt_h_inst_4505 dl02d1 $PINS I=c_dst[214] Z=copt_net_1673 VDD=VDD VSS=VSS
Xcopt_h_inst_4510 dl02d1 $PINS I=c_dst[98] Z=copt_net_1678 VDD=VDD VSS=VSS
Xcopt_h_inst_4511 dl02d1 $PINS I=c_dst[394] Z=copt_net_1679 VDD=VDD VSS=VSS
Xcopt_h_inst_4512 dl02d1 $PINS I=c_dst[400] Z=copt_net_1680 VDD=VDD VSS=VSS
Xcopt_h_inst_4513 dl02d1 $PINS I=dest_c_lat[5] Z=copt_net_1681 VDD=VDD VSS=VSS
Xcopt_h_inst_4520 dl02d1 $PINS I=c_dst[411] Z=copt_net_1688 VDD=VDD VSS=VSS
Xcopt_h_inst_4526 dl02d1 $PINS I=src_a_lat[16] Z=copt_net_1694 VDD=VDD VSS=VSS
Xcopt_h_inst_4528 dl02d1 $PINS I=dest_c_lat[12] Z=copt_net_1696 VDD=VDD VSS=VSS
Xcopt_h_inst_4534 dl02d1 $PINS I=c_dst[34] Z=copt_net_1702 VDD=VDD VSS=VSS
Xcopt_h_inst_4535 dl02d1 $PINS I=dest_c_lat[21] Z=copt_net_1703 VDD=VDD VSS=VSS
Xcopt_h_inst_4538 dl02d1 $PINS I=src_a_lat[17] Z=copt_net_1706 VDD=VDD VSS=VSS
Xcopt_h_inst_4540 dl02d1 $PINS I=c_dst[168] Z=copt_net_1708 VDD=VDD VSS=VSS
Xcopt_h_inst_4542 dl02d1 $PINS I=c_dst[374] Z=copt_net_1710 VDD=VDD VSS=VSS
Xcopt_h_inst_4543 dl02d1 $PINS I=src_a_lat[4] Z=copt_net_1711 VDD=VDD VSS=VSS
Xcopt_h_inst_4544 dl02d1 $PINS I=c_dst[16] Z=copt_net_1712 VDD=VDD VSS=VSS
Xcopt_h_inst_4548 dl02d1 $PINS I=src_b_lat[26] Z=copt_net_1716 VDD=VDD VSS=VSS
Xcopt_h_inst_4549 dl02d1 $PINS I=src_b_lat[24] Z=copt_net_1717 VDD=VDD VSS=VSS
Xcopt_h_inst_4551 dl02d1 $PINS I=c_dst[144] Z=copt_net_1719 VDD=VDD VSS=VSS
Xcopt_h_inst_4564 dl02d1 $PINS I=src_b_lat[21] Z=copt_net_1732 VDD=VDD VSS=VSS
Xcopt_h_inst_4566 dl02d1 $PINS I=c_dst[225] Z=copt_net_1734 VDD=VDD VSS=VSS
Xcopt_h_inst_4567 dl02d1 $PINS I=c_dst[272] Z=copt_net_1735 VDD=VDD VSS=VSS
Xcopt_h_inst_4568 dl02d1 $PINS I=c_dst[403] Z=copt_net_1736 VDD=VDD VSS=VSS
Xcopt_h_inst_4574 dl02d1 $PINS I=c_dst[424] Z=copt_net_1742 VDD=VDD VSS=VSS
Xcopt_h_inst_4575 dl02d1 $PINS I=c_dst[19] Z=copt_net_1743 VDD=VDD VSS=VSS
Xcopt_h_inst_4577 dl02d1 $PINS I=c_dst[296] Z=copt_net_1745 VDD=VDD VSS=VSS
Xcopt_h_inst_4581 dl02d1 $PINS I=c_dst[100] Z=copt_net_1749 VDD=VDD VSS=VSS
Xcopt_h_inst_4587 dl02d1 $PINS I=src_b_lat[5] Z=copt_net_1755 VDD=VDD VSS=VSS
Xcopt_h_inst_4590 dl02d1 $PINS I=src_a_lat[26] Z=copt_net_1758 VDD=VDD VSS=VSS
Xcopt_h_inst_4602 dl02d1 $PINS I=c_dst[27] Z=copt_net_1770 VDD=VDD VSS=VSS
Xcopt_h_inst_4606 dl02d1 $PINS I=c_dst[113] Z=copt_net_1774 VDD=VDD VSS=VSS
Xcopt_h_inst_4607 dl02d1 $PINS I=c_dst[507] Z=copt_net_1775 VDD=VDD VSS=VSS
Xcopt_h_inst_4609 dl02d1 $PINS I=c_dst[167] Z=copt_net_1777 VDD=VDD VSS=VSS
Xcopt_h_inst_4610 dl02d1 $PINS I=c_dst[147] Z=copt_net_1778 VDD=VDD VSS=VSS
Xcopt_h_inst_4611 dl02d1 $PINS I=c_dst[86] Z=copt_net_1779 VDD=VDD VSS=VSS
Xcopt_h_inst_4613 dl02d1 $PINS I=dest_c_lat[23] Z=copt_net_1781 VDD=VDD VSS=VSS
Xcopt_h_inst_4614 dl02d1 $PINS I=c_dst[319] Z=copt_net_1782 VDD=VDD VSS=VSS
Xcopt_h_inst_4615 dl02d1 $PINS I=c_dst[155] Z=copt_net_1783 VDD=VDD VSS=VSS
Xcopt_h_inst_4618 dl02d1 $PINS I=c_dst[91] Z=copt_net_1786 VDD=VDD VSS=VSS
Xcopt_h_inst_4620 dl02d1 $PINS I=dest_c_lat[26] Z=copt_net_1788 VDD=VDD VSS=VSS
Xcopt_h_inst_4622 dl02d1 $PINS I=c_dst[211] Z=copt_net_1790 VDD=VDD VSS=VSS
Xcopt_h_inst_4625 dl02d1 $PINS I=dest_c_lat[10] Z=copt_net_1793 VDD=VDD VSS=VSS
Xcopt_h_inst_4626 dl02d1 $PINS I=src_a_lat[5] Z=copt_net_1794 VDD=VDD VSS=VSS
Xcopt_h_inst_4627 dl02d1 $PINS I=c_dst[352] Z=copt_net_1795 VDD=VDD VSS=VSS
Xcopt_h_inst_4631 dl02d1 $PINS I=c_dst[346] Z=copt_net_1799 VDD=VDD VSS=VSS
Xcopt_h_inst_4633 dl02d1 $PINS I=c_dst[175] Z=copt_net_1801 VDD=VDD VSS=VSS
Xcopt_gre_h_inst_5782 dl01d1 $PINS I=n918 Z=copt_gre_net_2954 VDD=VDD VSS=VSS
Xcopt_h_inst_4648 dl02d1 $PINS I=src_a_lat[21] Z=copt_net_1816 VDD=VDD VSS=VSS
Xcopt_h_inst_4649 dl02d1 $PINS I=c_dst[356] Z=copt_net_1817 VDD=VDD VSS=VSS
Xcopt_h_inst_4654 dl02d1 $PINS I=c_dst[105] Z=copt_net_1822 VDD=VDD VSS=VSS
Xcopt_h_inst_4656 dl02d1 $PINS I=c_dst[283] Z=copt_net_1824 VDD=VDD VSS=VSS
Xcopt_h_inst_4657 dl02d1 $PINS I=c_dst[247] Z=copt_net_1825 VDD=VDD VSS=VSS
Xcopt_h_inst_4658 dl02d1 $PINS I=src_b_lat[17] Z=copt_net_1826 VDD=VDD VSS=VSS
Xcopt_h_inst_4660 dl02d1 $PINS I=c_dst[353] Z=copt_net_1828 VDD=VDD VSS=VSS
Xcopt_h_inst_4661 dl02d1 $PINS I=c_dst[116] Z=copt_net_1829 VDD=VDD VSS=VSS
Xcopt_h_inst_4664 dl02d1 $PINS I=dest_c_lat[25] Z=copt_net_1832 VDD=VDD VSS=VSS
Xcopt_h_inst_4669 dl02d1 $PINS I=dest_c_lat[9] Z=copt_net_1837 VDD=VDD VSS=VSS
Xcopt_h_inst_4670 dl02d1 $PINS I=src_a_lat[23] Z=copt_net_1838 VDD=VDD VSS=VSS
Xcopt_h_inst_4672 dl02d1 $PINS I=src_a_lat[19] Z=copt_net_1840 VDD=VDD VSS=VSS
Xcopt_h_inst_4673 dl02d1 $PINS I=c_dst[94] Z=copt_net_1841 VDD=VDD VSS=VSS
Xcopt_h_inst_4680 dl02d1 $PINS I=c_dst[47] Z=copt_net_1848 VDD=VDD VSS=VSS
Xcopt_h_inst_4682 dl02d1 $PINS I=c_dst[294] Z=copt_net_1850 VDD=VDD VSS=VSS
Xcopt_h_inst_4684 dl02d1 $PINS I=dest_c_lat[24] Z=copt_net_1852 VDD=VDD VSS=VSS
Xcopt_h_inst_4686 dl02d1 $PINS I=c_dst[402] Z=copt_net_1854 VDD=VDD VSS=VSS
Xcopt_h_inst_4690 dl02d1 $PINS I=src_b_lat[22] Z=copt_net_1858 VDD=VDD VSS=VSS
Xcopt_h_inst_4691 dl02d1 $PINS I=c_dst[36] Z=copt_net_1859 VDD=VDD VSS=VSS
Xcopt_h_inst_4698 dl02d1 $PINS I=dest_c_lat[8] Z=copt_net_1866 VDD=VDD VSS=VSS
Xcopt_h_inst_4699 dl02d1 $PINS I=c_dst[275] Z=copt_net_1867 VDD=VDD VSS=VSS
Xcopt_h_inst_4700 dl02d1 $PINS I=c_dst[317] Z=copt_net_1868 VDD=VDD VSS=VSS
Xcopt_h_inst_4702 dl02d1 $PINS I=c_dst[206] Z=copt_net_1870 VDD=VDD VSS=VSS
Xcopt_h_inst_4705 dl02d1 $PINS I=c_dst[422] Z=copt_net_1873 VDD=VDD VSS=VSS
Xcopt_h_inst_4707 dl02d1 $PINS I=dest_c_lat[19] Z=copt_net_1875 VDD=VDD VSS=VSS
Xcopt_h_inst_4708 dl02d1 $PINS I=c_dst[218] Z=copt_net_1876 VDD=VDD VSS=VSS
Xcopt_h_inst_4709 dl02d1 $PINS I=src_a_lat[24] Z=copt_net_1877 VDD=VDD VSS=VSS
Xcopt_h_inst_4710 dl02d1 $PINS I=c_dst[166] Z=copt_net_1878 VDD=VDD VSS=VSS
Xcopt_h_inst_4711 dl02d1 $PINS I=c_dst[146] Z=copt_net_1879 VDD=VDD VSS=VSS
Xcopt_h_inst_4712 dl02d1 $PINS I=c_dst[251] Z=copt_net_1880 VDD=VDD VSS=VSS
Xcopt_h_inst_4715 dl02d1 $PINS I=c_dst[18] Z=copt_net_1883 VDD=VDD VSS=VSS
Xcopt_h_inst_4716 dl02d1 $PINS I=c_dst[503] Z=copt_net_1884 VDD=VDD VSS=VSS
Xcopt_h_inst_4717 dl02d1 $PINS I=c_dst[123] Z=copt_net_1885 VDD=VDD VSS=VSS
Xcopt_h_inst_4719 dl02d1 $PINS I=c_dst[226] Z=copt_net_1887 VDD=VDD VSS=VSS
Xcopt_h_inst_4720 dl02d1 $PINS I=c_dst[223] Z=copt_net_1888 VDD=VDD VSS=VSS
Xcopt_h_inst_4725 dl02d1 $PINS I=src_b_lat[25] Z=copt_net_1893 VDD=VDD VSS=VSS
Xcopt_h_inst_4726 dl02d1 $PINS I=c_dst[336] Z=copt_net_1894 VDD=VDD VSS=VSS
Xcopt_h_inst_4727 dl02d1 $PINS I=src_a_lat[25] Z=copt_net_1895 VDD=VDD VSS=VSS
Xcopt_h_inst_4728 dl02d1 $PINS I=c_dst[500] Z=copt_net_1896 VDD=VDD VSS=VSS
Xcopt_h_inst_4731 dl02d1 $PINS I=c_dst[170] Z=copt_net_1899 VDD=VDD VSS=VSS
Xcopt_h_inst_4732 dl02d1 $PINS I=src_a_lat[18] Z=copt_net_1900 VDD=VDD VSS=VSS
Xcopt_h_inst_4736 dl02d1 $PINS I=c_dst[375] Z=copt_net_1904 VDD=VDD VSS=VSS
Xcopt_h_inst_4742 dl02d1 $PINS I=c_dst[207] Z=copt_net_1910 VDD=VDD VSS=VSS
Xcopt_h_inst_4750 dl02d1 $PINS I=c_dst[111] Z=copt_net_1918 VDD=VDD VSS=VSS
Xcopt_h_inst_4751 dl02d1 $PINS I=c_dst[88] Z=copt_net_1919 VDD=VDD VSS=VSS
Xcopt_h_inst_4752 dl02d1 $PINS I=c_dst[243] Z=copt_net_1920 VDD=VDD VSS=VSS
Xcopt_h_inst_4753 dl02d1 $PINS I=src_b_lat[27] Z=copt_net_1921 VDD=VDD VSS=VSS
Xcopt_h_inst_4757 dl02d1 $PINS I=c_dst[46] Z=copt_net_1925 VDD=VDD VSS=VSS
Xcopt_h_inst_4761 dl02d1 $PINS I=c_dst[115] Z=copt_net_1929 VDD=VDD VSS=VSS
Xcopt_h_inst_4763 dl02d1 $PINS I=c_dst[298] Z=copt_net_1931 VDD=VDD VSS=VSS
Xcopt_h_inst_4765 dl02d1 $PINS I=src_a_lat[27] Z=copt_net_1933 VDD=VDD VSS=VSS
Xcopt_h_inst_4766 dl02d1 $PINS I=c_dst[90] Z=copt_net_1934 VDD=VDD VSS=VSS
Xcopt_h_inst_4767 dl02d1 $PINS I=c_dst[83] Z=copt_net_1935 VDD=VDD VSS=VSS
Xcopt_h_inst_4776 dl02d1 $PINS I=c_dst[312] Z=copt_net_1944 VDD=VDD VSS=VSS
Xcopt_h_inst_4780 dl02d1 $PINS I=src_b_lat[19] Z=copt_net_1948 VDD=VDD VSS=VSS
Xcopt_h_inst_4781 dl02d1 $PINS I=c_dst[114] Z=copt_net_1949 VDD=VDD VSS=VSS
Xcopt_h_inst_4782 dl02d1 $PINS I=c_dst[462] Z=copt_net_1950 VDD=VDD VSS=VSS
Xcopt_h_inst_4784 dl02d1 $PINS I=c_dst[233] Z=copt_net_1951 VDD=VDD VSS=VSS
Xcopt_h_inst_4785 dl02d1 $PINS I=c_dst[224] Z=copt_net_1952 VDD=VDD VSS=VSS
Xcopt_h_inst_4786 dl02d1 $PINS I=c_dst[81] Z=copt_net_1953 VDD=VDD VSS=VSS
Xcopt_h_inst_4788 dl02d1 $PINS I=c_dst[472] Z=copt_net_1955 VDD=VDD VSS=VSS
Xcopt_h_inst_4790 dl02d1 $PINS I=src_b_lat[20] Z=copt_net_1957 VDD=VDD VSS=VSS
Xcopt_h_inst_4791 dl02d1 $PINS I=c_dst[193] Z=copt_net_1958 VDD=VDD VSS=VSS
Xcopt_h_inst_4795 dl02d1 $PINS I=c_dst[469] Z=copt_net_1962 VDD=VDD VSS=VSS
Xcopt_h_inst_4798 dl02d1 $PINS I=c_dst[426] Z=copt_net_1965 VDD=VDD VSS=VSS
Xcopt_h_inst_4802 dl02d1 $PINS I=dest_c_lat[7] Z=copt_net_1969 VDD=VDD VSS=VSS
Xcopt_h_inst_4806 dl02d1 $PINS I=c_dst[82] Z=copt_net_1973 VDD=VDD VSS=VSS
Xcopt_h_inst_4807 dl02d1 $PINS I=c_dst[499] Z=copt_net_1974 VDD=VDD VSS=VSS
Xcopt_h_inst_4817 dl02d1 $PINS I=c_dst[122] Z=copt_net_1984 VDD=VDD VSS=VSS
Xcopt_h_inst_4820 dl02d1 $PINS I=c_dst[42] Z=copt_net_1987 VDD=VDD VSS=VSS
Xcopt_h_inst_4826 dl02d1 $PINS I=c_dst[371] Z=copt_net_1993 VDD=VDD VSS=VSS
Xcopt_h_inst_4828 dl02d1 $PINS I=c_dst[495] Z=copt_net_1995 VDD=VDD VSS=VSS
Xcopt_h_inst_4830 dl02d1 $PINS I=src_b_lat[8] Z=copt_net_1997 VDD=VDD VSS=VSS
Xcopt_h_inst_4848 buffd1 $PINS I=c_dst[85] Z=copt_net_2015 VDD=VDD VSS=VSS
Xcopt_h_inst_4853 dl02d1 $PINS I=src_b_lat[30] Z=copt_net_2020 VDD=VDD VSS=VSS
Xcopt_h_inst_4859 dl02d1 $PINS I=c_dst[101] Z=copt_net_2026 VDD=VDD VSS=VSS
Xcopt_h_inst_4865 dl02d1 $PINS I=c_dst[332] Z=copt_net_2032 VDD=VDD VSS=VSS
Xcopt_h_inst_4871 dl02d1 $PINS I=c_dst[468] Z=copt_net_2038 VDD=VDD VSS=VSS
Xcopt_h_inst_4872 buffd1 $PINS I=c_dst[464] Z=copt_net_2039 VDD=VDD VSS=VSS
Xcopt_h_inst_4873 dl02d1 $PINS I=c_dst[341] Z=copt_net_2040 VDD=VDD VSS=VSS
Xcopt_h_inst_4874 dl02d1 $PINS I=src_a_lat[10] Z=copt_net_2041 VDD=VDD VSS=VSS
Xcopt_h_inst_4875 dl02d1 $PINS I=src_b_lat[23] Z=copt_net_2042 VDD=VDD VSS=VSS
Xcopt_h_inst_4879 dl02d1 $PINS I=c_dst[84] Z=copt_net_2046 VDD=VDD VSS=VSS
Xcopt_h_inst_4880 dl02d1 $PINS I=c_dst[373] Z=copt_net_2047 VDD=VDD VSS=VSS
Xcopt_h_inst_4881 buffd1 $PINS I=c_dst[96] Z=copt_net_2048 VDD=VDD VSS=VSS
Xcopt_h_inst_4885 dl02d1 $PINS I=src_b_lat[28] Z=copt_net_2052 VDD=VDD VSS=VSS
Xcopt_h_inst_4886 buffd1 $PINS I=c_dst[334] Z=copt_net_2053 VDD=VDD VSS=VSS
Xcopt_h_inst_4888 dl01d1 $PINS I=dest_c_lat[2] Z=copt_net_2055 VDD=VDD VSS=VSS
Xcopt_h_inst_4892 dl02d1 $PINS I=c_dst[163] Z=copt_net_2059 VDD=VDD VSS=VSS
Xcopt_h_inst_4894 dl02d1 $PINS I=c_dst[125] Z=copt_net_2061 VDD=VDD VSS=VSS
Xcopt_h_inst_4910 dl02d1 $PINS I=src_b_lat[2] Z=copt_net_2077 VDD=VDD VSS=VSS
Xcopt_h_inst_4915 dl02d1 $PINS I=dest_c_lat[31] Z=copt_net_2082 VDD=VDD VSS=VSS
Xcopt_h_inst_4918 dl02d1 $PINS I=c_dst[80] Z=copt_net_2085 VDD=VDD VSS=VSS
Xcopt_h_inst_4919 dl02d1 $PINS I=c_dst[463] Z=copt_net_2086 VDD=VDD VSS=VSS
Xcopt_h_inst_4924 buffd1 $PINS I=c_dst[103] Z=copt_net_2091 VDD=VDD VSS=VSS
Xcopt_h_inst_4927 dl02d1 $PINS I=dest_c_lat[6] Z=copt_net_2094 VDD=VDD VSS=VSS
Xcopt_h_inst_4929 dl01d1 $PINS I=c_dst[440] Z=copt_net_2096 VDD=VDD VSS=VSS
Xcopt_h_inst_4931 dl02d1 $PINS I=c_dst[250] Z=copt_net_2098 VDD=VDD VSS=VSS
Xcopt_h_inst_4936 dl02d1 $PINS I=c_dst[78] Z=copt_net_2103 VDD=VDD VSS=VSS
Xcopt_h_inst_4939 dl02d1 $PINS I=c_dst[291] Z=copt_net_2106 VDD=VDD VSS=VSS
Xcopt_h_inst_4941 dl02d1 $PINS I=dest_c_lat[1] Z=copt_net_2108 VDD=VDD VSS=VSS
Xcopt_h_inst_4944 dl02d1 $PINS I=c_dst[335] Z=copt_net_2111 VDD=VDD VSS=VSS
Xcopt_h_inst_4947 dl02d1 $PINS I=c_dst[79] Z=copt_net_2114 VDD=VDD VSS=VSS
Xcopt_h_inst_4963 dl01d1 $PINS I=c_dst[255] Z=copt_net_2130 VDD=VDD VSS=VSS
Xcopt_h_inst_4981 dl02d1 $PINS I=dest_c_lat[3] Z=copt_net_2148 VDD=VDD VSS=VSS
Xcopt_h_inst_4995 dl02d1 $PINS I=c_dst[229] Z=copt_net_2162 VDD=VDD VSS=VSS
Xcopt_h_inst_5005 dl01d1 $PINS I=c_in[61] Z=copt_net_2172 VDD=VDD VSS=VSS
Xcopt_h_inst_5007 buffd1 $PINS I=HFSNET_90 Z=copt_net_2174 VDD=VDD VSS=VSS
Xcopt_h_inst_5014 buffd1 $PINS I=c_dst[370] Z=copt_net_2181 VDD=VDD VSS=VSS
Xcopt_h_inst_5020 buffd1 $PINS I=c_dst[486] Z=copt_net_2187 VDD=VDD VSS=VSS
Xcopt_h_inst_5032 dl02d1 $PINS I=dest_c_lat[20] Z=copt_net_2199 VDD=VDD VSS=VSS
Xcopt_gre_h_inst_5784 dl01d1 $PINS I=n919 Z=copt_gre_net_2956 VDD=VDD VSS=VSS
Xcopt_h_inst_5043 dl01d1 $PINS I=c_dst[311] Z=copt_net_2210 VDD=VDD VSS=VSS
Xcopt_h_inst_5054 dl02d1 $PINS I=c_dst[152] Z=copt_net_2221 VDD=VDD VSS=VSS
Xcopt_h_inst_5058 buffd1 $PINS I=c_dst[220] Z=copt_net_2225 VDD=VDD VSS=VSS
Xcopt_h_inst_5059 dl02d1 $PINS I=src_a_lat[14] Z=copt_net_2226 VDD=VDD VSS=VSS
Xcopt_h_inst_5063 dl02d1 $PINS I=c_dst[343] Z=copt_net_2230 VDD=VDD VSS=VSS
Xcopt_h_inst_5072 dl02d1 $PINS I=src_b_lat[18] Z=copt_net_2239 VDD=VDD VSS=VSS
Xcopt_h_inst_5076 dl01d1 $PINS I=c_in[27] Z=copt_net_2243 VDD=VDD VSS=VSS
Xcopt_h_inst_5079 dl02d1 $PINS I=c_dst[438] Z=copt_net_2246 VDD=VDD VSS=VSS
Xcopt_h_inst_5081 dl02d1 $PINS I=c_dst[28] Z=copt_net_2248 VDD=VDD VSS=VSS
Xcopt_h_inst_5084 dl02d1 $PINS I=dest_c_lat[27] Z=copt_net_2251 VDD=VDD VSS=VSS
Xcopt_h_inst_5089 dl01d1 $PINS I=c_in[115] Z=copt_net_2256 VDD=VDD VSS=VSS
Xcopt_h_inst_5092 dl01d1 $PINS I=c_in[90] Z=copt_net_2259 VDD=VDD VSS=VSS
Xcopt_h_inst_5097 dl01d1 $PINS I=c_in[119] Z=copt_net_2264 VDD=VDD VSS=VSS
Xcopt_h_inst_5101 dl01d1 $PINS I=c_in[16] Z=copt_net_2268 VDD=VDD VSS=VSS
Xcopt_h_inst_5105 dl01d1 $PINS I=HFSNET_46 Z=copt_net_2272 VDD=VDD VSS=VSS
Xcopt_h_inst_5107 dl01d1 $PINS I=HFSNET_40 Z=copt_net_2274 VDD=VDD VSS=VSS
Xcopt_h_inst_5112 dl02d1 $PINS I=HFSNET_37 Z=copt_net_2279 VDD=VDD VSS=VSS
Xcopt_h_inst_5113 dl01d1 $PINS I=HFSNET_42 Z=copt_net_2280 VDD=VDD VSS=VSS
Xcopt_h_inst_5115 dl01d1 $PINS I=HFSNET_35 Z=copt_net_2282 VDD=VDD VSS=VSS
Xcopt_h_inst_5117 dl01d1 $PINS I=c_in[73] Z=copt_net_2284 VDD=VDD VSS=VSS
Xcopt_h_inst_5119 dl01d1 $PINS I=c_in[65] Z=copt_net_2286 VDD=VDD VSS=VSS
Xcopt_h_inst_5121 dl01d1 $PINS I=HFSNET_34 Z=copt_net_2288 VDD=VDD VSS=VSS
Xcopt_h_inst_5126 dl01d1 $PINS I=c_in[5] Z=copt_net_2293 VDD=VDD VSS=VSS
Xcopt_h_inst_5127 dl01d1 $PINS I=c_in[5] Z=copt_net_2294 VDD=VDD VSS=VSS
Xcopt_h_inst_5131 dl01d1 $PINS I=c_in[91] Z=copt_net_2298 VDD=VDD VSS=VSS
Xcopt_h_inst_5136 dl01d1 $PINS I=HFSNET_38 Z=copt_net_2303 VDD=VDD VSS=VSS
Xcopt_h_inst_5139 dl01d1 $PINS I=c_in[34] Z=copt_net_2306 VDD=VDD VSS=VSS
Xcopt_h_inst_5144 dl01d1 $PINS I=HFSNET_41 Z=copt_net_2311 VDD=VDD VSS=VSS
Xcopt_h_inst_5146 dl01d1 $PINS I=c_in[94] Z=copt_net_2313 VDD=VDD VSS=VSS
Xcopt_h_inst_5149 dl01d1 $PINS I=HFSNET_43 Z=copt_net_2316 VDD=VDD VSS=VSS
Xcopt_h_inst_5155 dl01d1 $PINS I=c_in[56] Z=copt_net_2322 VDD=VDD VSS=VSS
Xcopt_h_inst_5156 dl01d1 $PINS I=c_in[76] Z=copt_net_2323 VDD=VDD VSS=VSS
Xcopt_h_inst_5160 dl02d1 $PINS I=dest_c_lat[4] Z=copt_net_2327 VDD=VDD VSS=VSS
Xcopt_h_inst_5162 dl02d1 $PINS I=HFSNET_39 Z=copt_net_2329 VDD=VDD VSS=VSS
Xcopt_h_inst_5165 dl01d1 $PINS I=c_in[72] Z=copt_net_2332 VDD=VDD VSS=VSS
Xcopt_h_inst_5168 dl01d1 $PINS I=HFSNET_36 Z=copt_net_2335 VDD=VDD VSS=VSS
Xcopt_h_inst_5169 dl02d1 $PINS I=c_in[51] Z=copt_net_2336 VDD=VDD VSS=VSS
Xcopt_h_inst_5171 dl02d1 $PINS I=n646 Z=copt_net_2338 VDD=VDD VSS=VSS
Xcopt_h_inst_5175 dl01d1 $PINS I=c_in[48] Z=copt_net_2342 VDD=VDD VSS=VSS
Xcopt_h_inst_5185 dl02d1 $PINS I=n848 Z=copt_net_2352 VDD=VDD VSS=VSS
Xcopt_h_inst_5191 dl01d1 $PINS I=c_in[117] Z=copt_net_2358 VDD=VDD VSS=VSS
Xcopt_h_inst_5195 dl01d1 $PINS I=n164 Z=copt_net_2362 VDD=VDD VSS=VSS
Xcopt_h_inst_5196 dl02d1 $PINS I=c_dst[180] Z=copt_net_2363 VDD=VDD VSS=VSS
Xcopt_h_inst_5197 dl02d1 $PINS I=c_dst[177] Z=copt_net_2364 VDD=VDD VSS=VSS
Xcopt_h_inst_5198 dl02d1 $PINS I=dest_c_lat[13] Z=copt_net_2365 VDD=VDD VSS=VSS
Xcopt_h_inst_5199 dl01d1 $PINS I=c_in[125] Z=copt_net_2366 VDD=VDD VSS=VSS
Xcopt_h_inst_5200 dl02d1 $PINS I=c_dst[434] Z=copt_net_2367 VDD=VDD VSS=VSS
Xcopt_h_inst_5201 dl02d1 $PINS I=src_b_lat[13] Z=copt_net_2368 VDD=VDD VSS=VSS
Xcopt_h_inst_5204 dl02d1 $PINS I=c_dst[305] Z=copt_net_2371 VDD=VDD VSS=VSS
Xcopt_h_inst_5205 dl02d1 $PINS I=c_dst[38] Z=copt_net_2372 VDD=VDD VSS=VSS
Xcopt_h_inst_5206 dl02d1 $PINS I=c_dst[49] Z=copt_net_2373 VDD=VDD VSS=VSS
Xcopt_h_inst_5207 dl02d1 $PINS I=c_dst[433] Z=copt_net_2374 VDD=VDD VSS=VSS
Xcopt_h_inst_5208 dl02d1 $PINS I=src_a_lat[13] Z=copt_net_2375 VDD=VDD VSS=VSS
Xcopt_h_inst_5209 dl02d1 $PINS I=dest_c_lat[0] Z=copt_net_2376 VDD=VDD VSS=VSS
Xcopt_h_inst_5212 dl02d1 $PINS I=c_dst[178] Z=copt_net_2379 VDD=VDD VSS=VSS
Xcopt_h_inst_5213 dl02d1 $PINS I=c_dst[313] Z=copt_net_2380 VDD=VDD VSS=VSS
Xcopt_h_inst_5215 dl02d1 $PINS I=c_dst[306] Z=copt_net_2382 VDD=VDD VSS=VSS
Xcopt_h_inst_5217 dl02d1 $PINS I=c_dst[308] Z=copt_net_2384 VDD=VDD VSS=VSS
Xcopt_h_inst_5220 dl02d1 $PINS I=c_dst[436] Z=copt_net_2387 VDD=VDD VSS=VSS
Xcopt_h_inst_5222 dl02d1 $PINS I=c_dst[41] Z=copt_net_2389 VDD=VDD VSS=VSS
Xcopt_h_inst_5223 dl02d1 $PINS I=c_dst[52] Z=copt_net_2390 VDD=VDD VSS=VSS
Xcopt_h_inst_5224 dl02d1 $PINS I=src_b_lat[0] Z=copt_net_2391 VDD=VDD VSS=VSS
Xcopt_h_inst_5225 dl02d1 $PINS I=c_dst[185] Z=copt_net_2392 VDD=VDD VSS=VSS
Xcopt_h_inst_5228 dl02d1 $PINS I=c_dst[57] Z=copt_net_2395 VDD=VDD VSS=VSS
Xcopt_h_inst_5233 dl01d1 $PINS I=dim_m[0] Z=copt_net_2400 VDD=VDD VSS=VSS
Xcopt_h_inst_5239 dl01d1 $PINS I=c_in[55] Z=copt_net_2406 VDD=VDD VSS=VSS
Xcopt_h_inst_5240 dl02d1 $PINS I=c_dst[54] Z=copt_net_2407 VDD=VDD VSS=VSS
Xcopt_h_inst_5244 dl02d1 $PINS I=c_dst[55] Z=copt_net_2411 VDD=VDD VSS=VSS
Xcopt_h_inst_5245 dl02d1 $PINS I=c_dst[441] Z=copt_net_2412 VDD=VDD VSS=VSS
Xcopt_h_inst_5249 dl02d1 $PINS I=c_dst[50] Z=copt_net_2416 VDD=VDD VSS=VSS
Xcopt_h_inst_5251 dl02d1 $PINS I=c_dst[439] Z=copt_net_2418 VDD=VDD VSS=VSS
Xcopt_h_inst_5264 dl02d1 $PINS I=c_dst[309] Z=copt_net_2431 VDD=VDD VSS=VSS
Xcopt_h_inst_5266 dl02d1 $PINS I=c_dst[53] Z=copt_net_2433 VDD=VDD VSS=VSS
Xcopt_h_inst_5268 dl01d1 $PINS I=c_in[108] Z=copt_net_2435 VDD=VDD VSS=VSS
Xcopt_h_inst_5269 dl01d1 $PINS I=HFSNET_45 Z=copt_net_2436 VDD=VDD VSS=VSS
Xcopt_h_inst_5272 dl02d1 $PINS I=c_dst[437] Z=copt_net_2439 VDD=VDD VSS=VSS
Xcopt_h_inst_5307 dl02d1 $PINS I=n156 Z=copt_net_2474 VDD=VDD VSS=VSS
Xcopt_h_inst_5320 dl02d1 $PINS I=n161 Z=copt_net_2487 VDD=VDD VSS=VSS
Xcopt_h_inst_5328 dl01d1 $PINS I=c_dst[35] Z=copt_net_2495 VDD=VDD VSS=VSS
Xcopt_h_inst_5358 dl01d1 $PINS I=c_in[30] Z=copt_net_2525 VDD=VDD VSS=VSS
Xcopt_h_inst_5382 dl02d1 $PINS I=c_dst[183] Z=copt_net_2549 VDD=VDD VSS=VSS
Xcopt_h_inst_5398 dl02d1 $PINS I=n931 Z=copt_net_2565 VDD=VDD VSS=VSS
Xcopt_h_inst_5408 dl02d1 $PINS I=HFSNET_44 Z=copt_net_2575 VDD=VDD VSS=VSS
Xcopt_h_inst_5423 dl01d1 $PINS I=c_in[17] Z=copt_net_2590 VDD=VDD VSS=VSS
Xcopt_h_inst_5427 dl01d1 $PINS I=n165 Z=copt_net_2594 VDD=VDD VSS=VSS
Xcopt_h_inst_5428 dl01d1 $PINS I=n165 Z=copt_net_2595 VDD=VDD VSS=VSS
Xcopt_h_inst_5429 dl01d1 $PINS I=n165 Z=copt_net_2596 VDD=VDD VSS=VSS
Xcopt_h_inst_5443 dl02d1 $PINS I=c_dst[182] Z=copt_net_2610 VDD=VDD VSS=VSS
Xcopt_h_inst_5444 dl01d1 $PINS I=c_in[102] Z=copt_net_2611 VDD=VDD VSS=VSS
Xcopt_h_inst_5470 dl02d1 $PINS I=c_dst[181] Z=copt_net_2637 VDD=VDD VSS=VSS
Xcopt_h_inst_5472 dl01d1 $PINS I=c_in[93] Z=copt_net_2639 VDD=VDD VSS=VSS
Xcopt_h_inst_5479 dl02d1 $PINS I=n154 Z=copt_net_2646 VDD=VDD VSS=VSS
Xcopt_h_inst_5506 dl01d1 $PINS I=n162 Z=copt_net_2673 VDD=VDD VSS=VSS
Xcopt_h_inst_5510 dl02d1 $PINS I=c_dst[89] Z=copt_net_2677 VDD=VDD VSS=VSS
Xcopt_h_inst_5511 buffd1 $PINS I=n194 Z=copt_net_2678 VDD=VDD VSS=VSS
Xcopt_h_inst_5531 buffd1 $PINS I=c_dst[25] Z=copt_net_2698 VDD=VDD VSS=VSS
Xcopt_h_inst_5533 dl01d1 $PINS I=c_in[127] Z=copt_net_2700 VDD=VDD VSS=VSS
Xcopt_h_inst_5543 dl02d1 $PINS I=c_dst[184] Z=copt_net_2710 VDD=VDD VSS=VSS
Xcopt_h_inst_5549 buffd1 $PINS I=n153 Z=copt_net_2716 VDD=VDD VSS=VSS
Xcopt_h_inst_5560 dl01d1 $PINS I=n178 Z=copt_net_2727 VDD=VDD VSS=VSS
Xcopt_h_inst_5566 dl01d1 $PINS I=aps_rename_21_ Z=job_m[1] VDD=VDD VSS=VSS
Xcopt_h_inst_5567 dl02d1 $PINS I=aps_rename_22_ Z=copt_net_2734 VDD=VDD VSS=VSS
Xcopt_h_inst_5568 dl01d1 $PINS I=aps_rename_22_ Z=job_m[0] VDD=VDD VSS=VSS
Xcopt_h_inst_5570 dl02d1 $PINS I=n518 Z=copt_net_2737 VDD=VDD VSS=VSS
Xcopt_h_inst_5572 dl02d1 $PINS I=n382 Z=copt_net_2739 VDD=VDD VSS=VSS
Xcopt_h_inst_5573 dl02d1 $PINS I=n658 Z=copt_net_2740 VDD=VDD VSS=VSS
Xcopt_h_inst_5574 dl02d1 $PINS I=c_dst[31] Z=copt_net_2741 VDD=VDD VSS=VSS
Xcopt_h_inst_5576 dl02d1 $PINS I=c_dst[307] Z=copt_net_2743 VDD=VDD VSS=VSS
Xcopt_h_inst_5577 dl02d1 $PINS I=c_dst[51] Z=copt_net_2744 VDD=VDD VSS=VSS
Xcopt_h_inst_5580 dl02d1 $PINS I=n835 Z=copt_net_2747 VDD=VDD VSS=VSS
Xcopt_h_inst_5581 dl02d1 $PINS I=n444 Z=copt_net_2748 VDD=VDD VSS=VSS
Xcopt_h_inst_5582 dl01d1 $PINS I=n443 Z=copt_net_2749 VDD=VDD VSS=VSS
Xcopt_h_inst_5583 dl01d1 $PINS I=n709 Z=copt_net_2750 VDD=VDD VSS=VSS
Xcopt_h_inst_5584 dl02d1 $PINS I=n580 Z=copt_net_2751 VDD=VDD VSS=VSS
Xcopt_h_inst_5585 dl01d1 $PINS I=n248 Z=copt_net_2752 VDD=VDD VSS=VSS
Xcopt_h_inst_5586 dl01d1 $PINS I=n687 Z=copt_net_2753 VDD=VDD VSS=VSS
Xcopt_h_inst_5587 dl01d1 $PINS I=n319 Z=copt_net_2754 VDD=VDD VSS=VSS
Xcopt_h_inst_5588 dl01d1 $PINS I=n557 Z=copt_net_2755 VDD=VDD VSS=VSS
Xcopt_h_inst_5589 dl01d1 $PINS I=n593 Z=copt_net_2756 VDD=VDD VSS=VSS
Xcopt_h_inst_5590 dl01d1 $PINS I=n308 Z=copt_net_2757 VDD=VDD VSS=VSS
Xcopt_h_inst_5594 dl01d1 $PINS I=n326 Z=copt_net_2761 VDD=VDD VSS=VSS
Xcopt_h_inst_5611 dl01d1 $PINS I=aps_rename_20_ Z=job_m[2] VDD=VDD VSS=VSS
Xcopt_h_inst_5615 dl01d1 $PINS I=n258 Z=copt_net_2782 VDD=VDD VSS=VSS
Xcopt_h_inst_5630 buffd1 $PINS I=n484 Z=copt_net_2797 VDD=VDD VSS=VSS
Xcopt_h_inst_5631 buffd1 $PINS I=n556 Z=copt_net_2798 VDD=VDD VSS=VSS
Xcopt_h_inst_5656 dl02d1 $PINS I=n803 Z=copt_net_2822 VDD=VDD VSS=VSS
Xcopt_h_inst_5657 dl02d1 $PINS I=n770 Z=copt_net_2823 VDD=VDD VSS=VSS
Xcopt_h_inst_5658 dl02d1 $PINS I=n842 Z=copt_net_2824 VDD=VDD VSS=VSS
Xcopt_h_inst_5659 dl01d1 $PINS I=n844 Z=copt_net_2825 VDD=VDD VSS=VSS
Xcopt_h_inst_5661 dl01d1 $PINS I=c_in[39] Z=copt_net_2827 VDD=VDD VSS=VSS
Xcopt_h_inst_5688 dl02d1 $PINS I=n737 Z=copt_net_2854 VDD=VDD VSS=VSS
Xcopt_h_inst_5697 dl01d1 $PINS I=n841 Z=copt_net_2863 VDD=VDD VSS=VSS
Xcopt_h_inst_5699 dl01d1 $PINS I=n845 Z=copt_net_2865 VDD=VDD VSS=VSS
Xcopt_h_inst_5713 dl01d1 $PINS I=n847 Z=copt_net_2879 VDD=VDD VSS=VSS
Xcopt_h_inst_5714 buffd1 $PINS I=cycle[0] Z=copt_net_2880 VDD=VDD VSS=VSS
Xcopt_h_inst_5725 buffd1 $PINS I=n663 Z=copt_net_2891 VDD=VDD VSS=VSS
Xcopt_h_inst_5728 buffd1 $PINS I=n312 Z=copt_net_2894 VDD=VDD VSS=VSS
.ENDS

.SUBCKT unpu_csr clk rst_n csr_sel[9] csr_sel[8] csr_sel[7] csr_sel[6]
+ csr_sel[5] csr_sel[4] csr_sel[3] csr_sel[2] csr_sel[1] csr_sel[0]
+ csr_wdata[31] csr_wdata[30] csr_wdata[29] csr_wdata[28] csr_wdata[27]
+ csr_wdata[26] csr_wdata[25] csr_wdata[24] csr_wdata[23] csr_wdata[22]
+ csr_wdata[21] csr_wdata[20] csr_wdata[19] csr_wdata[18] csr_wdata[17]
+ csr_wdata[16] csr_wdata[15] csr_wdata[14] csr_wdata[13] csr_wdata[12]
+ csr_wdata[11] csr_wdata[10] csr_wdata[9] csr_wdata[8] csr_wdata[7]
+ csr_wdata[6] csr_wdata[5] csr_wdata[4] csr_wdata[3] csr_wdata[2] csr_wdata[1]
+ csr_wdata[0] csr_wen csr_rdata[31] csr_rdata[30] csr_rdata[29] csr_rdata[28]
+ csr_rdata[27] csr_rdata[26] csr_rdata[25] csr_rdata[24] csr_rdata[23]
+ csr_rdata[22] csr_rdata[21] csr_rdata[20] csr_rdata[19] csr_rdata[18]
+ csr_rdata[17] csr_rdata[16] csr_rdata[15] csr_rdata[14] csr_rdata[13]
+ csr_rdata[12] csr_rdata[11] csr_rdata[10] csr_rdata[9] csr_rdata[8]
+ csr_rdata[7] csr_rdata[6] csr_rdata[5] csr_rdata[4] csr_rdata[3] csr_rdata[2]
+ csr_rdata[1] csr_rdata[0] src_a[31] src_a[30] src_a[29] src_a[28] src_a[27]
+ src_a[26] src_a[25] src_a[24] src_a[23] src_a[22] src_a[21] src_a[20]
+ src_a[19] src_a[18] src_a[17] src_a[16] src_a[15] src_a[14] src_a[13]
+ src_a[12] src_a[11] src_a[10] src_a[9] src_a[8] src_a[7] src_a[6] src_a[5]
+ src_a[4] src_a[3] src_a[2] src_a[1] src_a[0] src_b[31] src_b[30] src_b[29]
+ src_b[28] src_b[27] src_b[26] src_b[25] src_b[24] src_b[23] src_b[22]
+ src_b[21] src_b[20] src_b[19] src_b[18] src_b[17] src_b[16] src_b[15]
+ src_b[14] src_b[13] src_b[12] src_b[11] src_b[10] src_b[9] src_b[8] src_b[7]
+ src_b[6] src_b[5] src_b[4] src_b[3] src_b[2] src_b[1] src_b[0] dest_c[31]
+ dest_c[30] dest_c[29] dest_c[28] dest_c[27] dest_c[26] dest_c[25] dest_c[24]
+ dest_c[23] dest_c[22] dest_c[21] dest_c[20] dest_c[19] dest_c[18] dest_c[17]
+ dest_c[16] dest_c[15] dest_c[14] dest_c[13] dest_c[12] dest_c[11] dest_c[10]
+ dest_c[9] dest_c[8] dest_c[7] dest_c[6] dest_c[5] dest_c[4] dest_c[3]
+ dest_c[2] dest_c[1] dest_c[0] dim_m[2] dim_m[1] dim_m[0] dim_n[2] dim_n[1]
+ dim_n[0] dim_k[2] dim_k[1] dim_k[0] mode_unsigned start_pulse done_i error_i
+ error_code_i[2] error_code_i[1] error_code_i[0] VDD VSS ZCTSNET_21
+ gre_a_INV_123_0 ZCTSNET_23 ZCTSNET_24 HFSNET_14 HFSNET_15 HFSNET_16 HFSNET_17
+ HFSNET_18 HFSNET_20 ZCTSNET_25 ZBUF_9_0 ZBUF_9_2 ZBUF_253_2 ZCTSNET_0
+ ZCTSNET_1 gre_a_INV_123_2 ZCTSNET_3 gre_a_INV_119_2 gre_a_INV_97_2
+ gre_a_INV_83_2 gre_a_INV_130_2
Xsrc_a_reg_reg_31_ dfcrn2 $PINS D=n367 CP=ZCTSNET_24 CDN=HFSNET_13 QN=n91
+ VDD=VDD VSS=VSS
Xsrc_a_reg_reg_30_ dfcrn2 $PINS D=n366 CP=ZCTSNET_0 CDN=HFSNET_18 QN=n90
+ VDD=VDD VSS=VSS
Xsrc_a_reg_reg_29_ dfcrn2 $PINS D=n365 CP=ZCTSNET_24 CDN=HFSNET_14 QN=n89
+ VDD=VDD VSS=VSS
Xsrc_a_reg_reg_28_ dfcrn2 $PINS D=n364 CP=ZCTSNET_23 CDN=HFSNET_19 QN=n88
+ VDD=VDD VSS=VSS
Xsrc_a_reg_reg_27_ dfcrn2 $PINS D=n363 CP=ZCTSNET_25 CDN=HFSNET_14 QN=n87
+ VDD=VDD VSS=VSS
Xsrc_a_reg_reg_26_ dfcrn2 $PINS D=n362 CP=ZCTSNET_23 CDN=HFSNET_19 QN=n86
+ VDD=VDD VSS=VSS
Xsrc_a_reg_reg_25_ dfcrn2 $PINS D=n361 CP=ZCTSNET_25 CDN=HFSNET_14 QN=n85
+ VDD=VDD VSS=VSS
Xsrc_a_reg_reg_24_ dfcrn2 $PINS D=n360 CP=ZCTSNET_23 CDN=HFSNET_19 QN=n84
+ VDD=VDD VSS=VSS
Xsrc_a_reg_reg_23_ dfcrn2 $PINS D=n359 CP=ZCTSNET_25 CDN=HFSNET_13 QN=n83
+ VDD=VDD VSS=VSS
Xsrc_a_reg_reg_22_ dfcrn2 $PINS D=n358 CP=ZCTSNET_23 CDN=HFSNET_19 QN=n82
+ VDD=VDD VSS=VSS
Xsrc_a_reg_reg_21_ dfcrn2 $PINS D=n357 CP=ZCTSNET_25 CDN=HFSNET_13 QN=n81
+ VDD=VDD VSS=VSS
Xsrc_a_reg_reg_20_ dfcrn2 $PINS D=n356 CP=ZCTSNET_23 CDN=HFSNET_19 QN=n80
+ VDD=VDD VSS=VSS
Xsrc_a_reg_reg_19_ dfcrn2 $PINS D=n355 CP=ZCTSNET_25 CDN=HFSNET_13 QN=n79
+ VDD=VDD VSS=VSS
Xsrc_a_reg_reg_18_ dfcrn2 $PINS D=n354 CP=ZCTSNET_23 CDN=HFSNET_19
+ QN=aps_rename_1_ VDD=VDD VSS=VSS
Xsrc_a_reg_reg_17_ dfcrn2 $PINS D=n353 CP=ZCTSNET_25 CDN=HFSNET_13 QN=n77
+ VDD=VDD VSS=VSS
Xsrc_a_reg_reg_16_ dfcrn2 $PINS D=n352 CP=clk CDN=HFSNET_17 QN=aps_rename_2_
+ VDD=VDD VSS=VSS
Xsrc_a_reg_reg_15_ dfcrn2 $PINS D=n351 CP=ZCTSNET_24 CDN=HFSNET_13 QN=n75
+ VDD=VDD VSS=VSS
Xsrc_a_reg_reg_14_ dfcrn2 $PINS D=n350 CP=ZCTSNET_23 CDN=HFSNET_19
+ QN=aps_rename_3_ VDD=VDD VSS=VSS
Xsrc_a_reg_reg_13_ dfcrn2 $PINS D=n349 CP=ZCTSNET_1 CDN=HFSNET_15 QN=n73
+ VDD=VDD VSS=VSS
Xsrc_a_reg_reg_12_ dfcrn2 $PINS D=n348 CP=clk CDN=HFSNET_19 QN=aps_rename_4_
+ VDD=VDD VSS=VSS
Xsrc_a_reg_reg_11_ dfcrn2 $PINS D=n347 CP=ZCTSNET_24 CDN=HFSNET_13 QN=n71
+ VDD=VDD VSS=VSS
Xsrc_a_reg_reg_10_ dfcrn2 $PINS D=n346 CP=ZCTSNET_23 CDN=HFSNET_19
+ QN=aps_rename_5_ VDD=VDD VSS=VSS
Xsrc_a_reg_reg_9_ dfcrn2 $PINS D=n345 CP=ZCTSNET_24 CDN=HFSNET_13 QN=n69
+ VDD=VDD VSS=VSS
Xsrc_a_reg_reg_8_ dfcrn2 $PINS D=n344 CP=ZCTSNET_23 CDN=HFSNET_19 QN=n68
+ VDD=VDD VSS=VSS
Xsrc_a_reg_reg_7_ dfcrn2 $PINS D=n343 CP=ZCTSNET_1 CDN=HFSNET_15 QN=n67 VDD=VDD
+ VSS=VSS
Xsrc_a_reg_reg_6_ dfcrn2 $PINS D=n342 CP=ZCTSNET_23 CDN=HFSNET_19 QN=n66
+ VDD=VDD VSS=VSS
Xsrc_a_reg_reg_5_ dfcrn2 $PINS D=n341 CP=ZCTSNET_1 CDN=HFSNET_13 QN=n65 VDD=VDD
+ VSS=VSS
Xsrc_a_reg_reg_4_ dfcrn2 $PINS D=n340 CP=ZCTSNET_23 CDN=HFSNET_19 QN=n64
+ VDD=VDD VSS=VSS
Xsrc_a_reg_reg_3_ dfcrn2 $PINS D=n339 CP=ZCTSNET_23 CDN=HFSNET_18 QN=n63
+ VDD=VDD VSS=VSS
Xsrc_a_reg_reg_2_ dfcrn2 $PINS D=n338 CP=ZCTSNET_1 CDN=HFSNET_14 QN=n62 VDD=VDD
+ VSS=VSS
Xsrc_a_reg_reg_0_ dfcrn2 $PINS D=n336 CP=ZCTSNET_0 CDN=HFSNET_18 QN=n61 VDD=VDD
+ VSS=VSS
Xsrc_b_reg_reg_31_ dfcrn2 $PINS D=n335 CP=ZCTSNET_25 CDN=rst_n QN=n60 VDD=VDD
+ VSS=VSS
Xsrc_b_reg_reg_30_ dfcrn2 $PINS D=n334 CP=ZCTSNET_23 CDN=HFSNET_19 QN=n59
+ VDD=VDD VSS=VSS
Xsrc_b_reg_reg_29_ dfcrn2 $PINS D=n333 CP=ZCTSNET_25 CDN=rst_n QN=n58 VDD=VDD
+ VSS=VSS
Xsrc_b_reg_reg_28_ dfcrn2 $PINS D=n332 CP=ZCTSNET_23 CDN=HFSNET_19 QN=n57
+ VDD=VDD VSS=VSS
Xsrc_b_reg_reg_27_ dfcrn2 $PINS D=n331 CP=ZCTSNET_25 CDN=rst_n QN=n56 VDD=VDD
+ VSS=VSS
Xsrc_b_reg_reg_26_ dfcrn2 $PINS D=n330 CP=ZCTSNET_23 CDN=HFSNET_19 QN=n55
+ VDD=VDD VSS=VSS
Xsrc_b_reg_reg_25_ dfcrn2 $PINS D=n329 CP=ZCTSNET_25 CDN=rst_n QN=n54 VDD=VDD
+ VSS=VSS
Xsrc_b_reg_reg_24_ dfcrn2 $PINS D=n328 CP=ZCTSNET_23 CDN=HFSNET_19 QN=n53
+ VDD=VDD VSS=VSS
Xsrc_b_reg_reg_23_ dfcrn2 $PINS D=n327 CP=ZCTSNET_25 CDN=rst_n QN=n52 VDD=VDD
+ VSS=VSS
Xsrc_b_reg_reg_22_ dfcrn2 $PINS D=n326 CP=ZCTSNET_23 CDN=HFSNET_19
+ QN=aps_rename_6_ VDD=VDD VSS=VSS
Xsrc_b_reg_reg_21_ dfcrn2 $PINS D=n325 CP=ZCTSNET_25 CDN=rst_n QN=n50 VDD=VDD
+ VSS=VSS
Xsrc_b_reg_reg_20_ dfcrn2 $PINS D=n324 CP=ZCTSNET_23 CDN=HFSNET_19
+ QN=aps_rename_7_ VDD=VDD VSS=VSS
Xsrc_b_reg_reg_19_ dfcrn2 $PINS D=n323 CP=ZCTSNET_25 CDN=rst_n QN=n48 VDD=VDD
+ VSS=VSS
Xsrc_b_reg_reg_18_ dfcrn2 $PINS D=n322 CP=ZCTSNET_23 CDN=HFSNET_19
+ QN=copt_gre_net_3199 VDD=VDD VSS=VSS
Xsrc_b_reg_reg_17_ dfcrn2 $PINS D=n321 CP=ZCTSNET_24 CDN=HFSNET_13 QN=n46
+ VDD=VDD VSS=VSS
Xsrc_b_reg_reg_16_ dfcrn2 $PINS D=n320 CP=clk CDN=HFSNET_17 QN=aps_rename_8_
+ VDD=VDD VSS=VSS
Xsrc_b_reg_reg_15_ dfcrn2 $PINS D=n319 CP=ZCTSNET_21 CDN=HFSNET_18 QN=n44
+ VDD=VDD VSS=VSS
Xsrc_b_reg_reg_14_ dfcrn2 $PINS D=n318 CP=clk CDN=HFSNET_17 QN=aps_rename_9_
+ VDD=VDD VSS=VSS
Xsrc_b_reg_reg_13_ dfcrn2 $PINS D=n317 CP=ZCTSNET_1 CDN=HFSNET_15 QN=n42
+ VDD=VDD VSS=VSS
Xsrc_b_reg_reg_12_ dfcrn2 $PINS D=n316 CP=ZCTSNET_0 CDN=HFSNET_18 QN=n41
+ VDD=VDD VSS=VSS
Xsrc_b_reg_reg_11_ dfcrn2 $PINS D=n315 CP=ZCTSNET_25 CDN=HFSNET_13 QN=n40
+ VDD=VDD VSS=VSS
Xsrc_b_reg_reg_10_ dfcrn2 $PINS D=n314 CP=clk CDN=HFSNET_19 QN=n39 VDD=VDD
+ VSS=VSS
Xsrc_b_reg_reg_9_ dfcrn2 $PINS D=n313 CP=ZCTSNET_24 CDN=HFSNET_13 QN=n38
+ VDD=VDD VSS=VSS
Xsrc_b_reg_reg_8_ dfcrn2 $PINS D=n312 CP=ZCTSNET_23 CDN=HFSNET_18 QN=n37
+ VDD=VDD VSS=VSS
Xsrc_b_reg_reg_7_ dfcrn2 $PINS D=n311 CP=ZCTSNET_3 CDN=HFSNET_15 QN=n36 VDD=VDD
+ VSS=VSS
Xsrc_b_reg_reg_6_ dfcrn2 $PINS D=n310 CP=ZCTSNET_23 CDN=HFSNET_19 QN=n35
+ VDD=VDD VSS=VSS
Xsrc_b_reg_reg_5_ dfcrn2 $PINS D=n309 CP=ZCTSNET_24 CDN=HFSNET_13 QN=n34
+ VDD=VDD VSS=VSS
Xsrc_b_reg_reg_4_ dfcrn2 $PINS D=n308 CP=ZCTSNET_24 CDN=HFSNET_13 QN=n33
+ VDD=VDD VSS=VSS
Xsrc_b_reg_reg_3_ dfcrn2 $PINS D=n307 CP=ZCTSNET_1 CDN=HFSNET_15 QN=n32 VDD=VDD
+ VSS=VSS
Xdest_c_reg_reg_31_ dfcrn2 $PINS D=n303 CP=ZCTSNET_24 CDN=HFSNET_14 QN=n31
+ VDD=VDD VSS=VSS
Xdest_c_reg_reg_30_ dfcrn2 $PINS D=n302 CP=clk CDN=HFSNET_19 QN=n30 VDD=VDD
+ VSS=VSS
Xdest_c_reg_reg_29_ dfcrn2 $PINS D=n301 CP=ZCTSNET_24 CDN=HFSNET_14 QN=n29
+ VDD=VDD VSS=VSS
Xdest_c_reg_reg_28_ dfcrn2 $PINS D=n300 CP=clk CDN=HFSNET_19 QN=n28 VDD=VDD
+ VSS=VSS
Xdest_c_reg_reg_27_ dfcrn2 $PINS D=n299 CP=ZCTSNET_24 CDN=HFSNET_14 QN=n27
+ VDD=VDD VSS=VSS
Xdest_c_reg_reg_26_ dfcrn2 $PINS D=n298 CP=ZCTSNET_23 CDN=HFSNET_19 QN=n26
+ VDD=VDD VSS=VSS
Xdest_c_reg_reg_25_ dfcrn2 $PINS D=n297 CP=ZCTSNET_24 CDN=HFSNET_14 QN=n25
+ VDD=VDD VSS=VSS
Xdest_c_reg_reg_24_ dfcrn2 $PINS D=n296 CP=ZCTSNET_23 CDN=HFSNET_18 QN=n24
+ VDD=VDD VSS=VSS
Xdest_c_reg_reg_23_ dfcrn2 $PINS D=n295 CP=ZCTSNET_25 CDN=HFSNET_13 QN=n23
+ VDD=VDD VSS=VSS
Xdest_c_reg_reg_22_ dfcrn2 $PINS D=n294 CP=ZCTSNET_23 CDN=HFSNET_19 QN=n22
+ VDD=VDD VSS=VSS
Xdest_c_reg_reg_21_ dfcrn2 $PINS D=n293 CP=ZCTSNET_24 CDN=HFSNET_14 QN=n21
+ VDD=VDD VSS=VSS
Xdest_c_reg_reg_20_ dfcrn2 $PINS D=n292 CP=ZCTSNET_23 CDN=HFSNET_19
+ QN=aps_rename_12_ VDD=VDD VSS=VSS
Xdest_c_reg_reg_19_ dfcrn2 $PINS D=n291 CP=ZCTSNET_25 CDN=rst_n QN=n19 VDD=VDD
+ VSS=VSS
Xdest_c_reg_reg_18_ dfcrn2 $PINS D=n290 CP=ZCTSNET_23 CDN=HFSNET_19 QN=n18
+ VDD=VDD VSS=VSS
Xdest_c_reg_reg_17_ dfcrn2 $PINS D=n289 CP=ZCTSNET_0 CDN=HFSNET_18 QN=n17
+ VDD=VDD VSS=VSS
Xdest_c_reg_reg_16_ dfcrn2 $PINS D=n288 CP=clk CDN=HFSNET_17 QN=n16 VDD=VDD
+ VSS=VSS
Xdest_c_reg_reg_15_ dfcrn2 $PINS D=n287 CP=ZCTSNET_24 CDN=HFSNET_13 QN=n15
+ VDD=VDD VSS=VSS
Xdest_c_reg_reg_14_ dfcrn2 $PINS D=n286 CP=ZCTSNET_23 CDN=HFSNET_17 QN=n14
+ VDD=VDD VSS=VSS
Xdest_c_reg_reg_13_ dfcrn2 $PINS D=n285 CP=ZCTSNET_1 CDN=HFSNET_15 QN=n13
+ VDD=VDD VSS=VSS
Xdest_c_reg_reg_12_ dfcrn2 $PINS D=n284 CP=ZCTSNET_23 CDN=HFSNET_17 QN=n12
+ VDD=VDD VSS=VSS
Xdest_c_reg_reg_11_ dfcrn2 $PINS D=n283 CP=ZCTSNET_24 CDN=HFSNET_13 QN=n11
+ VDD=VDD VSS=VSS
Xdest_c_reg_reg_10_ dfcrn2 $PINS D=n282 CP=ZCTSNET_23 CDN=HFSNET_17 QN=n10
+ VDD=VDD VSS=VSS
Xdest_c_reg_reg_9_ dfcrn2 $PINS D=n281 CP=ZCTSNET_24 CDN=HFSNET_13 QN=n9
+ VDD=VDD VSS=VSS
Xdest_c_reg_reg_8_ dfcrn2 $PINS D=n280 CP=ZCTSNET_23 CDN=HFSNET_19 QN=n8
+ VDD=VDD VSS=VSS
Xdest_c_reg_reg_7_ dfcrn2 $PINS D=n279 CP=ZCTSNET_1 CDN=HFSNET_15 QN=n7 VDD=VDD
+ VSS=VSS
Xdest_c_reg_reg_6_ dfcrn2 $PINS D=n278 CP=ZCTSNET_23 CDN=HFSNET_17 QN=n6
+ VDD=VDD VSS=VSS
Xdest_c_reg_reg_5_ dfcrn2 $PINS D=n277 CP=ZCTSNET_24 CDN=HFSNET_13 QN=n5
+ VDD=VDD VSS=VSS
Xdim_n_reg_reg_2_ dfcrn2 $PINS D=n268 CP=ZCTSNET_1 CDN=HFSNET_15 QN=n4 VDD=VDD
+ VSS=VSS
Xdim_n_reg_reg_0_ dfcrn2 $PINS D=n266 CP=ZCTSNET_21 CDN=HFSNET_18 QN=n3 VDD=VDD
+ VSS=VSS
Xdim_k_reg_reg_2_ dfcrn2 $PINS D=n265 CP=ZCTSNET_0 CDN=HFSNET_18 QN=n2 VDD=VDD
+ VSS=VSS
Xdim_k_reg_reg_0_ dfcrn2 $PINS D=n263 CP=ZCTSNET_0 CDN=HFSNET_18 QN=n1 VDD=VDD
+ VSS=VSS
XU103 an02d1 $PINS A1=n249 A2=n233 Z=n231 VDD=VDD VSS=VSS
XU105 an02d2 $PINS A1=n250 A2=n128 Z=n241 VDD=VDD VSS=VSS
XU106 an02d0 $PINS A1=n249 A2=ZBUF_13_3 Z=n250 VDD=VDD VSS=VSS
XU115 nd04d0 $PINS A1=csr_sel[1] A2=n228 A3=csr_wen A4=n133 ZN=n236 VDD=VDD
+ VSS=VSS
XU117 nd02d1 $PINS A1=n260 A2=n261 ZN=n248 VDD=VDD VSS=VSS
XU254 aoim21d1 $PINS B1=done_i B2=status_done_reg A=start_pulse ZN=n262 VDD=VDD
+ VSS=VSS
XU255 oai22d1 $PINS A1=copt_net_2874 A2=n164 B1=n130 B2=copt_net_2318 ZN=n263
+ VDD=VDD VSS=VSS
XU256 aor22d1 $PINS A1=n130 A2=ZBUF_253_3 B1=copt_net_2874 B2=dim_k[1] Z=n264
+ VDD=VDD VSS=VSS
XU257 oai22d1 $PINS A1=copt_net_2874 A2=n163 B1=n130 B2=copt_net_2301 ZN=n265
+ VDD=VDD VSS=VSS
XU258 oai22d1 $PINS A1=n164 A2=copt_net_2818 B1=n129 B2=copt_net_2308 ZN=n266
+ VDD=VDD VSS=VSS
XU259 aor22d1 $PINS A1=ZBUF_253_3 A2=n129 B1=copt_net_2818 B2=dim_n[1] Z=n267
+ VDD=VDD VSS=VSS
XU260 oai22d1 $PINS A1=n163 A2=copt_net_2818 B1=n129 B2=copt_net_2295 ZN=n268
+ VDD=VDD VSS=VSS
XU261 oaim22d1 $PINS A1=n164 A2=copt_net_2851 B1=copt_net_2851 B2=copt_net_2401
+ ZN=n269 VDD=VDD VSS=VSS
XU264 aor22d1 $PINS A1=copt_net_244 A2=copt_net_2731 B1=HFSNET_11 B2=dest_c[0]
+ Z=n272 VDD=VDD VSS=VSS
XU265 aor22d1 $PINS A1=ZBUF_253_3 A2=copt_net_2731 B1=HFSNET_11 B2=dest_c[1]
+ Z=n273 VDD=VDD VSS=VSS
XU266 aor22d1 $PINS A1=copt_net_235 A2=copt_net_2731 B1=HFSNET_11
+ B2=copt_net_991 Z=n274 VDD=VDD VSS=VSS
XU267 aor22d1 $PINS A1=copt_net_2731 A2=copt_net_234 B1=HFSNET_11 B2=dest_c[3]
+ Z=n275 VDD=VDD VSS=VSS
XU268 aor22d1 $PINS A1=copt_net_2731 A2=ZBUF_9_2 B1=HFSNET_11 B2=copt_net_972
+ Z=n276 VDD=VDD VSS=VSS
XU269 oai22d1 $PINS A1=HFSNET_11 A2=copt_net_228 B1=copt_net_2731
+ B2=copt_net_608 ZN=n277 VDD=VDD VSS=VSS
XU270 oai22d1 $PINS A1=HFSNET_11 A2=copt_net_272 B1=copt_net_2731
+ B2=copt_net_718 ZN=n278 VDD=VDD VSS=VSS
XU271 oai22d1 $PINS A1=HFSNET_11 A2=copt_net_243 B1=copt_net_2731
+ B2=copt_net_616 ZN=n279 VDD=VDD VSS=VSS
XU272 oai22d1 $PINS A1=HFSNET_11 A2=copt_net_350 B1=copt_net_2731
+ B2=copt_net_614 ZN=n280 VDD=VDD VSS=VSS
XU273 oai22d1 $PINS A1=HFSNET_11 A2=copt_net_232 B1=copt_net_2731
+ B2=copt_net_624 ZN=n281 VDD=VDD VSS=VSS
XU274 oai22d1 $PINS A1=HFSNET_11 A2=copt_net_255 B1=copt_net_2731
+ B2=copt_net_619 ZN=n282 VDD=VDD VSS=VSS
XU275 oai22d1 $PINS A1=HFSNET_11 A2=copt_net_229 B1=copt_net_2731
+ B2=copt_net_664 ZN=n283 VDD=VDD VSS=VSS
XU276 oai22d1 $PINS A1=HFSNET_11 A2=copt_net_292 B1=copt_net_2731
+ B2=copt_net_621 ZN=n284 VDD=VDD VSS=VSS
XU277 oai22d1 $PINS A1=HFSNET_11 A2=copt_net_242 B1=copt_net_2731
+ B2=copt_net_668 ZN=n285 VDD=VDD VSS=VSS
XU278 oai22d1 $PINS A1=HFSNET_11 A2=copt_net_247 B1=copt_net_2731
+ B2=copt_net_623 ZN=n286 VDD=VDD VSS=VSS
XU279 oai22d1 $PINS A1=HFSNET_11 A2=copt_gre_net_3197 B1=copt_net_2731
+ B2=copt_net_700 ZN=n287 VDD=VDD VSS=VSS
XU280 oai22d1 $PINS A1=HFSNET_11 A2=copt_net_246 B1=copt_net_2731
+ B2=copt_net_654 ZN=n288 VDD=VDD VSS=VSS
XU281 oai22d1 $PINS A1=HFSNET_11 A2=gre_a_INV_63_3 B1=copt_net_2731
+ B2=copt_net_731 ZN=n289 VDD=VDD VSS=VSS
XU282 oai22d1 $PINS A1=HFSNET_11 A2=copt_net_260 B1=copt_net_2731
+ B2=copt_net_607 ZN=n290 VDD=VDD VSS=VSS
XU283 oai22d1 $PINS A1=HFSNET_11 A2=copt_gre_net_3193 B1=copt_net_2731
+ B2=copt_net_735 ZN=n291 VDD=VDD VSS=VSS
XU284 oai22d2 $PINS A1=HFSNET_11 A2=copt_net_266 B1=copt_net_2731 B2=dest_c[20]
+ ZN=n292 VDD=VDD VSS=VSS
XU285 oai22d1 $PINS A1=HFSNET_11 A2=copt_net_226 B1=copt_net_2731
+ B2=copt_net_695 ZN=n293 VDD=VDD VSS=VSS
XU286 oai22d1 $PINS A1=HFSNET_11 A2=copt_net_300 B1=copt_net_2731
+ B2=copt_net_634 ZN=n294 VDD=VDD VSS=VSS
XU287 oai22d1 $PINS A1=HFSNET_11 A2=copt_net_225 B1=copt_net_2731
+ B2=copt_net_673 ZN=n295 VDD=VDD VSS=VSS
XU288 oai22d1 $PINS A1=HFSNET_11 A2=copt_net_336 B1=copt_net_2731
+ B2=copt_net_730 ZN=n296 VDD=VDD VSS=VSS
XU289 oai22d1 $PINS A1=HFSNET_11 A2=copt_gre_net_3196 B1=copt_net_2731
+ B2=copt_net_653 ZN=n297 VDD=VDD VSS=VSS
XU290 oai22d1 $PINS A1=HFSNET_11 A2=copt_net_248 B1=copt_net_2731
+ B2=copt_net_707 ZN=n298 VDD=VDD VSS=VSS
XU291 oai22d1 $PINS A1=HFSNET_11 A2=copt_gre_net_3194 B1=copt_net_2731
+ B2=copt_net_666 ZN=n299 VDD=VDD VSS=VSS
XU292 oai22d1 $PINS A1=HFSNET_11 A2=copt_net_291 B1=copt_net_2731
+ B2=copt_net_757 ZN=n300 VDD=VDD VSS=VSS
XU293 oai22d1 $PINS A1=HFSNET_11 A2=copt_gre_net_3195 B1=copt_net_2731
+ B2=copt_net_679 ZN=n301 VDD=VDD VSS=VSS
XU294 oai22d1 $PINS A1=HFSNET_11 A2=copt_net_1355 B1=copt_net_2731
+ B2=copt_net_740 ZN=n302 VDD=VDD VSS=VSS
XU295 oai22d1 $PINS A1=HFSNET_11 A2=copt_net_245 B1=copt_net_2731
+ B2=copt_net_638 ZN=n303 VDD=VDD VSS=VSS
XU296 aor22d1 $PINS A1=copt_net_244 A2=HFSNET_7 B1=HFSNET_8 B2=src_b[0] Z=n304
+ VDD=VDD VSS=VSS
XU297 aor22d1 $PINS A1=ZBUF_253_3 A2=HFSNET_7 B1=HFSNET_8 B2=copt_net_1051
+ Z=n305 VDD=VDD VSS=VSS
XU298 aor22d1 $PINS A1=copt_net_235 A2=HFSNET_7 B1=HFSNET_8 B2=src_b[2] Z=n306
+ VDD=VDD VSS=VSS
XU299 oai22d1 $PINS A1=n162 A2=HFSNET_8 B1=HFSNET_7 B2=copt_net_773 ZN=n307
+ VDD=VDD VSS=VSS
XU300 oai22d1 $PINS A1=n161 A2=HFSNET_8 B1=HFSNET_7 B2=copt_net_894 ZN=n308
+ VDD=VDD VSS=VSS
XU301 oai22d1 $PINS A1=copt_net_228 A2=HFSNET_8 B1=HFSNET_7 B2=copt_net_647
+ ZN=n309 VDD=VDD VSS=VSS
XU302 oai22d1 $PINS A1=copt_net_272 A2=HFSNET_8 B1=HFSNET_7 B2=copt_net_659
+ ZN=n310 VDD=VDD VSS=VSS
XU303 oai22d1 $PINS A1=copt_net_243 A2=HFSNET_8 B1=HFSNET_7 B2=copt_net_709
+ ZN=n311 VDD=VDD VSS=VSS
XU304 oai22d1 $PINS A1=copt_net_350 A2=HFSNET_8 B1=HFSNET_7 B2=copt_net_658
+ ZN=n312 VDD=VDD VSS=VSS
XU305 oai22d1 $PINS A1=copt_net_232 A2=HFSNET_8 B1=HFSNET_7 B2=copt_net_637
+ ZN=n313 VDD=VDD VSS=VSS
XU306 oai22d1 $PINS A1=copt_net_255 A2=HFSNET_8 B1=HFSNET_7 B2=copt_net_671
+ ZN=n314 VDD=VDD VSS=VSS
XU307 oai22d1 $PINS A1=copt_net_229 A2=HFSNET_8 B1=HFSNET_7 B2=copt_net_667
+ ZN=n315 VDD=VDD VSS=VSS
XU308 oai22d1 $PINS A1=copt_net_292 A2=HFSNET_8 B1=HFSNET_7 B2=copt_net_696
+ ZN=n316 VDD=VDD VSS=VSS
XU309 oai22d1 $PINS A1=copt_net_242 A2=HFSNET_8 B1=HFSNET_7 B2=copt_net_650
+ ZN=n317 VDD=VDD VSS=VSS
XU310 oai22d1 $PINS A1=copt_net_247 A2=HFSNET_8 B1=HFSNET_7 B2=src_b[14]
+ ZN=n318 VDD=VDD VSS=VSS
XU311 oai22d1 $PINS A1=copt_gre_net_3197 A2=HFSNET_8 B1=HFSNET_7
+ B2=copt_net_944 ZN=n319 VDD=VDD VSS=VSS
XU312 oai22d1 $PINS A1=copt_net_246 A2=HFSNET_8 B1=HFSNET_7 B2=src_b[16]
+ ZN=n320 VDD=VDD VSS=VSS
XU313 oai22d1 $PINS A1=gre_a_INV_63_3 A2=HFSNET_8 B1=HFSNET_7 B2=copt_net_738
+ ZN=n321 VDD=VDD VSS=VSS
XU314 oai22d1 $PINS A1=copt_net_260 A2=HFSNET_8 B1=HFSNET_7 B2=src_b[18]
+ ZN=n322 VDD=VDD VSS=VSS
XU315 oai22d1 $PINS A1=copt_gre_net_3193 A2=HFSNET_8 B1=HFSNET_7
+ B2=copt_net_791 ZN=n323 VDD=VDD VSS=VSS
XU316 oai22d1 $PINS A1=copt_net_266 A2=HFSNET_8 B1=HFSNET_7 B2=src_b[20]
+ ZN=n324 VDD=VDD VSS=VSS
XU317 oai22d1 $PINS A1=copt_net_226 A2=HFSNET_8 B1=HFSNET_7 B2=copt_net_737
+ ZN=n325 VDD=VDD VSS=VSS
XU318 oai22d1 $PINS A1=copt_net_300 A2=HFSNET_8 B1=HFSNET_7 B2=src_b[22]
+ ZN=n326 VDD=VDD VSS=VSS
XU319 oai22d1 $PINS A1=copt_net_225 A2=HFSNET_8 B1=HFSNET_7 B2=copt_net_687
+ ZN=n327 VDD=VDD VSS=VSS
XU320 oai22d1 $PINS A1=copt_net_336 A2=HFSNET_8 B1=HFSNET_7 B2=copt_net_660
+ ZN=n328 VDD=VDD VSS=VSS
XU321 oai22d1 $PINS A1=copt_gre_net_3196 A2=HFSNET_8 B1=HFSNET_7
+ B2=copt_net_672 ZN=n329 VDD=VDD VSS=VSS
XU322 oai22d1 $PINS A1=copt_net_248 A2=HFSNET_8 B1=HFSNET_7 B2=copt_net_674
+ ZN=n330 VDD=VDD VSS=VSS
XU323 oai22d1 $PINS A1=copt_gre_net_3194 A2=HFSNET_8 B1=HFSNET_7
+ B2=copt_net_701 ZN=n331 VDD=VDD VSS=VSS
XU324 oai22d1 $PINS A1=copt_net_291 A2=HFSNET_8 B1=HFSNET_7 B2=copt_net_713
+ ZN=n332 VDD=VDD VSS=VSS
XU325 oai22d1 $PINS A1=copt_gre_net_3195 A2=HFSNET_8 B1=HFSNET_7
+ B2=copt_net_727 ZN=n333 VDD=VDD VSS=VSS
XU326 oai22d1 $PINS A1=copt_net_1355 A2=HFSNET_8 B1=HFSNET_7 B2=copt_net_663
+ ZN=n334 VDD=VDD VSS=VSS
XU327 oai22d1 $PINS A1=copt_net_245 A2=HFSNET_8 B1=HFSNET_7 B2=copt_net_720
+ ZN=n335 VDD=VDD VSS=VSS
XU328 oai22d1 $PINS A1=n164 A2=copt_net_2252 B1=HFSNET_9 B2=copt_net_677
+ ZN=n336 VDD=VDD VSS=VSS
XU329 aor22d1 $PINS A1=ZBUF_253_3 A2=HFSNET_9 B1=copt_net_2252 B2=copt_net_1076
+ Z=n337 VDD=VDD VSS=VSS
XU330 oai22d1 $PINS A1=n163 A2=copt_net_2252 B1=HFSNET_9 B2=copt_net_769
+ ZN=n338 VDD=VDD VSS=VSS
XU331 oai22d1 $PINS A1=n162 A2=copt_net_2252 B1=HFSNET_9 B2=copt_net_688
+ ZN=n339 VDD=VDD VSS=VSS
XU332 oai22d1 $PINS A1=n161 A2=copt_net_2252 B1=HFSNET_9 B2=copt_net_601
+ ZN=n340 VDD=VDD VSS=VSS
XU333 oai22d1 $PINS A1=copt_net_228 A2=copt_net_2252 B1=HFSNET_9
+ B2=copt_net_633 ZN=n341 VDD=VDD VSS=VSS
XU334 oai22d1 $PINS A1=copt_net_272 A2=copt_net_2252 B1=HFSNET_9
+ B2=copt_net_661 ZN=n342 VDD=VDD VSS=VSS
XU335 oai22d1 $PINS A1=copt_net_243 A2=copt_net_2252 B1=HFSNET_9
+ B2=copt_net_705 ZN=n343 VDD=VDD VSS=VSS
XU336 oai22d1 $PINS A1=copt_net_350 A2=copt_net_2252 B1=HFSNET_9
+ B2=copt_net_631 ZN=n344 VDD=VDD VSS=VSS
XU337 oai22d1 $PINS A1=copt_net_232 A2=copt_net_2252 B1=HFSNET_9
+ B2=copt_net_625 ZN=n345 VDD=VDD VSS=VSS
XU338 oai22d1 $PINS A1=copt_net_255 A2=copt_net_2252 B1=HFSNET_9 B2=src_a[10]
+ ZN=n346 VDD=VDD VSS=VSS
XU339 oai22d1 $PINS A1=copt_net_229 A2=copt_net_2252 B1=HFSNET_9
+ B2=copt_net_642 ZN=n347 VDD=VDD VSS=VSS
XU340 oai22d1 $PINS A1=copt_net_292 A2=copt_net_2252 B1=HFSNET_9 B2=src_a[12]
+ ZN=n348 VDD=VDD VSS=VSS
XU341 oai22d1 $PINS A1=copt_net_242 A2=copt_net_2252 B1=HFSNET_9
+ B2=copt_net_628 ZN=n349 VDD=VDD VSS=VSS
XU342 oai22d1 $PINS A1=copt_net_247 A2=copt_net_2252 B1=HFSNET_9 B2=src_a[14]
+ ZN=n350 VDD=VDD VSS=VSS
XU343 oai22d1 $PINS A1=copt_gre_net_3197 A2=copt_net_2252 B1=HFSNET_9
+ B2=copt_net_2250 ZN=n351 VDD=VDD VSS=VSS
XU344 oai22d1 $PINS A1=copt_net_246 A2=copt_net_2252 B1=HFSNET_9 B2=src_a[16]
+ ZN=n352 VDD=VDD VSS=VSS
XU345 oai22d1 $PINS A1=gre_a_INV_83_3 A2=copt_net_2252 B1=HFSNET_9
+ B2=copt_net_724 ZN=n353 VDD=VDD VSS=VSS
XU346 oai22d1 $PINS A1=copt_net_260 A2=copt_net_2252 B1=HFSNET_9 B2=src_a[18]
+ ZN=n354 VDD=VDD VSS=VSS
XU347 oai22d1 $PINS A1=copt_gre_net_3193 A2=copt_net_2252 B1=HFSNET_9
+ B2=copt_net_2249 ZN=n355 VDD=VDD VSS=VSS
XU348 oai22d1 $PINS A1=copt_net_266 A2=copt_net_2252 B1=HFSNET_9
+ B2=copt_net_704 ZN=n356 VDD=VDD VSS=VSS
XU349 oai22d1 $PINS A1=copt_net_226 A2=copt_net_2252 B1=HFSNET_9
+ B2=copt_net_725 ZN=n357 VDD=VDD VSS=VSS
XU350 oai22d1 $PINS A1=copt_net_300 A2=copt_net_2252 B1=HFSNET_9
+ B2=copt_net_651 ZN=n358 VDD=VDD VSS=VSS
XU351 oai22d1 $PINS A1=copt_net_225 A2=copt_net_2252 B1=HFSNET_9
+ B2=copt_net_717 ZN=n359 VDD=VDD VSS=VSS
XU352 oai22d1 $PINS A1=copt_net_336 A2=copt_net_2252 B1=HFSNET_9
+ B2=copt_net_729 ZN=n360 VDD=VDD VSS=VSS
XU353 oai22d1 $PINS A1=copt_gre_net_3196 A2=copt_net_2252 B1=HFSNET_9
+ B2=copt_net_675 ZN=n361 VDD=VDD VSS=VSS
XU354 oai22d1 $PINS A1=copt_net_248 A2=copt_net_2252 B1=HFSNET_9
+ B2=copt_net_743 ZN=n362 VDD=VDD VSS=VSS
XU355 oai22d1 $PINS A1=copt_gre_net_3194 A2=copt_net_2252 B1=HFSNET_9
+ B2=copt_net_726 ZN=n363 VDD=VDD VSS=VSS
XU356 oai22d1 $PINS A1=copt_net_291 A2=copt_net_2252 B1=HFSNET_9
+ B2=copt_net_722 ZN=n364 VDD=VDD VSS=VSS
XU357 oai22d1 $PINS A1=copt_gre_net_3195 A2=copt_net_2252 B1=HFSNET_9
+ B2=copt_net_698 ZN=n365 VDD=VDD VSS=VSS
XU358 oai22d1 $PINS A1=copt_net_1355 A2=copt_net_2252 B1=HFSNET_9
+ B2=copt_net_801 ZN=n366 VDD=VDD VSS=VSS
XU359 oai22d1 $PINS A1=copt_net_245 A2=copt_net_2252 B1=HFSNET_9
+ B2=copt_net_683 ZN=n367 VDD=VDD VSS=VSS
XU361 oai222d1 $PINS A1=n106 A2=copt_net_637 B1=n104 B2=net_PTECO_HOLD_NET6
+ C1=n98 C2=net_PTECO_HOLD_NET10 ZN=csr_rdata[9] VDD=VDD VSS=VSS
XU363 oai222d1 $PINS A1=n93 A2=copt_net_709 B1=n104 B2=copt_net_616 C1=n98
+ C2=n67 ZN=csr_rdata[7] VDD=VDD VSS=VSS
XU365 oai222d1 $PINS A1=n93 A2=n34 B1=n104 B2=n5 C1=n98 C2=copt_net_633
+ ZN=csr_rdata[5] VDD=VDD VSS=VSS
XHFSINV_101_406 inv0d0 $PINS I=ZBUF_13_3 ZN=HFSNET_4 VDD=VDD VSS=VSS
Xcopt_gre_h_inst_5848 dl03d1 $PINS I=gre_a_INV_83_2 Z=copt_gre_net_3192 VDD=VDD
+ VSS=VSS
XctmTdsLR_1_2895 oai21d4 $PINS B1=n93 B2=copt_net_773 A=tmp_net188
+ ZN=csr_rdata[3] VDD=VDD VSS=VSS
XU370 oai222d2 $PINS A1=n106 A2=copt_net_720 B1=n104 B2=n31 C1=n98
+ C2=copt_net_683 ZN=csr_rdata[31] VDD=VDD VSS=VSS
XU373 aoi322d1 $PINS C1=n245 C2=n132 C3=n228 A1=error_code_i[0] A2=n241
+ B1=dim_m[2] B2=n231 ZN=n244 VDD=VDD VSS=VSS
XU374 oai22d1 $PINS A1=n133 A2=copt_net_2301 B1=csr_sel[0] B2=n4 ZN=n245
+ VDD=VDD VSS=VSS
XU376 oai222d1 $PINS A1=n93 A2=copt_net_727 B1=n104 B2=net_PTECO_HOLD_NET11
+ C1=n99 C2=n89 ZN=csr_rdata[29] VDD=VDD VSS=VSS
XU379 oai222d1 $PINS A1=n106 A2=copt_net_674 B1=n103 B2=n26 C1=n99
+ C2=copt_net_743 ZN=csr_rdata[26] VDD=VDD VSS=VSS
XU381 oai222d1 $PINS A1=n93 A2=copt_net_660 B1=n103 B2=copt_net_730 C1=n99
+ C2=copt_net_729 ZN=csr_rdata[24] VDD=VDD VSS=VSS
XU383 oai222d1 $PINS A1=n93 A2=src_b[22] B1=n103 B2=copt_net_634 C1=n99
+ C2=copt_net_651 ZN=csr_rdata[22] VDD=VDD VSS=VSS
XU385 oai222d1 $PINS A1=n106 A2=src_b[20] B1=n103 B2=dest_c[20] C1=n100
+ C2=copt_net_704 ZN=csr_rdata[20] VDD=VDD VSS=VSS
XU387 aoi322d1 $PINS C1=n249 C2=HFSNET_4 C3=aps_rename_17_ A1=error_i A2=n250
+ B1=ZBUF_13_3 B2=n251 ZN=n247 VDD=VDD VSS=VSS
XU388 oai21d1 $PINS B1=csr_sel[1] B2=n252 A=n253 ZN=n251 VDD=VDD VSS=VSS
XU389 aoi22d1 $PINS A1=dim_n[1] A2=n133 B1=dim_k[1] B2=csr_sel[0] ZN=n252
+ VDD=VDD VSS=VSS
XU390 aoi222d1 $PINS A1=n254 A2=src_a[1] B1=n255 B2=dest_c[1] C1=n256
+ C2=src_b[1] ZN=n246 VDD=VDD VSS=VSS
XU392 oai222d1 $PINS A1=n106 A2=src_b[18] B1=n102 B2=copt_net_607 C1=n100
+ C2=src_a[18] ZN=csr_rdata[18] VDD=VDD VSS=VSS
XU394 oai222d1 $PINS A1=n106 A2=src_b[16] B1=n102 B2=copt_net_654 C1=n100
+ C2=src_a[16] ZN=csr_rdata[16] VDD=VDD VSS=VSS
XU396 oai222d1 $PINS A1=n106 A2=src_b[14] B1=n102 B2=copt_net_623 C1=n100
+ C2=src_a[14] ZN=csr_rdata[14] VDD=VDD VSS=VSS
XU398 oai222d2 $PINS A1=n106 A2=net_PTECO_HOLD_NET9 B1=n102 B2=copt_net_621
+ C1=n101 C2=src_a[12] ZN=csr_rdata[12] VDD=VDD VSS=VSS
XU400 oai222d1 $PINS A1=n93 A2=copt_net_671 B1=n102 B2=copt_net_619 C1=n98
+ C2=src_a[10] ZN=csr_rdata[10] VDD=VDD VSS=VSS
XU401 oai211d4 $PINS C1=n98 C2=n61 A=n258 B=n257 ZN=csr_rdata[0] VDD=VDD
+ VSS=VSS
XU402 aoi322d1 $PINS C1=n259 C2=n132 C3=n228 A1=status_done_reg A2=n241
+ B1=dim_m[0] B2=n231 ZN=n258 VDD=VDD VSS=VSS
XU403 oai22d1 $PINS A1=n133 A2=copt_net_2318 B1=csr_sel[0] B2=copt_net_2308
+ ZN=n259 VDD=VDD VSS=VSS
XU404 aoi22d1 $PINS A1=n94 A2=dest_c[0] B1=n107 B2=src_b[0] ZN=n257 VDD=VDD
+ VSS=VSS
Xstart_pulse_reg dfcrq2 $PINS D=N_uc_73 CP=ZCTSNET_0 CDN=HFSNET_18
+ Q=start_pulse VDD=VDD VSS=VSS
Xdest_c_reg_reg_4_ dfcrq2 $PINS D=n276 CP=ZCTSNET_23 CDN=HFSNET_18 Q=dest_c[4]
+ VDD=VDD VSS=VSS
Xdest_c_reg_reg_2_ dfcrq2 $PINS D=n274 CP=ZCTSNET_0 CDN=HFSNET_18 Q=dest_c[2]
+ VDD=VDD VSS=VSS
Xdest_c_reg_reg_0_ dfcrq2 $PINS D=n272 CP=ZCTSNET_23 CDN=HFSNET_18
+ Q=aps_rename_15_ VDD=VDD VSS=VSS
Xsrc_b_reg_reg_2_ dfcrq2 $PINS D=n306 CP=ZCTSNET_23 CDN=HFSNET_18
+ Q=aps_rename_10_ VDD=VDD VSS=VSS
Xsrc_b_reg_reg_0_ dfcrq2 $PINS D=n304 CP=ZCTSNET_23 CDN=HFSNET_18
+ Q=aps_rename_11_ VDD=VDD VSS=VSS
Xstatus_done_reg_reg dfcrq2 $PINS D=copt_net_923 CP=ZCTSNET_3 CDN=HFSNET_18
+ Q=status_done_reg VDD=VDD VSS=VSS
Xdim_m_reg_reg_2_ dfcrq2 $PINS D=n271 CP=ZCTSNET_0 CDN=HFSNET_18
+ Q=aps_rename_16_ VDD=VDD VSS=VSS
Xdim_m_reg_reg_0_ dfcrq2 $PINS D=n269 CP=ZCTSNET_0 CDN=HFSNET_18 Q=dim_m[0]
+ VDD=VDD VSS=VSS
Xdest_c_reg_reg_3_ dfcrq2 $PINS D=n275 CP=ZCTSNET_1 CDN=HFSNET_15
+ Q=aps_rename_13_ VDD=VDD VSS=VSS
Xsrc_a_reg_reg_1_ dfcrq2 $PINS D=n337 CP=ZCTSNET_0 CDN=HFSNET_18 Q=src_a[1]
+ VDD=VDD VSS=VSS
Xdest_c_reg_reg_1_ dfcrq2 $PINS D=n273 CP=ZCTSNET_0 CDN=HFSNET_15
+ Q=aps_rename_14_ VDD=VDD VSS=VSS
Xsrc_b_reg_reg_1_ dfcrq2 $PINS D=n305 CP=ZCTSNET_0 CDN=HFSNET_15 Q=src_b[1]
+ VDD=VDD VSS=VSS
Xdim_m_reg_reg_1_ dfcrq2 $PINS D=n270 CP=ZCTSNET_0 CDN=HFSNET_18
+ Q=aps_rename_17_ VDD=VDD VSS=VSS
Xctrl_signed_reg_reg dfcrq2 $PINS D=n368 CP=ZCTSNET_0 CDN=HFSNET_15
+ Q=ctrl_signed_reg VDD=VDD VSS=VSS
Xdim_n_reg_reg_1_ dfcrq2 $PINS D=n267 CP=ZCTSNET_3 CDN=HFSNET_15
+ Q=aps_rename_18_ VDD=VDD VSS=VSS
Xdim_k_reg_reg_1_ dfcrq2 $PINS D=n264 CP=ZCTSNET_3 CDN=HFSNET_15
+ Q=aps_rename_19_ VDD=VDD VSS=VSS
XctmTdsLR_1_2888 nd12d1 $PINS A1=n248 A2=n256 ZN=n105 VDD=VDD VSS=VSS
XU4 aoi22d1 $PINS A1=n94 A2=dest_c[2] B1=n107 B2=src_b[2] ZN=n243 VDD=VDD
+ VSS=VSS
XU5 inv0d1 $PINS I=n105 ZN=n107 VDD=VDD VSS=VSS
XU6 mx02d0 $PINS I0=ZBUF_253_3 I1=copt_net_264 S=copt_gre_net_3198 Z=n368
+ VDD=VDD VSS=VSS
XctmTdsLR_1_2893 oai21d4 $PINS B1=n93 B2=n33 A=tmp_net187 ZN=csr_rdata[4]
+ VDD=VDD VSS=VSS
XU8 mx02d0 $PINS I0=ZBUF_253_3 I1=dim_m[1] S=copt_net_2851 Z=n270 VDD=VDD
+ VSS=VSS
XU9 oai222d1 $PINS A1=n106 A2=copt_net_650 B1=n102 B2=net_PTECO_HOLD_NET3
+ C1=n239 C2=copt_net_628 ZN=csr_rdata[13] VDD=VDD VSS=VSS
XU10 mx02d0 $PINS I0=copt_net_235 I1=dim_m[2] S=copt_net_2851 Z=n271 VDD=VDD
+ VSS=VSS
XU11 buffd2 $PINS I=n105 Z=n93 VDD=VDD VSS=VSS
XU12 nd03d0 $PINS A1=csr_sel[0] A2=n227 A3=n233 ZN=n234 VDD=VDD VSS=VSS
XU13 an02d2 $PINS A1=n255 A2=n128 Z=n94 VDD=VDD VSS=VSS
XU14 nd03d0 $PINS A1=n227 A2=n133 A3=n233 ZN=n235 VDD=VDD VSS=VSS
XU15 inv0d1 $PINS I=n248 ZN=n128 VDD=VDD VSS=VSS
XU16 nd02d2 $PINS A1=n128 A2=n254 ZN=n239 VDD=VDD VSS=VSS
XU17 buffd3 $PINS I=n239 Z=n100 VDD=VDD VSS=VSS
XU18 buffd3 $PINS I=n239 Z=n99 VDD=VDD VSS=VSS
XU19 bufbd7 $PINS I=n239 Z=n98 VDD=VDD VSS=VSS
XU20 inv0d2 $PINS I=csr_sel[1] ZN=n132 VDD=VDD VSS=VSS
XU21 nr03d1 $PINS A1=n132 A2=ZBUF_13_3 A3=csr_sel[0] ZN=n255 VDD=VDD VSS=VSS
XU22 inv0d2 $PINS I=n107 ZN=n106 VDD=VDD VSS=VSS
XU23 inv0d2 $PINS I=csr_sel[0] ZN=n133 VDD=VDD VSS=VSS
XU24 nr03d1 $PINS A1=csr_sel[1] A2=ZBUF_13_3 A3=n133 ZN=n256 VDD=VDD VSS=VSS
XU25 nr03d1 $PINS A1=csr_sel[3] A2=csr_sel[5] A3=csr_sel[4] ZN=n260 VDD=VDD
+ VSS=VSS
XU26 bufbd1 $PINS I=n239 Z=n101 VDD=VDD VSS=VSS
XU27 nd03d0 $PINS A1=n227 A2=n228 A3=csr_sel[0] ZN=n226 VDD=VDD VSS=VSS
Xcopt_h_inst_3055 dl02d1 $PINS I=n142 Z=copt_net_225 VDD=VDD VSS=VSS
XU29 inv0d2 $PINS I=n94 ZN=n102 VDD=VDD VSS=VSS
XU30 inv0d2 $PINS I=n94 ZN=n104 VDD=VDD VSS=VSS
XU31 inv0d1 $PINS I=n94 ZN=n103 VDD=VDD VSS=VSS
XHFSINV_8245_431 inv0da $PINS I=n234 ZN=HFSNET_7 VDD=VDD VSS=VSS
XHFSBUF_132_432 buffd1 $PINS I=n234 Z=HFSNET_8 VDD=VDD VSS=VSS
XHFSINV_8275_433 inv0d2 $PINS I=copt_net_2252 ZN=HFSNET_9 VDD=VDD VSS=VSS
Xcopt_h_inst_3056 dl02d1 $PINS I=n144 Z=copt_net_226 VDD=VDD VSS=VSS
XHFSINV_3941_435 inv0d1 $PINS I=copt_net_2731 ZN=HFSNET_11 VDD=VDD VSS=VSS
XZBUF_253_inst_1690 dl02d1 $PINS I=ZBUF_253_2 Z=ZBUF_253_3 VDD=VDD VSS=VSS
XHFSINV_11146_626 inv0d1 $PINS I=HFSNET_16 ZN=HFSNET_13 VDD=VDD VSS=VSS
XHFSBUF_7034_647 buffd3 $PINS I=HFSNET_20 Z=HFSNET_19 VDD=VDD VSS=VSS
Xcopt_gre_h_inst_5849 dl02d1 $PINS I=gre_a_INV_97_3 Z=copt_gre_net_3193 VDD=VDD
+ VSS=VSS
XU41 inv0d0 $PINS I=copt_net_2818 ZN=n129 VDD=VDD VSS=VSS
XctmTdsLR_2_2894 aoim22d1 $PINS A1=n94 A2=dest_c[4] B1=n101 B2=copt_net_601
+ Z=tmp_net187 VDD=VDD VSS=VSS
XZBUF_13_inst_1692 buffd3 $PINS I=ZBUF_9_0 Z=ZBUF_13_3 VDD=VDD VSS=VSS
XctmTdsLR_2_2896 aoim22d1 $PINS A1=n94 A2=dest_c[3] B1=n101 B2=copt_net_688
+ Z=tmp_net188 VDD=VDD VSS=VSS
Xcopt_h_inst_3058 dl02d1 $PINS I=n160 Z=copt_net_228 VDD=VDD VSS=VSS
XU46 nd03d0 $PINS A1=n228 A2=n133 A3=n227 ZN=n229 VDD=VDD VSS=VSS
XU47 inv0d0 $PINS I=copt_net_2874 ZN=n130 VDD=VDD VSS=VSS
XU48 nr02d0 $PINS A1=n164 A2=copt_gre_net_3198 ZN=N_uc_73 VDD=VDD VSS=VSS
Xcopt_h_inst_3059 dl02d1 $PINS I=n154 Z=copt_net_229 VDD=VDD VSS=VSS
Xcopt_gre_h_inst_5850 dl02d1 $PINS I=gre_a_INV_123_3 Z=copt_gre_net_3194
+ VDD=VDD VSS=VSS
Xcopt_gre_h_inst_5851 dl02d1 $PINS I=gre_a_INV_123_1 Z=copt_gre_net_3195
+ VDD=VDD VSS=VSS
Xcopt_h_inst_3062 dl02d1 $PINS I=n156 Z=copt_net_232 VDD=VDD VSS=VSS
Xcopt_h_inst_3064 dl02d1 $PINS I=csr_wdata[3] Z=copt_net_234 VDD=VDD VSS=VSS
XU54 nr02d1 $PINS A1=n248 A2=ZBUF_13_3 ZN=n233 VDD=VDD VSS=VSS
Xcopt_h_inst_3065 dl02d1 $PINS I=csr_wdata[2] Z=copt_net_235 VDD=VDD VSS=VSS
XU56 an04d0 $PINS A1=n233 A2=csr_sel[1] A3=csr_wen A4=n133 Z=n97 VDD=VDD
+ VSS=VSS
XU57 nd02d0 $PINS A1=n231 A2=csr_wen ZN=n230 VDD=VDD VSS=VSS
XU58 an02d0 $PINS A1=csr_wen A2=n132 Z=n227 VDD=VDD VSS=VSS
XU59 inv0d0 $PINS I=copt_net_244 ZN=n164 VDD=VDD VSS=VSS
XU60 inv0d0 $PINS I=copt_net_235 ZN=n163 VDD=VDD VSS=VSS
XU61 inv0d0 $PINS I=copt_net_234 ZN=n162 VDD=VDD VSS=VSS
XU62 inv0d0 $PINS I=csr_wdata[4] ZN=n161 VDD=VDD VSS=VSS
Xcopt_gre_h_inst_5852 dl02d1 $PINS I=gre_a_INV_119_3 Z=copt_gre_net_3196
+ VDD=VDD VSS=VSS
Xcopt_gre_h_inst_5853 dl02d1 $PINS I=gre_a_INV_130_3 Z=copt_gre_net_3197
+ VDD=VDD VSS=VSS
Xcopt_h_inst_3072 dl02d1 $PINS I=n152 Z=copt_net_242 VDD=VDD VSS=VSS
XU66 nr04d1 $PINS A1=csr_sel[9] A2=csr_sel[8] A3=csr_sel[7] A4=csr_sel[6]
+ ZN=n261 VDD=VDD VSS=VSS
XU67 nd03d0 $PINS A1=ctrl_signed_reg A2=n133 A3=csr_sel[1] ZN=n253 VDD=VDD
+ VSS=VSS
XU68 oai222d1 $PINS A1=n93 A2=copt_net_658 B1=n104 B2=copt_net_614 C1=n98
+ C2=copt_net_631 ZN=csr_rdata[8] VDD=VDD VSS=VSS
XU69 oai222d1 $PINS A1=n93 A2=copt_net_663 B1=n104 B2=copt_net_740 C1=n98
+ C2=copt_net_801 ZN=csr_rdata[30] VDD=VDD VSS=VSS
XU70 oai222d1 $PINS A1=n106 A2=copt_net_667 B1=n102 B2=n11 C1=n100 C2=n71
+ ZN=csr_rdata[11] VDD=VDD VSS=VSS
XU71 oai222d1 $PINS A1=n106 A2=copt_net_944 B1=n102 B2=n15 C1=n100 C2=n75
+ ZN=csr_rdata[15] VDD=VDD VSS=VSS
XU72 oai222d1 $PINS A1=n106 A2=copt_net_738 B1=n102 B2=copt_net_731 C1=n100
+ C2=net_PTECO_HOLD_NET8 ZN=csr_rdata[17] VDD=VDD VSS=VSS
XU73 oai222d1 $PINS A1=n106 A2=copt_net_791 B1=n103 B2=copt_net_735 C1=n100
+ C2=n79 ZN=csr_rdata[19] VDD=VDD VSS=VSS
XU74 oai222d1 $PINS A1=n106 A2=copt_net_737 B1=n103 B2=n21 C1=n100
+ C2=net_PTECO_HOLD_NET5 ZN=csr_rdata[21] VDD=VDD VSS=VSS
Xcopt_h_inst_3073 dl02d1 $PINS I=n158 Z=copt_net_243 VDD=VDD VSS=VSS
XU76 oai222d4 $PINS A1=n93 A2=copt_net_659 B1=n104 B2=n6 C1=n99 C2=n66
+ ZN=csr_rdata[6] VDD=VDD VSS=VSS
XU77 oai222d1 $PINS A1=n93 A2=net_PTECO_HOLD_NET1 B1=n103
+ B2=net_PTECO_HOLD_NET4 C1=n99 C2=net_PTECO_HOLD_NET2 ZN=csr_rdata[23] VDD=VDD
+ VSS=VSS
XU78 oai222d2 $PINS A1=n93 A2=copt_net_672 B1=n103 B2=n25 C1=n99 C2=n85
+ ZN=csr_rdata[25] VDD=VDD VSS=VSS
XU79 oai222d1 $PINS A1=n93 A2=copt_net_701 B1=n103 B2=net_PTECO_HOLD_NET7
+ C1=n99 C2=copt_net_726 ZN=csr_rdata[27] VDD=VDD VSS=VSS
XU80 oai222d1 $PINS A1=n93 A2=copt_net_713 B1=n104 B2=copt_net_757 C1=n99
+ C2=copt_net_722 ZN=csr_rdata[28] VDD=VDD VSS=VSS
XU81 inv0d0 $PINS I=csr_wdata[5] ZN=n160 VDD=VDD VSS=VSS
XU82 inv0d0 $PINS I=csr_wdata[6] ZN=n159 VDD=VDD VSS=VSS
XU83 inv0d0 $PINS I=csr_wdata[7] ZN=n158 VDD=VDD VSS=VSS
XU84 inv0d0 $PINS I=csr_wdata[8] ZN=n157 VDD=VDD VSS=VSS
XU85 inv0d0 $PINS I=csr_wdata[9] ZN=n156 VDD=VDD VSS=VSS
XU86 inv0d0 $PINS I=csr_wdata[10] ZN=n155 VDD=VDD VSS=VSS
XU87 inv0d0 $PINS I=csr_wdata[11] ZN=n154 VDD=VDD VSS=VSS
XU88 inv0d0 $PINS I=csr_wdata[12] ZN=n153 VDD=VDD VSS=VSS
XU89 inv0d0 $PINS I=csr_wdata[13] ZN=n152 VDD=VDD VSS=VSS
XU90 inv0d0 $PINS I=csr_wdata[14] ZN=n151 VDD=VDD VSS=VSS
Xcopt_gre_h_inst_5854 dl02d1 $PINS I=n236 Z=copt_gre_net_3198 VDD=VDD VSS=VSS
XU92 inv0d0 $PINS I=csr_wdata[16] ZN=n149 VDD=VDD VSS=VSS
Xcopt_gre_h_inst_5855 dl02d1 $PINS I=copt_gre_net_3199 Z=src_b[18] VDD=VDD
+ VSS=VSS
XU94 inv0d0 $PINS I=csr_wdata[18] ZN=n147 VDD=VDD VSS=VSS
XU_PTECO_HOLD_BUF1 dl01d1 $PINS I=n52 Z=net_PTECO_HOLD_NET1 VDD=VDD VSS=VSS
XU96 inv0d0 $PINS I=csr_wdata[20] ZN=n145 VDD=VDD VSS=VSS
XU97 inv0d0 $PINS I=csr_wdata[21] ZN=n144 VDD=VDD VSS=VSS
XU98 inv0d0 $PINS I=csr_wdata[22] ZN=n143 VDD=VDD VSS=VSS
XU99 inv0d0 $PINS I=csr_wdata[23] ZN=n142 VDD=VDD VSS=VSS
XU100 inv0d0 $PINS I=csr_wdata[24] ZN=n141 VDD=VDD VSS=VSS
XU_PTECO_HOLD_BUF2 dl01d1 $PINS I=n83 Z=net_PTECO_HOLD_NET2 VDD=VDD VSS=VSS
XU102 inv0d0 $PINS I=csr_wdata[26] ZN=n139 VDD=VDD VSS=VSS
XU_PTECO_HOLD_BUF3 buffd1 $PINS I=n13 Z=net_PTECO_HOLD_NET3 VDD=VDD VSS=VSS
XU107 inv0d0 $PINS I=csr_wdata[28] ZN=n137 VDD=VDD VSS=VSS
XU_PTECO_HOLD_BUF4 buffd1 $PINS I=n23 Z=net_PTECO_HOLD_NET4 VDD=VDD VSS=VSS
XU109 inv0d0 $PINS I=csr_wdata[30] ZN=n135 VDD=VDD VSS=VSS
XU110 inv0d0 $PINS I=csr_wdata[31] ZN=n134 VDD=VDD VSS=VSS
XU111 inv0d0 $PINS I=copt_net_2318 ZN=dim_k[0] VDD=VDD VSS=VSS
XU112 inv0d0 $PINS I=copt_net_2308 ZN=dim_n[0] VDD=VDD VSS=VSS
XU113 inv0d0 $PINS I=copt_net_2301 ZN=dim_k[2] VDD=VDD VSS=VSS
XU114 inv0d0 $PINS I=copt_net_2296 ZN=dim_n[2] VDD=VDD VSS=VSS
XU116 inv0d0 $PINS I=copt_net_265 ZN=mode_unsigned VDD=VDD VSS=VSS
XU118 inv0d0 $PINS I=copt_net_680 ZN=dest_c[29] VDD=VDD VSS=VSS
XU119 inv0d0 $PINS I=copt_net_730 ZN=dest_c[24] VDD=VDD VSS=VSS
XU120 inv0d0 $PINS I=copt_net_673 ZN=dest_c[23] VDD=VDD VSS=VSS
XU121 inv0d0 $PINS I=copt_net_634 ZN=dest_c[22] VDD=VDD VSS=VSS
XU122 inv0d0 $PINS I=copt_net_695 ZN=dest_c[21] VDD=VDD VSS=VSS
Xcopt_h_inst_3074 dl01d1 $PINS I=csr_wdata[0] Z=copt_net_244 VDD=VDD VSS=VSS
XU124 inv0d0 $PINS I=copt_net_735 ZN=dest_c[19] VDD=VDD VSS=VSS
XU125 inv0d0 $PINS I=copt_net_607 ZN=dest_c[18] VDD=VDD VSS=VSS
XU126 inv0d0 $PINS I=copt_net_731 ZN=dest_c[17] VDD=VDD VSS=VSS
XU127 inv0d0 $PINS I=copt_net_654 ZN=dest_c[16] VDD=VDD VSS=VSS
XU128 inv0d0 $PINS I=copt_net_700 ZN=dest_c[15] VDD=VDD VSS=VSS
XU129 inv0d0 $PINS I=copt_net_623 ZN=dest_c[14] VDD=VDD VSS=VSS
XU130 inv0d0 $PINS I=copt_net_669 ZN=dest_c[13] VDD=VDD VSS=VSS
XU131 inv0d0 $PINS I=copt_net_621 ZN=dest_c[12] VDD=VDD VSS=VSS
XU132 inv0d0 $PINS I=copt_net_664 ZN=dest_c[11] VDD=VDD VSS=VSS
XU133 inv0d0 $PINS I=copt_net_619 ZN=dest_c[10] VDD=VDD VSS=VSS
XU134 inv0d0 $PINS I=copt_net_624 ZN=dest_c[9] VDD=VDD VSS=VSS
XU135 inv0d0 $PINS I=copt_net_614 ZN=dest_c[8] VDD=VDD VSS=VSS
XU136 inv0d0 $PINS I=copt_net_616 ZN=dest_c[7] VDD=VDD VSS=VSS
XU137 inv0d0 $PINS I=copt_net_719 ZN=dest_c[6] VDD=VDD VSS=VSS
XU138 inv0d0 $PINS I=copt_net_609 ZN=dest_c[5] VDD=VDD VSS=VSS
XU139 inv0d0 $PINS I=copt_net_720 ZN=src_b[31] VDD=VDD VSS=VSS
XU140 inv0d0 $PINS I=copt_net_663 ZN=src_b[30] VDD=VDD VSS=VSS
XU141 inv0d0 $PINS I=copt_net_727 ZN=src_b[29] VDD=VDD VSS=VSS
XU142 inv0d0 $PINS I=copt_net_713 ZN=src_b[28] VDD=VDD VSS=VSS
XU143 inv0d0 $PINS I=copt_net_701 ZN=src_b[27] VDD=VDD VSS=VSS
XU144 inv0d0 $PINS I=copt_net_674 ZN=src_b[26] VDD=VDD VSS=VSS
XU145 inv0d0 $PINS I=copt_net_672 ZN=src_b[25] VDD=VDD VSS=VSS
XU146 inv0d0 $PINS I=copt_net_660 ZN=src_b[24] VDD=VDD VSS=VSS
XU147 inv0d0 $PINS I=copt_net_687 ZN=src_b[23] VDD=VDD VSS=VSS
Xcopt_h_inst_3075 dl02d1 $PINS I=n134 Z=copt_net_245 VDD=VDD VSS=VSS
XU149 inv0d0 $PINS I=copt_net_737 ZN=src_b[21] VDD=VDD VSS=VSS
Xcopt_h_inst_3076 dl02d1 $PINS I=n149 Z=copt_net_246 VDD=VDD VSS=VSS
XU151 inv0d0 $PINS I=copt_net_791 ZN=src_b[19] VDD=VDD VSS=VSS
Xcopt_h_inst_3077 dl02d1 $PINS I=n151 Z=copt_net_247 VDD=VDD VSS=VSS
XU153 inv0d0 $PINS I=copt_net_738 ZN=src_b[17] VDD=VDD VSS=VSS
Xcopt_h_inst_3078 dl02d1 $PINS I=n139 Z=copt_net_248 VDD=VDD VSS=VSS
XU155 inv0d0 $PINS I=copt_net_944 ZN=src_b[15] VDD=VDD VSS=VSS
Xcopt_h_inst_3085 dl02d1 $PINS I=n155 Z=copt_net_255 VDD=VDD VSS=VSS
XU157 inv0d0 $PINS I=copt_net_650 ZN=src_b[13] VDD=VDD VSS=VSS
XU158 inv0d0 $PINS I=copt_net_697 ZN=src_b[12] VDD=VDD VSS=VSS
XU159 inv0d0 $PINS I=copt_net_667 ZN=src_b[11] VDD=VDD VSS=VSS
XU160 inv0d0 $PINS I=copt_net_671 ZN=src_b[10] VDD=VDD VSS=VSS
XU161 inv0d0 $PINS I=copt_net_637 ZN=src_b[9] VDD=VDD VSS=VSS
XU162 inv0d0 $PINS I=copt_net_658 ZN=src_b[8] VDD=VDD VSS=VSS
XU163 inv0d0 $PINS I=copt_net_709 ZN=src_b[7] VDD=VDD VSS=VSS
XU164 inv0d0 $PINS I=copt_net_659 ZN=src_b[6] VDD=VDD VSS=VSS
XU165 inv0d0 $PINS I=copt_net_648 ZN=src_b[5] VDD=VDD VSS=VSS
XU166 inv0d0 $PINS I=copt_net_895 ZN=src_b[4] VDD=VDD VSS=VSS
XU167 inv0d0 $PINS I=copt_net_773 ZN=src_b[3] VDD=VDD VSS=VSS
XU168 inv0d0 $PINS I=copt_net_683 ZN=src_a[31] VDD=VDD VSS=VSS
XU169 inv0d0 $PINS I=copt_net_801 ZN=src_a[30] VDD=VDD VSS=VSS
XU170 inv0d0 $PINS I=copt_net_699 ZN=src_a[29] VDD=VDD VSS=VSS
XU171 inv0d0 $PINS I=copt_net_722 ZN=src_a[28] VDD=VDD VSS=VSS
XU172 inv0d0 $PINS I=copt_net_726 ZN=src_a[27] VDD=VDD VSS=VSS
XU173 inv0d0 $PINS I=copt_net_743 ZN=src_a[26] VDD=VDD VSS=VSS
XU174 inv0d0 $PINS I=copt_net_676 ZN=src_a[25] VDD=VDD VSS=VSS
XU175 inv0d0 $PINS I=copt_net_729 ZN=src_a[24] VDD=VDD VSS=VSS
XU176 inv0d0 $PINS I=copt_net_717 ZN=src_a[23] VDD=VDD VSS=VSS
XU177 inv0d0 $PINS I=copt_net_651 ZN=src_a[22] VDD=VDD VSS=VSS
XU178 inv0d0 $PINS I=copt_net_725 ZN=src_a[21] VDD=VDD VSS=VSS
XU179 inv0d0 $PINS I=copt_net_704 ZN=src_a[20] VDD=VDD VSS=VSS
XU180 inv0d0 $PINS I=copt_net_2249 ZN=src_a[19] VDD=VDD VSS=VSS
Xcopt_h_inst_3090 dl02d1 $PINS I=n147 Z=copt_net_260 VDD=VDD VSS=VSS
XU182 inv0d0 $PINS I=copt_net_724 ZN=src_a[17] VDD=VDD VSS=VSS
Xcopt_h_inst_3094 dl02d1 $PINS I=ctrl_signed_reg Z=copt_net_264 VDD=VDD VSS=VSS
XU184 inv0d0 $PINS I=copt_net_2250 ZN=src_a[15] VDD=VDD VSS=VSS
Xcopt_h_inst_3095 dl01d1 $PINS I=ctrl_signed_reg Z=copt_net_265 VDD=VDD VSS=VSS
XU186 inv0d0 $PINS I=copt_net_628 ZN=src_a[13] VDD=VDD VSS=VSS
XU187 inv0d0 $PINS I=copt_net_639 ZN=dest_c[31] VDD=VDD VSS=VSS
XU188 inv0d0 $PINS I=copt_net_740 ZN=dest_c[30] VDD=VDD VSS=VSS
XU189 inv0d0 $PINS I=copt_net_757 ZN=dest_c[28] VDD=VDD VSS=VSS
XU190 inv0d0 $PINS I=copt_net_666 ZN=dest_c[27] VDD=VDD VSS=VSS
XU191 inv0d0 $PINS I=copt_net_708 ZN=dest_c[26] VDD=VDD VSS=VSS
XU192 inv0d0 $PINS I=copt_net_653 ZN=dest_c[25] VDD=VDD VSS=VSS
Xcopt_h_inst_3096 dl02d1 $PINS I=n145 Z=copt_net_266 VDD=VDD VSS=VSS
XU194 inv0d0 $PINS I=copt_net_642 ZN=src_a[11] VDD=VDD VSS=VSS
Xcopt_h_inst_3102 dl02d1 $PINS I=n159 Z=copt_net_272 VDD=VDD VSS=VSS
XU196 inv0d0 $PINS I=copt_net_625 ZN=src_a[9] VDD=VDD VSS=VSS
XU197 inv0d0 $PINS I=copt_net_631 ZN=src_a[8] VDD=VDD VSS=VSS
XU198 inv0d0 $PINS I=copt_net_706 ZN=src_a[7] VDD=VDD VSS=VSS
XU199 inv0d0 $PINS I=copt_net_662 ZN=src_a[6] VDD=VDD VSS=VSS
XU200 inv0d0 $PINS I=copt_net_633 ZN=src_a[5] VDD=VDD VSS=VSS
XU201 inv0d0 $PINS I=copt_net_601 ZN=src_a[4] VDD=VDD VSS=VSS
XU202 inv0d0 $PINS I=copt_net_688 ZN=src_a[3] VDD=VDD VSS=VSS
XU203 inv0d0 $PINS I=copt_net_770 ZN=src_a[2] VDD=VDD VSS=VSS
XU204 inv0d0 $PINS I=copt_net_678 ZN=src_a[0] VDD=VDD VSS=VSS
XU205 aoi21d4 $PINS B1=n246 B2=n247 A=n248 ZN=csr_rdata[1] VDD=VDD VSS=VSS
XU206 oai211d4 $PINS C1=n98 C2=n62 A=n243 B=n244 ZN=csr_rdata[2] VDD=VDD
+ VSS=VSS
XU207 nr02d4 $PINS A1=HFSNET_4 A2=n248 ZN=n228 VDD=VDD VSS=VSS
XU208 nr02d1 $PINS A1=n132 A2=n133 ZN=n249 VDD=VDD VSS=VSS
XU209 nr03d0 $PINS A1=csr_sel[1] A2=ZBUF_13_3 A3=csr_sel[0] ZN=n254 VDD=VDD
+ VSS=VSS
Xcopt_h_inst_3121 dl02d1 $PINS I=n137 Z=copt_net_291 VDD=VDD VSS=VSS
Xcopt_h_inst_3122 dl02d1 $PINS I=n153 Z=copt_net_292 VDD=VDD VSS=VSS
Xcopt_h_inst_3130 dl02d1 $PINS I=n143 Z=copt_net_300 VDD=VDD VSS=VSS
XU_PTECO_HOLD_BUF5 buffd1 $PINS I=n81 Z=net_PTECO_HOLD_NET5 VDD=VDD VSS=VSS
Xcopt_h_inst_3166 dl02d1 $PINS I=n141 Z=copt_net_336 VDD=VDD VSS=VSS
Xcopt_h_inst_3180 dl02d1 $PINS I=n157 Z=copt_net_350 VDD=VDD VSS=VSS
Xcopt_h_inst_3431 dl02d1 $PINS I=n64 Z=copt_net_601 VDD=VDD VSS=VSS
Xcopt_h_inst_3437 dl02d1 $PINS I=n18 Z=copt_net_607 VDD=VDD VSS=VSS
Xcopt_h_inst_3438 dl02d1 $PINS I=n5 Z=copt_net_608 VDD=VDD VSS=VSS
Xcopt_h_inst_3439 dl01d1 $PINS I=n5 Z=copt_net_609 VDD=VDD VSS=VSS
Xcopt_h_inst_3444 dl02d1 $PINS I=n8 Z=copt_net_614 VDD=VDD VSS=VSS
Xcopt_h_inst_3446 dl02d1 $PINS I=n7 Z=copt_net_616 VDD=VDD VSS=VSS
Xcopt_h_inst_3449 dl02d1 $PINS I=n10 Z=copt_net_619 VDD=VDD VSS=VSS
Xcopt_h_inst_3451 dl02d1 $PINS I=n12 Z=copt_net_621 VDD=VDD VSS=VSS
Xcopt_h_inst_3453 dl02d1 $PINS I=n14 Z=copt_net_623 VDD=VDD VSS=VSS
Xcopt_h_inst_3454 dl02d1 $PINS I=n9 Z=copt_net_624 VDD=VDD VSS=VSS
Xcopt_h_inst_3455 dl02d1 $PINS I=n69 Z=copt_net_625 VDD=VDD VSS=VSS
Xcopt_h_inst_3458 dl02d1 $PINS I=n73 Z=copt_net_628 VDD=VDD VSS=VSS
Xcopt_h_inst_3461 dl02d1 $PINS I=n68 Z=copt_net_631 VDD=VDD VSS=VSS
Xgre_a_INV_123_inst_5788 inv0d0 $PINS I=gre_a_INV_123_0 ZN=gre_a_INV_123_1
+ VDD=VDD VSS=VSS
Xcopt_h_inst_3463 dl02d1 $PINS I=n65 Z=copt_net_633 VDD=VDD VSS=VSS
Xcopt_h_inst_3464 dl02d1 $PINS I=n22 Z=copt_net_634 VDD=VDD VSS=VSS
Xcopt_h_inst_3467 dl02d1 $PINS I=n38 Z=copt_net_637 VDD=VDD VSS=VSS
Xcopt_h_inst_3468 dl02d1 $PINS I=n31 Z=copt_net_638 VDD=VDD VSS=VSS
Xcopt_h_inst_3469 dl01d1 $PINS I=n31 Z=copt_net_639 VDD=VDD VSS=VSS
Xcopt_h_inst_3472 dl02d1 $PINS I=n71 Z=copt_net_642 VDD=VDD VSS=VSS
Xcopt_h_inst_3477 dl02d1 $PINS I=n34 Z=copt_net_647 VDD=VDD VSS=VSS
Xcopt_h_inst_3478 dl01d1 $PINS I=n34 Z=copt_net_648 VDD=VDD VSS=VSS
Xgre_a_INV_123_inst_5789 inv0d0 $PINS I=gre_a_INV_123_2 ZN=gre_a_INV_123_3
+ VDD=VDD VSS=VSS
Xcopt_h_inst_3480 dl02d1 $PINS I=n42 Z=copt_net_650 VDD=VDD VSS=VSS
Xcopt_h_inst_3481 dl02d1 $PINS I=n82 Z=copt_net_651 VDD=VDD VSS=VSS
Xcopt_h_inst_3483 dl02d1 $PINS I=n25 Z=copt_net_653 VDD=VDD VSS=VSS
Xcopt_h_inst_3484 dl02d1 $PINS I=n16 Z=copt_net_654 VDD=VDD VSS=VSS
Xcopt_h_inst_3488 dl02d1 $PINS I=n37 Z=copt_net_658 VDD=VDD VSS=VSS
Xcopt_h_inst_3489 dl02d1 $PINS I=n35 Z=copt_net_659 VDD=VDD VSS=VSS
Xcopt_h_inst_3490 dl02d1 $PINS I=n53 Z=copt_net_660 VDD=VDD VSS=VSS
Xcopt_h_inst_3491 dl02d1 $PINS I=n66 Z=copt_net_661 VDD=VDD VSS=VSS
Xcopt_h_inst_3492 dl01d1 $PINS I=n66 Z=copt_net_662 VDD=VDD VSS=VSS
Xcopt_h_inst_3493 dl02d1 $PINS I=n59 Z=copt_net_663 VDD=VDD VSS=VSS
Xcopt_h_inst_3494 dl02d1 $PINS I=n11 Z=copt_net_664 VDD=VDD VSS=VSS
Xcopt_h_inst_3496 dl02d1 $PINS I=n27 Z=copt_net_666 VDD=VDD VSS=VSS
Xcopt_h_inst_3497 dl02d1 $PINS I=n40 Z=copt_net_667 VDD=VDD VSS=VSS
Xcopt_h_inst_3498 dl02d1 $PINS I=n13 Z=copt_net_668 VDD=VDD VSS=VSS
Xcopt_h_inst_3499 dl01d1 $PINS I=n13 Z=copt_net_669 VDD=VDD VSS=VSS
Xcopt_h_inst_3501 dl02d1 $PINS I=n39 Z=copt_net_671 VDD=VDD VSS=VSS
Xcopt_h_inst_3502 dl02d1 $PINS I=n54 Z=copt_net_672 VDD=VDD VSS=VSS
Xcopt_h_inst_3503 dl02d1 $PINS I=n23 Z=copt_net_673 VDD=VDD VSS=VSS
Xcopt_h_inst_3504 dl02d1 $PINS I=n55 Z=copt_net_674 VDD=VDD VSS=VSS
Xcopt_h_inst_3505 dl02d1 $PINS I=n85 Z=copt_net_675 VDD=VDD VSS=VSS
Xcopt_h_inst_3506 dl01d1 $PINS I=n85 Z=copt_net_676 VDD=VDD VSS=VSS
Xcopt_h_inst_3507 dl02d1 $PINS I=n61 Z=copt_net_677 VDD=VDD VSS=VSS
Xcopt_h_inst_3508 dl01d1 $PINS I=n61 Z=copt_net_678 VDD=VDD VSS=VSS
Xcopt_h_inst_3509 dl02d1 $PINS I=n29 Z=copt_net_679 VDD=VDD VSS=VSS
Xcopt_h_inst_3510 dl01d1 $PINS I=n29 Z=copt_net_680 VDD=VDD VSS=VSS
Xgre_a_INV_119_inst_5790 inv0d0 $PINS I=gre_a_INV_119_2 ZN=gre_a_INV_119_3
+ VDD=VDD VSS=VSS
Xcopt_h_inst_3513 dl02d1 $PINS I=n91 Z=copt_net_683 VDD=VDD VSS=VSS
Xcopt_h_inst_3517 dl02d1 $PINS I=n52 Z=copt_net_687 VDD=VDD VSS=VSS
Xcopt_h_inst_3518 dl02d1 $PINS I=n63 Z=copt_net_688 VDD=VDD VSS=VSS
Xcopt_h_inst_3525 dl02d1 $PINS I=n21 Z=copt_net_695 VDD=VDD VSS=VSS
Xcopt_h_inst_3526 dl02d1 $PINS I=n41 Z=copt_net_696 VDD=VDD VSS=VSS
Xcopt_h_inst_3527 dl01d1 $PINS I=n41 Z=copt_net_697 VDD=VDD VSS=VSS
Xcopt_h_inst_3528 dl02d1 $PINS I=n89 Z=copt_net_698 VDD=VDD VSS=VSS
Xcopt_h_inst_3529 dl01d1 $PINS I=n89 Z=copt_net_699 VDD=VDD VSS=VSS
Xcopt_h_inst_3530 dl02d1 $PINS I=n15 Z=copt_net_700 VDD=VDD VSS=VSS
Xcopt_h_inst_3531 dl02d1 $PINS I=n56 Z=copt_net_701 VDD=VDD VSS=VSS
Xcopt_h_inst_3534 dl02d1 $PINS I=n80 Z=copt_net_704 VDD=VDD VSS=VSS
Xcopt_h_inst_3535 dl02d1 $PINS I=n67 Z=copt_net_705 VDD=VDD VSS=VSS
Xcopt_h_inst_3536 dl01d1 $PINS I=n67 Z=copt_net_706 VDD=VDD VSS=VSS
Xcopt_h_inst_3537 dl02d1 $PINS I=n26 Z=copt_net_707 VDD=VDD VSS=VSS
Xcopt_h_inst_3538 dl01d1 $PINS I=n26 Z=copt_net_708 VDD=VDD VSS=VSS
Xcopt_h_inst_3539 dl02d1 $PINS I=n36 Z=copt_net_709 VDD=VDD VSS=VSS
Xcopt_h_inst_3543 dl02d1 $PINS I=n57 Z=copt_net_713 VDD=VDD VSS=VSS
Xcopt_h_inst_3547 dl02d1 $PINS I=n83 Z=copt_net_717 VDD=VDD VSS=VSS
Xcopt_h_inst_3548 dl02d1 $PINS I=n6 Z=copt_net_718 VDD=VDD VSS=VSS
Xcopt_h_inst_3549 dl01d1 $PINS I=n6 Z=copt_net_719 VDD=VDD VSS=VSS
Xcopt_h_inst_3550 dl01d1 $PINS I=n60 Z=copt_net_720 VDD=VDD VSS=VSS
Xcopt_h_inst_3552 dl02d1 $PINS I=n88 Z=copt_net_722 VDD=VDD VSS=VSS
Xcopt_h_inst_3554 dl02d1 $PINS I=n77 Z=copt_net_724 VDD=VDD VSS=VSS
Xcopt_h_inst_3555 dl02d1 $PINS I=n81 Z=copt_net_725 VDD=VDD VSS=VSS
Xcopt_h_inst_3556 dl02d1 $PINS I=n87 Z=copt_net_726 VDD=VDD VSS=VSS
Xcopt_h_inst_3557 dl02d1 $PINS I=n58 Z=copt_net_727 VDD=VDD VSS=VSS
Xcopt_h_inst_3559 dl02d1 $PINS I=n84 Z=copt_net_729 VDD=VDD VSS=VSS
Xcopt_h_inst_3560 dl02d1 $PINS I=n24 Z=copt_net_730 VDD=VDD VSS=VSS
Xcopt_h_inst_3561 dl02d1 $PINS I=n17 Z=copt_net_731 VDD=VDD VSS=VSS
Xcopt_h_inst_3565 dl02d1 $PINS I=aps_rename_6_ Z=src_b[22] VDD=VDD VSS=VSS
Xcopt_h_inst_3566 dl02d1 $PINS I=n19 Z=copt_net_735 VDD=VDD VSS=VSS
Xcopt_h_inst_3568 dl02d1 $PINS I=n50 Z=copt_net_737 VDD=VDD VSS=VSS
Xcopt_h_inst_3569 dl02d1 $PINS I=n46 Z=copt_net_738 VDD=VDD VSS=VSS
Xcopt_h_inst_3571 dl02d1 $PINS I=n30 Z=copt_net_740 VDD=VDD VSS=VSS
Xcopt_h_inst_3574 dl02d1 $PINS I=n86 Z=copt_net_743 VDD=VDD VSS=VSS
Xcopt_h_inst_3575 dl02d1 $PINS I=aps_rename_5_ Z=src_a[10] VDD=VDD VSS=VSS
Xcopt_h_inst_3579 dl01d1 $PINS I=aps_rename_12_ Z=dest_c[20] VDD=VDD VSS=VSS
Xcopt_h_inst_3580 dl02d1 $PINS I=aps_rename_15_ Z=dest_c[0] VDD=VDD VSS=VSS
Xcopt_h_inst_3583 dl01d1 $PINS I=aps_rename_4_ Z=src_a[12] VDD=VDD VSS=VSS
Xcopt_h_inst_3584 dl01d1 $PINS I=aps_rename_7_ Z=src_b[20] VDD=VDD VSS=VSS
Xcopt_h_inst_3588 dl02d1 $PINS I=n28 Z=copt_net_757 VDD=VDD VSS=VSS
Xcopt_h_inst_3600 dl02d1 $PINS I=n62 Z=copt_net_769 VDD=VDD VSS=VSS
Xcopt_h_inst_3601 dl01d1 $PINS I=n62 Z=copt_net_770 VDD=VDD VSS=VSS
Xcopt_h_inst_3604 dl02d1 $PINS I=n32 Z=copt_net_773 VDD=VDD VSS=VSS
Xcopt_h_inst_3622 dl02d1 $PINS I=n48 Z=copt_net_791 VDD=VDD VSS=VSS
Xgre_a_INV_97_inst_5791 inv0d0 $PINS I=gre_a_INV_97_2 ZN=gre_a_INV_97_3 VDD=VDD
+ VSS=VSS
Xcopt_h_inst_3633 dl01d1 $PINS I=n90 Z=copt_net_801 VDD=VDD VSS=VSS
Xcopt_h_inst_3668 dl01d1 $PINS I=aps_rename_2_ Z=src_a[16] VDD=VDD VSS=VSS
Xcopt_h_inst_3717 dl01d1 $PINS I=aps_rename_1_ Z=src_a[18] VDD=VDD VSS=VSS
Xcopt_h_inst_3726 dl02d1 $PINS I=n33 Z=copt_net_894 VDD=VDD VSS=VSS
Xcopt_h_inst_3727 dl01d1 $PINS I=n33 Z=copt_net_895 VDD=VDD VSS=VSS
Xcopt_h_inst_3739 dl01d1 $PINS I=aps_rename_8_ Z=src_b[16] VDD=VDD VSS=VSS
Xcopt_h_inst_3747 dl01d1 $PINS I=aps_rename_9_ Z=src_b[14] VDD=VDD VSS=VSS
Xcopt_h_inst_3753 dl01d1 $PINS I=aps_rename_3_ Z=src_a[14] VDD=VDD VSS=VSS
Xcopt_h_inst_3755 dl02d1 $PINS I=n262 Z=copt_net_923 VDD=VDD VSS=VSS
Xcopt_h_inst_3774 dl02d1 $PINS I=aps_rename_11_ Z=src_b[0] VDD=VDD VSS=VSS
Xcopt_h_inst_3776 dl02d1 $PINS I=n44 Z=copt_net_944 VDD=VDD VSS=VSS
XU_PTECO_HOLD_BUF6 buffd1 $PINS I=n9 Z=net_PTECO_HOLD_NET6 VDD=VDD VSS=VSS
Xcopt_h_inst_3804 dl02d1 $PINS I=dest_c[4] Z=copt_net_972 VDD=VDD VSS=VSS
Xcopt_h_inst_3823 dl02d1 $PINS I=dest_c[2] Z=copt_net_991 VDD=VDD VSS=VSS
Xcopt_h_inst_3853 dl01d1 $PINS I=aps_rename_13_ Z=dest_c[3] VDD=VDD VSS=VSS
Xcopt_h_inst_3871 dl01d1 $PINS I=aps_rename_14_ Z=dest_c[1] VDD=VDD VSS=VSS
Xcopt_h_inst_3881 dl01d1 $PINS I=aps_rename_10_ Z=src_b[2] VDD=VDD VSS=VSS
Xcopt_h_inst_3883 dl02d1 $PINS I=src_b[1] Z=copt_net_1051 VDD=VDD VSS=VSS
Xcopt_h_inst_3908 dl01d1 $PINS I=src_a[1] Z=copt_net_1076 VDD=VDD VSS=VSS
Xcopt_h_inst_4187 dl02d1 $PINS I=n135 Z=copt_net_1355 VDD=VDD VSS=VSS
Xcopt_h_inst_5082 dl02d1 $PINS I=n79 Z=copt_net_2249 VDD=VDD VSS=VSS
Xcopt_h_inst_5083 dl02d1 $PINS I=n75 Z=copt_net_2250 VDD=VDD VSS=VSS
Xcopt_h_inst_5085 buffd1 $PINS I=n235 Z=copt_net_2252 VDD=VDD VSS=VSS
Xcopt_h_inst_5128 dl02d1 $PINS I=n4 Z=copt_net_2295 VDD=VDD VSS=VSS
Xcopt_h_inst_5129 dl01d1 $PINS I=n4 Z=copt_net_2296 VDD=VDD VSS=VSS
Xgre_a_INV_83_inst_5792 inv0d0 $PINS I=copt_gre_net_3192 ZN=gre_a_INV_83_3
+ VDD=VDD VSS=VSS
Xcopt_h_inst_5134 dl02d1 $PINS I=n2 Z=copt_net_2301 VDD=VDD VSS=VSS
Xcopt_h_inst_5141 dl02d1 $PINS I=n3 Z=copt_net_2308 VDD=VDD VSS=VSS
Xcopt_h_inst_5151 dl02d1 $PINS I=n1 Z=copt_net_2318 VDD=VDD VSS=VSS
Xgre_a_INV_63_inst_5793 inv0d0 $PINS I=copt_gre_net_3192 ZN=gre_a_INV_63_3
+ VDD=VDD VSS=VSS
Xcopt_h_inst_5203 dl02d1 $PINS I=aps_rename_16_ Z=dim_m[2] VDD=VDD VSS=VSS
Xcopt_h_inst_5234 dl02d1 $PINS I=dim_m[0] Z=copt_net_2401 VDD=VDD VSS=VSS
Xcopt_h_inst_5243 dl01d1 $PINS I=aps_rename_17_ Z=dim_m[1] VDD=VDD VSS=VSS
Xcopt_h_inst_5247 dl01d1 $PINS I=aps_rename_19_ Z=dim_k[1] VDD=VDD VSS=VSS
Xgre_a_INV_130_inst_5794 inv0d0 $PINS I=gre_a_INV_130_2 ZN=gre_a_INV_130_3
+ VDD=VDD VSS=VSS
Xcopt_h_inst_5283 dl01d1 $PINS I=aps_rename_18_ Z=dim_n[1] VDD=VDD VSS=VSS
Xcopt_h_inst_5564 buffd1 $PINS I=n97 Z=copt_net_2731 VDD=VDD VSS=VSS
Xcopt_h_inst_5652 dl01d1 $PINS I=n229 Z=copt_net_2818 VDD=VDD VSS=VSS
Xcopt_h_inst_5685 dl02d1 $PINS I=n230 Z=copt_net_2851 VDD=VDD VSS=VSS
Xcopt_h_inst_5708 dl02d1 $PINS I=n226 Z=copt_net_2874 VDD=VDD VSS=VSS
XU_PTECO_HOLD_BUF7 buffd1 $PINS I=n27 Z=net_PTECO_HOLD_NET7 VDD=VDD VSS=VSS
XU_PTECO_HOLD_BUF8 buffd1 $PINS I=n77 Z=net_PTECO_HOLD_NET8 VDD=VDD VSS=VSS
XU_PTECO_HOLD_BUF9 buffd1 $PINS I=n41 Z=net_PTECO_HOLD_NET9 VDD=VDD VSS=VSS
XU_PTECO_HOLD_BUF10 buffd1 $PINS I=n69 Z=net_PTECO_HOLD_NET10 VDD=VDD VSS=VSS
XU_PTECO_HOLD_BUF11 buffd1 $PINS I=n29 Z=net_PTECO_HOLD_NET11 VDD=VDD VSS=VSS
.ENDS

.SUBCKT unpu_apb paddr[31] paddr[30] paddr[29] paddr[28] paddr[27] paddr[26]
+ paddr[25] paddr[24] paddr[23] paddr[22] paddr[21] paddr[20] paddr[19]
+ paddr[18] paddr[17] paddr[16] paddr[15] paddr[14] paddr[13] paddr[12]
+ paddr[11] paddr[10] paddr[9] paddr[8] paddr[7] paddr[6] paddr[5] paddr[4]
+ paddr[3] paddr[2] paddr[1] paddr[0] pwdata[31] pwdata[30] pwdata[29]
+ pwdata[28] pwdata[27] pwdata[26] pwdata[25] pwdata[24] pwdata[23] pwdata[22]
+ pwdata[21] pwdata[20] pwdata[19] pwdata[18] pwdata[17] pwdata[16] pwdata[15]
+ pwdata[14] pwdata[13] pwdata[12] pwdata[11] pwdata[10] pwdata[9] pwdata[8]
+ pwdata[7] pwdata[6] pwdata[5] pwdata[4] pwdata[3] pwdata[2] pwdata[1]
+ pwdata[0] pwrite psel penable prdata[31] prdata[30] prdata[29] prdata[28]
+ prdata[27] prdata[26] prdata[25] prdata[24] prdata[23] prdata[22] prdata[21]
+ prdata[20] prdata[19] prdata[18] prdata[17] prdata[16] prdata[15] prdata[14]
+ prdata[13] prdata[12] prdata[11] prdata[10] prdata[9] prdata[8] prdata[7]
+ prdata[6] prdata[5] prdata[4] prdata[3] prdata[2] prdata[1] prdata[0] pready
+ csr_sel[9] csr_sel[8] csr_sel[7] csr_sel[6] csr_sel[5] csr_sel[4] csr_sel[3]
+ csr_sel[2] csr_sel[1] csr_sel[0] csr_wdata[31] csr_wdata[30] csr_wdata[29]
+ csr_wdata[28] csr_wdata[27] csr_wdata[26] csr_wdata[25] csr_wdata[24]
+ csr_wdata[23] csr_wdata[22] csr_wdata[21] csr_wdata[20] csr_wdata[19]
+ csr_wdata[18] csr_wdata[17] csr_wdata[16] csr_wdata[15] csr_wdata[14]
+ csr_wdata[13] csr_wdata[12] csr_wdata[11] csr_wdata[10] csr_wdata[9]
+ csr_wdata[8] csr_wdata[7] csr_wdata[6] csr_wdata[5] csr_wdata[4] csr_wdata[3]
+ csr_wdata[2] csr_wdata[1] csr_wdata[0] csr_wen csr_rdata[31] csr_rdata[30]
+ csr_rdata[29] csr_rdata[28] csr_rdata[27] csr_rdata[26] csr_rdata[25]
+ csr_rdata[24] csr_rdata[23] csr_rdata[22] csr_rdata[21] csr_rdata[20]
+ csr_rdata[19] csr_rdata[18] csr_rdata[17] csr_rdata[16] csr_rdata[15]
+ csr_rdata[14] csr_rdata[13] csr_rdata[12] csr_rdata[11] csr_rdata[10]
+ csr_rdata[9] csr_rdata[8] csr_rdata[7] csr_rdata[6] csr_rdata[5] csr_rdata[4]
+ csr_rdata[3] csr_rdata[2] csr_rdata[1] csr_rdata[0] VSS VDD
*.CONNECT csr_sel[9] paddr[11]
*.CONNECT csr_sel[7] paddr[9]
*.CONNECT csr_sel[5] paddr[7]
*.CONNECT csr_sel[3] paddr[5]
*.CONNECT csr_sel[0] paddr[2]
*.CONNECT csr_wdata[31] pwdata[31]
*.CONNECT csr_wdata[30] pwdata[30]
*.CONNECT csr_wdata[29] pwdata[29]
*.CONNECT csr_wdata[28] pwdata[28]
*.CONNECT csr_wdata[27] pwdata[27]
*.CONNECT csr_wdata[26] pwdata[26]
*.CONNECT csr_wdata[25] pwdata[25]
*.CONNECT csr_wdata[24] pwdata[24]
*.CONNECT csr_wdata[23] pwdata[23]
*.CONNECT csr_wdata[22] pwdata[22]
*.CONNECT csr_wdata[21] pwdata[21]
*.CONNECT csr_wdata[20] pwdata[20]
*.CONNECT csr_wdata[19] pwdata[19]
*.CONNECT csr_wdata[18] pwdata[18]
*.CONNECT csr_wdata[17] pwdata[17]
*.CONNECT csr_wdata[16] pwdata[16]
*.CONNECT csr_wdata[15] pwdata[15]
*.CONNECT csr_wdata[14] pwdata[14]
*.CONNECT csr_wdata[13] pwdata[13]
*.CONNECT csr_wdata[12] pwdata[12]
*.CONNECT csr_wdata[11] pwdata[11]
*.CONNECT csr_wdata[10] pwdata[10]
*.CONNECT csr_wdata[9] pwdata[9]
*.CONNECT csr_wdata[8] pwdata[8]
*.CONNECT csr_wdata[7] pwdata[7]
*.CONNECT csr_wdata[6] pwdata[6]
*.CONNECT csr_wdata[5] pwdata[5]
*.CONNECT csr_wdata[4] pwdata[4]
*.CONNECT csr_wdata[3] pwdata[3]
*.CONNECT csr_wdata[2] pwdata[2]
*.CONNECT csr_wdata[0] pwdata[0]
*.CONNECT prdata[31] csr_rdata[31]
*.CONNECT prdata[30] csr_rdata[30]
*.CONNECT prdata[29] csr_rdata[29]
*.CONNECT prdata[28] csr_rdata[28]
*.CONNECT prdata[27] csr_rdata[27]
*.CONNECT prdata[26] csr_rdata[26]
*.CONNECT prdata[25] csr_rdata[25]
*.CONNECT prdata[24] csr_rdata[24]
*.CONNECT prdata[23] csr_rdata[23]
*.CONNECT prdata[22] csr_rdata[22]
*.CONNECT prdata[20] csr_rdata[20]
*.CONNECT prdata[19] csr_rdata[19]
*.CONNECT prdata[18] csr_rdata[18]
*.CONNECT prdata[17] csr_rdata[17]
*.CONNECT prdata[16] csr_rdata[16]
*.CONNECT prdata[15] csr_rdata[15]
*.CONNECT prdata[14] csr_rdata[14]
*.CONNECT prdata[13] csr_rdata[13]
*.CONNECT prdata[12] csr_rdata[12]
*.CONNECT prdata[11] csr_rdata[11]
*.CONNECT prdata[10] csr_rdata[10]
*.CONNECT prdata[9] csr_rdata[9]
*.CONNECT prdata[8] csr_rdata[8]
*.CONNECT prdata[7] csr_rdata[7]
*.CONNECT prdata[6] csr_rdata[6]
*.CONNECT prdata[5] csr_rdata[5]
*.CONNECT prdata[4] csr_rdata[4]
*.CONNECT prdata[3] csr_rdata[3]
*.CONNECT prdata[2] csr_rdata[2]
*.CONNECT prdata[1] csr_rdata[1]
*.CONNECT prdata[0] csr_rdata[0]
XctmTdsLR_1_2963 buffd7 $PINS I=csr_rdata[21] Z=prdata[21] VDD=VDD VSS=VSS
XU4 buffd3 $PINS I=paddr[10] Z=csr_sel[8] VDD=VDD VSS=VSS
XU25 buffd3 $PINS I=paddr[8] Z=csr_sel[6] VDD=VDD VSS=VSS
XU29 buffd3 $PINS I=paddr[3] Z=csr_sel[1] VDD=VDD VSS=VSS
XU30 buffd3 $PINS I=paddr[6] Z=csr_sel[4] VDD=VDD VSS=VSS
XU46 an03d0 $PINS A1=psel A2=penable A3=pwrite Z=csr_wen VDD=VDD VSS=VSS
.ENDS

.SUBCKT unpu_top clk rst_n paddr[31] paddr[30] paddr[29] paddr[28] paddr[27]
+ paddr[26] paddr[25] paddr[24] paddr[23] paddr[22] paddr[21] paddr[20]
+ paddr[19] paddr[18] paddr[17] paddr[16] paddr[15] paddr[14] paddr[13]
+ paddr[12] paddr[11] paddr[10] paddr[9] paddr[8] paddr[7] paddr[6] paddr[5]
+ paddr[4] paddr[3] paddr[2] paddr[1] paddr[0] pwdata[31] pwdata[30] pwdata[29]
+ pwdata[28] pwdata[27] pwdata[26] pwdata[25] pwdata[24] pwdata[23] pwdata[22]
+ pwdata[21] pwdata[20] pwdata[19] pwdata[18] pwdata[17] pwdata[16] pwdata[15]
+ pwdata[14] pwdata[13] pwdata[12] pwdata[11] pwdata[10] pwdata[9] pwdata[8]
+ pwdata[7] pwdata[6] pwdata[5] pwdata[4] pwdata[3] pwdata[2] pwdata[1]
+ pwdata[0] pwrite psel penable prdata[31] prdata[30] prdata[29] prdata[28]
+ prdata[27] prdata[26] prdata[25] prdata[24] prdata[23] prdata[22] prdata[21]
+ prdata[20] prdata[19] prdata[18] prdata[17] prdata[16] prdata[15] prdata[14]
+ prdata[13] prdata[12] prdata[11] prdata[10] prdata[9] prdata[8] prdata[7]
+ prdata[6] prdata[5] prdata[4] prdata[3] prdata[2] prdata[1] prdata[0] pready
+ dma_addr[31] dma_addr[30] dma_addr[29] dma_addr[28] dma_addr[27] dma_addr[26]
+ dma_addr[25] dma_addr[24] dma_addr[23] dma_addr[22] dma_addr[21] dma_addr[20]
+ dma_addr[19] dma_addr[18] dma_addr[17] dma_addr[16] dma_addr[15] dma_addr[14]
+ dma_addr[13] dma_addr[12] dma_addr[11] dma_addr[10] dma_addr[9] dma_addr[8]
+ dma_addr[7] dma_addr[6] dma_addr[5] dma_addr[4] dma_addr[3] dma_addr[2]
+ dma_addr[1] dma_addr[0] dma_wdata[31] dma_wdata[30] dma_wdata[29]
+ dma_wdata[28] dma_wdata[27] dma_wdata[26] dma_wdata[25] dma_wdata[24]
+ dma_wdata[23] dma_wdata[22] dma_wdata[21] dma_wdata[20] dma_wdata[19]
+ dma_wdata[18] dma_wdata[17] dma_wdata[16] dma_wdata[15] dma_wdata[14]
+ dma_wdata[13] dma_wdata[12] dma_wdata[11] dma_wdata[10] dma_wdata[9]
+ dma_wdata[8] dma_wdata[7] dma_wdata[6] dma_wdata[5] dma_wdata[4] dma_wdata[3]
+ dma_wdata[2] dma_wdata[1] dma_wdata[0] dma_rdata[31] dma_rdata[30]
+ dma_rdata[29] dma_rdata[28] dma_rdata[27] dma_rdata[26] dma_rdata[25]
+ dma_rdata[24] dma_rdata[23] dma_rdata[22] dma_rdata[21] dma_rdata[20]
+ dma_rdata[19] dma_rdata[18] dma_rdata[17] dma_rdata[16] dma_rdata[15]
+ dma_rdata[14] dma_rdata[13] dma_rdata[12] dma_rdata[11] dma_rdata[10]
+ dma_rdata[9] dma_rdata[8] dma_rdata[7] dma_rdata[6] dma_rdata[5] dma_rdata[4]
+ dma_rdata[3] dma_rdata[2] dma_rdata[1] dma_rdata[0] dma_wstrb[3] dma_wstrb[2]
+ dma_wstrb[1] dma_wstrb[0] dma_valid dma_ready VDD VSS
Xu_apb unpu_apb $PINS paddr[31]=SYNOPSYS_UNCONNECTED_1
+ paddr[30]=SYNOPSYS_UNCONNECTED_2 paddr[29]=SYNOPSYS_UNCONNECTED_3
+ paddr[28]=SYNOPSYS_UNCONNECTED_4 paddr[27]=SYNOPSYS_UNCONNECTED_5
+ paddr[26]=SYNOPSYS_UNCONNECTED_6 paddr[25]=SYNOPSYS_UNCONNECTED_7
+ paddr[24]=SYNOPSYS_UNCONNECTED_8 paddr[23]=SYNOPSYS_UNCONNECTED_9
+ paddr[22]=SYNOPSYS_UNCONNECTED_10 paddr[21]=SYNOPSYS_UNCONNECTED_11
+ paddr[20]=SYNOPSYS_UNCONNECTED_12 paddr[19]=SYNOPSYS_UNCONNECTED_13
+ paddr[18]=SYNOPSYS_UNCONNECTED_14 paddr[17]=SYNOPSYS_UNCONNECTED_15
+ paddr[16]=SYNOPSYS_UNCONNECTED_16 paddr[15]=SYNOPSYS_UNCONNECTED_17
+ paddr[14]=SYNOPSYS_UNCONNECTED_18 paddr[13]=SYNOPSYS_UNCONNECTED_19
+ paddr[12]=SYNOPSYS_UNCONNECTED_20 paddr[11]=paddr[11] paddr[10]=paddr[10]
+ paddr[9]=paddr[9] paddr[8]=paddr[8] paddr[7]=antbuf_paddr_7__0_t1a1_n
+ paddr[6]=paddr[6] paddr[5]=paddr[5] paddr[4]=SYNOPSYS_UNCONNECTED_21
+ paddr[3]=paddr[3] paddr[2]=n60 paddr[1]=SYNOPSYS_UNCONNECTED_22
+ paddr[0]=SYNOPSYS_UNCONNECTED_23 pwdata[31]=earlybuf_pwdata_31__2_a1_n
+ pwdata[30]=earlybuf_pwdata_30__3_a1_n pwdata[29]=pwdata[29]
+ pwdata[28]=earlybuf_pwdata_28__4_a1_n pwdata[27]=pwdata[27]
+ pwdata[26]=earlybuf_pwdata_26__5_a1_n pwdata[25]=pwdata[25]
+ pwdata[24]=earlybuf_pwdata_24__6_a1_n pwdata[23]=earlybuf_pwdata_23__7_a1_n
+ pwdata[22]=earlybuf_pwdata_22__8_a1_n pwdata[21]=earlybuf_pwdata_21__9_a1_n
+ pwdata[20]=earlybuf_pwdata_20__10_a1_n pwdata[19]=pwdata[19]
+ pwdata[18]=earlybuf_pwdata_18__11_a1_n pwdata[17]=pwdata[17]
+ pwdata[16]=earlybuf_pwdata_16__12_a1_n pwdata[15]=pwdata[15]
+ pwdata[14]=earlybuf_pwdata_14__13_a1_n pwdata[13]=pwdata[13]
+ pwdata[12]=earlybuf_pwdata_12__14_a1_n pwdata[11]=earlybuf_pwdata_11__15_a1_n
+ pwdata[10]=earlybuf_pwdata_10__16_a1_n pwdata[9]=earlybuf_pwdata_9__17_a1_n
+ pwdata[8]=earlybuf_pwdata_8__18_a1_n pwdata[7]=earlybuf_pwdata_7__19_a1_n
+ pwdata[6]=earlybuf_pwdata_6__20_a1_n pwdata[5]=earlybuf_pwdata_5__21_a1_n
+ pwdata[4]=copt_net_233 pwdata[3]=earlybuf_pwdata_3__23_a1_n
+ pwdata[2]=earlybuf_pwdata_2__24_a1_n pwdata[1]=SYNOPSYS_UNCONNECTED_24
+ pwdata[0]=earlybuf_pwdata_0__25_a1_n pwrite=pwrite psel=earlybuf_psel_26_a1_n
+ penable=penable prdata[31]=n63 prdata[30]=n64 prdata[29]=n65 prdata[28]=n66
+ prdata[27]=n67 prdata[26]=n68 prdata[25]=n69 prdata[24]=n70 prdata[23]=n71
+ prdata[22]=n72 prdata[21]=prdata[21] prdata[20]=n73 prdata[19]=n74
+ prdata[18]=n75 prdata[17]=n76 prdata[16]=n77 prdata[15]=n78 prdata[14]=n79
+ prdata[13]=n80 prdata[12]=n81 prdata[11]=n82 prdata[10]=n83 prdata[9]=n84
+ prdata[8]=n85 prdata[7]=n86 prdata[6]=n87 prdata[5]=n88 prdata[4]=prdata[4]
+ prdata[3]=prdata[3] prdata[2]=prdata[2] prdata[1]=ropt_net_3211
+ prdata[0]=prdata[0] csr_sel[9]=csr_sel[9] csr_sel[8]=csr_sel[8]
+ csr_sel[7]=csr_sel[7] csr_sel[6]=csr_sel[6] csr_sel[5]=csr_sel[5]
+ csr_sel[4]=csr_sel[4] csr_sel[3]=csr_sel[3] csr_sel[2]=SYNOPSYS_UNCONNECTED_25
+ csr_sel[1]=csr_sel[1] csr_sel[0]=csr_sel[0] csr_wdata[31]=csr_wdata[31]
+ csr_wdata[30]=csr_wdata[30] csr_wdata[29]=csr_wdata[29]
+ csr_wdata[28]=csr_wdata[28] csr_wdata[27]=csr_wdata[27]
+ csr_wdata[26]=csr_wdata[26] csr_wdata[25]=csr_wdata[25]
+ csr_wdata[24]=csr_wdata[24] csr_wdata[23]=csr_wdata[23]
+ csr_wdata[22]=csr_wdata[22] csr_wdata[21]=csr_wdata[21]
+ csr_wdata[20]=csr_wdata[20] csr_wdata[19]=csr_wdata[19]
+ csr_wdata[18]=csr_wdata[18] csr_wdata[17]=csr_wdata[17]
+ csr_wdata[16]=csr_wdata[16] csr_wdata[15]=csr_wdata[15]
+ csr_wdata[14]=csr_wdata[14] csr_wdata[13]=csr_wdata[13]
+ csr_wdata[12]=csr_wdata[12] csr_wdata[11]=csr_wdata[11]
+ csr_wdata[10]=csr_wdata[10] csr_wdata[9]=csr_wdata[9] csr_wdata[8]=csr_wdata[8]
+ csr_wdata[7]=csr_wdata[7] csr_wdata[6]=csr_wdata[6] csr_wdata[5]=csr_wdata[5]
+ csr_wdata[4]=csr_wdata[4] csr_wdata[3]=csr_wdata[3] csr_wdata[2]=csr_wdata[2]
+ csr_wdata[1]=SYNOPSYS_UNCONNECTED_26 csr_wdata[0]=csr_wdata[0] csr_wen=csr_wen
+ csr_rdata[31]=csr_rdata[31] csr_rdata[30]=csr_rdata[30]
+ csr_rdata[29]=csr_rdata[29] csr_rdata[28]=csr_rdata[28]
+ csr_rdata[27]=csr_rdata[27] csr_rdata[26]=csr_rdata[26]
+ csr_rdata[25]=csr_rdata[25] csr_rdata[24]=csr_rdata[24]
+ csr_rdata[23]=csr_rdata[23] csr_rdata[22]=csr_rdata[22]
+ csr_rdata[21]=csr_rdata[21] csr_rdata[20]=csr_rdata[20]
+ csr_rdata[19]=csr_rdata[19] csr_rdata[18]=csr_rdata[18]
+ csr_rdata[17]=csr_rdata[17] csr_rdata[16]=csr_rdata[16]
+ csr_rdata[15]=csr_rdata[15] csr_rdata[14]=csr_rdata[14]
+ csr_rdata[13]=csr_rdata[13] csr_rdata[12]=csr_rdata[12]
+ csr_rdata[11]=csr_rdata[11] csr_rdata[10]=csr_rdata[10]
+ csr_rdata[9]=csr_rdata[9] csr_rdata[8]=csr_rdata[8] csr_rdata[7]=csr_rdata[7]
+ csr_rdata[6]=csr_rdata[6] csr_rdata[5]=csr_rdata[5] csr_rdata[4]=csr_rdata[4]
+ csr_rdata[3]=csr_rdata[3] csr_rdata[2]=csr_rdata[2] csr_rdata[1]=csr_rdata[1]
+ csr_rdata[0]=csr_rdata[0] VSS=VSS VDD=VDD
Xu_csr unpu_csr $PINS clk=ZCTSNET_25 rst_n=HFSNET_61 csr_sel[9]=csr_sel[9]
+ csr_sel[8]=csr_sel[8] csr_sel[7]=csr_sel[7] csr_sel[6]=csr_sel[6]
+ csr_sel[5]=csr_sel[5] csr_sel[4]=csr_sel[4] csr_sel[3]=csr_sel[3]
+ csr_sel[2]=SYNOPSYS_UNCONNECTED_27 csr_sel[1]=csr_sel[1] csr_sel[0]=csr_sel[0]
+ csr_wdata[31]=csr_wdata[31] csr_wdata[30]=csr_wdata[30]
+ csr_wdata[29]=csr_wdata[29] csr_wdata[28]=csr_wdata[28]
+ csr_wdata[27]=csr_wdata[27] csr_wdata[26]=csr_wdata[26]
+ csr_wdata[25]=csr_wdata[25] csr_wdata[24]=csr_wdata[24]
+ csr_wdata[23]=csr_wdata[23] csr_wdata[22]=csr_wdata[22]
+ csr_wdata[21]=csr_wdata[21] csr_wdata[20]=csr_wdata[20]
+ csr_wdata[19]=csr_wdata[19] csr_wdata[18]=csr_wdata[18]
+ csr_wdata[17]=csr_wdata[17] csr_wdata[16]=csr_wdata[16]
+ csr_wdata[15]=csr_wdata[15] csr_wdata[14]=csr_wdata[14]
+ csr_wdata[13]=csr_wdata[13] csr_wdata[12]=csr_wdata[12]
+ csr_wdata[11]=csr_wdata[11] csr_wdata[10]=csr_wdata[10]
+ csr_wdata[9]=csr_wdata[9] csr_wdata[8]=csr_wdata[8] csr_wdata[7]=csr_wdata[7]
+ csr_wdata[6]=csr_wdata[6] csr_wdata[5]=csr_wdata[5] csr_wdata[4]=csr_wdata[4]
+ csr_wdata[3]=csr_wdata[3] csr_wdata[2]=csr_wdata[2]
+ csr_wdata[1]=SYNOPSYS_UNCONNECTED_28 csr_wdata[0]=csr_wdata[0] csr_wen=csr_wen
+ csr_rdata[31]=csr_rdata[31] csr_rdata[30]=csr_rdata[30]
+ csr_rdata[29]=csr_rdata[29] csr_rdata[28]=csr_rdata[28]
+ csr_rdata[27]=csr_rdata[27] csr_rdata[26]=csr_rdata[26]
+ csr_rdata[25]=csr_rdata[25] csr_rdata[24]=csr_rdata[24]
+ csr_rdata[23]=csr_rdata[23] csr_rdata[22]=csr_rdata[22]
+ csr_rdata[21]=csr_rdata[21] csr_rdata[20]=csr_rdata[20]
+ csr_rdata[19]=csr_rdata[19] csr_rdata[18]=csr_rdata[18]
+ csr_rdata[17]=csr_rdata[17] csr_rdata[16]=csr_rdata[16]
+ csr_rdata[15]=csr_rdata[15] csr_rdata[14]=csr_rdata[14]
+ csr_rdata[13]=csr_rdata[13] csr_rdata[12]=csr_rdata[12]
+ csr_rdata[11]=csr_rdata[11] csr_rdata[10]=csr_rdata[10]
+ csr_rdata[9]=csr_rdata[9] csr_rdata[8]=csr_rdata[8] csr_rdata[7]=csr_rdata[7]
+ csr_rdata[6]=csr_rdata[6] csr_rdata[5]=csr_rdata[5] csr_rdata[4]=csr_rdata[4]
+ csr_rdata[3]=csr_rdata[3] csr_rdata[2]=csr_rdata[2] csr_rdata[1]=csr_rdata[1]
+ csr_rdata[0]=csr_rdata[0] src_a[31]=src_a[31] src_a[30]=src_a[30]
+ src_a[29]=src_a[29] src_a[28]=src_a[28] src_a[27]=src_a[27] src_a[26]=src_a[26]
+ src_a[25]=src_a[25] src_a[24]=src_a[24] src_a[23]=src_a[23] src_a[22]=src_a[22]
+ src_a[21]=src_a[21] src_a[20]=src_a[20] src_a[19]=src_a[19] src_a[18]=src_a[18]
+ src_a[17]=src_a[17] src_a[16]=src_a[16] src_a[15]=src_a[15] src_a[14]=src_a[14]
+ src_a[13]=src_a[13] src_a[12]=src_a[12] src_a[11]=src_a[11] src_a[10]=src_a[10]
+ src_a[9]=src_a[9] src_a[8]=src_a[8] src_a[7]=src_a[7] src_a[6]=src_a[6]
+ src_a[5]=src_a[5] src_a[4]=src_a[4] src_a[3]=src_a[3] src_a[2]=src_a[2]
+ src_a[1]=src_a[1] src_a[0]=src_a[0] src_b[31]=src_b[31] src_b[30]=src_b[30]
+ src_b[29]=src_b[29] src_b[28]=src_b[28] src_b[27]=src_b[27] src_b[26]=src_b[26]
+ src_b[25]=src_b[25] src_b[24]=src_b[24] src_b[23]=src_b[23] src_b[22]=src_b[22]
+ src_b[21]=src_b[21] src_b[20]=src_b[20] src_b[19]=src_b[19] src_b[18]=src_b[18]
+ src_b[17]=src_b[17] src_b[16]=src_b[16] src_b[15]=src_b[15] src_b[14]=src_b[14]
+ src_b[13]=src_b[13] src_b[12]=src_b[12] src_b[11]=src_b[11] src_b[10]=src_b[10]
+ src_b[9]=src_b[9] src_b[8]=src_b[8] src_b[7]=src_b[7] src_b[6]=src_b[6]
+ src_b[5]=src_b[5] src_b[4]=src_b[4] src_b[3]=src_b[3] src_b[2]=src_b[2]
+ src_b[1]=src_b[1] src_b[0]=src_b[0] dest_c[31]=dest_c[31] dest_c[30]=dest_c[30]
+ dest_c[29]=dest_c[29] dest_c[28]=dest_c[28] dest_c[27]=dest_c[27]
+ dest_c[26]=dest_c[26] dest_c[25]=dest_c[25] dest_c[24]=dest_c[24]
+ dest_c[23]=dest_c[23] dest_c[22]=dest_c[22] dest_c[21]=dest_c[21]
+ dest_c[20]=dest_c[20] dest_c[19]=dest_c[19] dest_c[18]=dest_c[18]
+ dest_c[17]=dest_c[17] dest_c[16]=dest_c[16] dest_c[15]=dest_c[15]
+ dest_c[14]=dest_c[14] dest_c[13]=dest_c[13] dest_c[12]=dest_c[12]
+ dest_c[11]=dest_c[11] dest_c[10]=dest_c[10] dest_c[9]=dest_c[9]
+ dest_c[8]=dest_c[8] dest_c[7]=dest_c[7] dest_c[6]=dest_c[6] dest_c[5]=dest_c[5]
+ dest_c[4]=dest_c[4] dest_c[3]=dest_c[3] dest_c[2]=dest_c[2] dest_c[1]=dest_c[1]
+ dest_c[0]=dest_c[0] dim_m[2]=dim_m[2] dim_m[1]=dim_m[1] dim_m[0]=dim_m[0]
+ dim_n[2]=dim_n[2] dim_n[1]=dim_n[1] dim_n[0]=dim_n[0] dim_k[2]=dim_k[2]
+ dim_k[1]=dim_k[1] dim_k[0]=dim_k[0] mode_unsigned=mode_unsigned
+ start_pulse=start_pulse done_i=seq_done error_i=seq_error error_code_i[2]=VSS
+ error_code_i[1]=VSS error_code_i[0]=seq_error_code[0] VDD=VDD VSS=VSS
+ ZCTSNET_21=ZCTSNET_38 gre_a_INV_123_0=pwdata[29] ZCTSNET_23=ZCTSNET_31
+ ZCTSNET_24=ZCTSNET_41 HFSNET_14=HFSNET_63 HFSNET_15=HFSNET_64
+ HFSNET_16=HFSNET_70 HFSNET_17=HFSNET_71 HFSNET_18=HFSNET_72 HFSNET_20=HFSNET_84
+ ZCTSNET_25=ZCTSNET_42 ZBUF_9_0=paddr[4] ZBUF_9_2=copt_net_233
+ ZBUF_253_2=pwdata[1] ZCTSNET_0=ZCTSNET_39 ZCTSNET_1=ZCTSNET_40
+ gre_a_INV_123_2=pwdata[27] ZCTSNET_3=ZCTSNET_43 gre_a_INV_119_2=pwdata[25]
+ gre_a_INV_97_2=pwdata[19] gre_a_INV_83_2=pwdata[17] gre_a_INV_130_2=pwdata[15]
Xu_seq unpu_seq $PINS ZCTSNET_202=ZCTSNET_45 rst_n=HFSNET_56 start=start_pulse
+ dim_m[2]=dim_m[2] dim_m[1]=dim_m[1] dim_m[0]=dim_m[0] dim_n[2]=dim_n[2]
+ dim_n[1]=dim_n[1] dim_n[0]=dim_n[0] dim_k[2]=dim_k[2] dim_k[1]=dim_k[1]
+ dim_k[0]=dim_k[0] mode_unsigned=mode_unsigned src_a[31]=src_a[31]
+ src_a[30]=src_a[30] src_a[29]=src_a[29] src_a[28]=src_a[28] src_a[27]=src_a[27]
+ src_a[26]=src_a[26] src_a[25]=src_a[25] src_a[24]=src_a[24] src_a[23]=src_a[23]
+ src_a[22]=src_a[22] src_a[21]=src_a[21] src_a[20]=src_a[20] src_a[19]=src_a[19]
+ src_a[18]=src_a[18] src_a[17]=src_a[17] src_a[16]=src_a[16] src_a[15]=src_a[15]
+ src_a[14]=src_a[14] src_a[13]=src_a[13] src_a[12]=src_a[12] src_a[11]=src_a[11]
+ src_a[10]=src_a[10] src_a[9]=src_a[9] src_a[8]=src_a[8] src_a[7]=src_a[7]
+ src_a[6]=src_a[6] src_a[5]=src_a[5] src_a[4]=src_a[4] src_a[3]=src_a[3]
+ src_a[2]=src_a[2] src_a[1]=src_a[1] src_a[0]=src_a[0] src_b[31]=src_b[31]
+ src_b[30]=src_b[30] src_b[29]=src_b[29] src_b[28]=src_b[28] src_b[27]=src_b[27]
+ src_b[26]=src_b[26] src_b[25]=src_b[25] src_b[24]=src_b[24] src_b[23]=src_b[23]
+ src_b[22]=src_b[22] src_b[21]=src_b[21] src_b[20]=src_b[20] src_b[19]=src_b[19]
+ src_b[18]=src_b[18] src_b[17]=src_b[17] src_b[16]=src_b[16] src_b[15]=src_b[15]
+ src_b[14]=src_b[14] src_b[13]=src_b[13] src_b[12]=src_b[12] src_b[11]=src_b[11]
+ src_b[10]=src_b[10] src_b[9]=src_b[9] src_b[8]=src_b[8] src_b[7]=src_b[7]
+ src_b[6]=src_b[6] src_b[5]=src_b[5] src_b[4]=src_b[4] src_b[3]=src_b[3]
+ src_b[2]=src_b[2] src_b[1]=src_b[1] src_b[0]=src_b[0] dest_c[31]=dest_c[31]
+ dest_c[30]=dest_c[30] dest_c[29]=dest_c[29] dest_c[28]=dest_c[28]
+ dest_c[27]=dest_c[27] dest_c[26]=dest_c[26] dest_c[25]=dest_c[25]
+ dest_c[24]=dest_c[24] dest_c[23]=dest_c[23] dest_c[22]=dest_c[22]
+ dest_c[21]=dest_c[21] dest_c[20]=dest_c[20] dest_c[19]=dest_c[19]
+ dest_c[18]=dest_c[18] dest_c[17]=dest_c[17] dest_c[16]=dest_c[16]
+ dest_c[15]=dest_c[15] dest_c[14]=dest_c[14] dest_c[13]=dest_c[13]
+ dest_c[12]=dest_c[12] dest_c[11]=dest_c[11] dest_c[10]=dest_c[10]
+ dest_c[9]=dest_c[9] dest_c[8]=dest_c[8] dest_c[7]=dest_c[7] dest_c[6]=dest_c[6]
+ dest_c[5]=dest_c[5] dest_c[4]=dest_c[4] dest_c[3]=dest_c[3] dest_c[2]=dest_c[2]
+ dest_c[1]=dest_c[1] dest_c[0]=dest_c[0] c_dst[511]=c_dst[511]
+ c_dst[510]=c_dst[510] c_dst[509]=c_dst[509] c_dst[508]=c_dst[508]
+ c_dst[507]=c_dst[507] c_dst[506]=c_dst[506] c_dst[505]=c_dst[505]
+ c_dst[504]=c_dst[504] c_dst[503]=c_dst[503] c_dst[502]=c_dst[502]
+ c_dst[501]=c_dst[501] c_dst[500]=c_dst[500] c_dst[499]=c_dst[499]
+ c_dst[498]=c_dst[498] c_dst[497]=c_dst[497] c_dst[496]=c_dst[496]
+ c_dst[495]=c_dst[495] c_dst[494]=c_dst[494] c_dst[493]=c_dst[493]
+ c_dst[492]=c_dst[492] c_dst[491]=c_dst[491] c_dst[490]=c_dst[490]
+ c_dst[489]=c_dst[489] c_dst[488]=c_dst[488] c_dst[487]=c_dst[487]
+ c_dst[486]=c_dst[486] c_dst[485]=c_dst[485] c_dst[484]=c_dst[484]
+ c_dst[483]=c_dst[483] c_dst[482]=c_dst[482] c_dst[481]=c_dst[481]
+ c_dst[480]=c_dst[480] c_dst[479]=c_dst[479] c_dst[478]=c_dst[478]
+ c_dst[477]=c_dst[477] c_dst[476]=c_dst[476] c_dst[475]=c_dst[475]
+ c_dst[474]=c_dst[474] c_dst[473]=c_dst[473] c_dst[472]=c_dst[472]
+ c_dst[471]=c_dst[471] c_dst[470]=c_dst[470] c_dst[469]=c_dst[469]
+ c_dst[468]=c_dst[468] c_dst[467]=c_dst[467] c_dst[466]=c_dst[466]
+ c_dst[465]=c_dst[465] c_dst[464]=c_dst[464] c_dst[463]=c_dst[463]
+ c_dst[462]=c_dst[462] c_dst[461]=c_dst[461] c_dst[460]=c_dst[460]
+ c_dst[459]=c_dst[459] c_dst[458]=c_dst[458] c_dst[457]=c_dst[457]
+ c_dst[456]=c_dst[456] c_dst[455]=c_dst[455] c_dst[454]=c_dst[454]
+ c_dst[453]=c_dst[453] c_dst[452]=c_dst[452] c_dst[451]=c_dst[451]
+ c_dst[450]=c_dst[450] c_dst[449]=c_dst[449] c_dst[448]=c_dst[448]
+ c_dst[447]=c_dst[447] c_dst[446]=c_dst[446] c_dst[445]=c_dst[445]
+ c_dst[444]=c_dst[444] c_dst[443]=c_dst[443] c_dst[442]=c_dst[442]
+ c_dst[441]=c_dst[441] c_dst[440]=c_dst[440] c_dst[439]=c_dst[439]
+ c_dst[438]=c_dst[438] c_dst[437]=c_dst[437] c_dst[436]=c_dst[436]
+ c_dst[435]=c_dst[435] c_dst[434]=c_dst[434] c_dst[433]=c_dst[433]
+ c_dst[432]=c_dst[432] c_dst[431]=c_dst[431] c_dst[430]=c_dst[430]
+ c_dst[429]=c_dst[429] c_dst[428]=c_dst[428] c_dst[427]=c_dst[427]
+ c_dst[426]=c_dst[426] c_dst[425]=c_dst[425] c_dst[424]=c_dst[424]
+ c_dst[423]=c_dst[423] c_dst[422]=c_dst[422] c_dst[421]=c_dst[421]
+ c_dst[420]=c_dst[420] c_dst[419]=c_dst[419] c_dst[418]=c_dst[418]
+ c_dst[417]=c_dst[417] c_dst[416]=c_dst[416] c_dst[415]=c_dst[415]
+ c_dst[414]=c_dst[414] c_dst[413]=c_dst[413] c_dst[412]=c_dst[412]
+ c_dst[411]=c_dst[411] c_dst[410]=c_dst[410] c_dst[409]=c_dst[409]
+ c_dst[408]=c_dst[408] c_dst[407]=c_dst[407] c_dst[406]=c_dst[406]
+ c_dst[405]=c_dst[405] c_dst[404]=c_dst[404] c_dst[403]=c_dst[403]
+ c_dst[402]=c_dst[402] c_dst[401]=c_dst[401] c_dst[400]=c_dst[400]
+ c_dst[399]=c_dst[399] c_dst[398]=c_dst[398] c_dst[397]=c_dst[397]
+ c_dst[396]=c_dst[396] c_dst[395]=c_dst[395] c_dst[394]=c_dst[394]
+ c_dst[393]=c_dst[393] c_dst[392]=c_dst[392] c_dst[391]=c_dst[391]
+ c_dst[390]=c_dst[390] c_dst[389]=c_dst[389] c_dst[388]=c_dst[388]
+ c_dst[387]=c_dst[387] c_dst[386]=c_dst[386] c_dst[385]=c_dst[385]
+ c_dst[384]=c_dst[384] c_dst[383]=c_dst[383] c_dst[382]=c_dst[382]
+ c_dst[381]=c_dst[381] c_dst[380]=c_dst[380] c_dst[379]=c_dst[379]
+ c_dst[378]=c_dst[378] c_dst[377]=c_dst[377] c_dst[376]=c_dst[376]
+ c_dst[375]=c_dst[375] c_dst[374]=c_dst[374] c_dst[373]=c_dst[373]
+ c_dst[372]=c_dst[372] c_dst[371]=c_dst[371] c_dst[370]=c_dst[370]
+ c_dst[369]=c_dst[369] c_dst[368]=c_dst[368] c_dst[367]=c_dst[367]
+ c_dst[366]=c_dst[366] c_dst[365]=c_dst[365] c_dst[364]=c_dst[364]
+ c_dst[363]=c_dst[363] c_dst[362]=c_dst[362] c_dst[361]=c_dst[361]
+ c_dst[360]=c_dst[360] c_dst[359]=c_dst[359] c_dst[358]=c_dst[358]
+ c_dst[357]=c_dst[357] c_dst[356]=c_dst[356] c_dst[355]=c_dst[355]
+ c_dst[354]=c_dst[354] c_dst[353]=c_dst[353] c_dst[352]=c_dst[352]
+ c_dst[351]=c_dst[351] c_dst[350]=c_dst[350] c_dst[349]=c_dst[349]
+ c_dst[348]=c_dst[348] c_dst[347]=c_dst[347] c_dst[346]=c_dst[346]
+ c_dst[345]=c_dst[345] c_dst[344]=c_dst[344] c_dst[343]=c_dst[343]
+ c_dst[342]=c_dst[342] c_dst[341]=c_dst[341] c_dst[340]=c_dst[340]
+ c_dst[339]=c_dst[339] c_dst[338]=c_dst[338] c_dst[337]=c_dst[337]
+ c_dst[336]=c_dst[336] c_dst[335]=c_dst[335] c_dst[334]=c_dst[334]
+ c_dst[333]=c_dst[333] c_dst[332]=c_dst[332] c_dst[331]=c_dst[331]
+ c_dst[330]=c_dst[330] c_dst[329]=c_dst[329] c_dst[328]=c_dst[328]
+ c_dst[327]=c_dst[327] c_dst[326]=c_dst[326] c_dst[325]=c_dst[325]
+ c_dst[324]=c_dst[324] c_dst[323]=c_dst[323] c_dst[322]=c_dst[322]
+ c_dst[321]=c_dst[321] c_dst[320]=c_dst[320] c_dst[319]=c_dst[319]
+ c_dst[318]=c_dst[318] c_dst[317]=c_dst[317] c_dst[316]=c_dst[316]
+ c_dst[315]=c_dst[315] c_dst[314]=c_dst[314] c_dst[313]=c_dst[313]
+ c_dst[312]=c_dst[312] c_dst[311]=c_dst[311] c_dst[310]=c_dst[310]
+ c_dst[309]=c_dst[309] c_dst[308]=c_dst[308] c_dst[307]=c_dst[307]
+ c_dst[306]=c_dst[306] c_dst[305]=c_dst[305] c_dst[304]=c_dst[304]
+ c_dst[303]=c_dst[303] c_dst[302]=c_dst[302] c_dst[301]=c_dst[301]
+ c_dst[300]=c_dst[300] c_dst[299]=c_dst[299] c_dst[298]=c_dst[298]
+ c_dst[297]=c_dst[297] c_dst[296]=c_dst[296] c_dst[295]=c_dst[295]
+ c_dst[294]=c_dst[294] c_dst[293]=c_dst[293] c_dst[292]=c_dst[292]
+ c_dst[291]=c_dst[291] c_dst[290]=c_dst[290] c_dst[289]=c_dst[289]
+ c_dst[288]=c_dst[288] c_dst[287]=c_dst[287] c_dst[286]=c_dst[286]
+ c_dst[285]=c_dst[285] c_dst[284]=c_dst[284] c_dst[283]=c_dst[283]
+ c_dst[282]=c_dst[282] c_dst[281]=c_dst[281] c_dst[280]=c_dst[280]
+ c_dst[279]=c_dst[279] c_dst[278]=c_dst[278] c_dst[277]=c_dst[277]
+ c_dst[276]=c_dst[276] c_dst[275]=c_dst[275] c_dst[274]=c_dst[274]
+ c_dst[273]=c_dst[273] c_dst[272]=c_dst[272] c_dst[271]=c_dst[271]
+ c_dst[270]=c_dst[270] c_dst[269]=c_dst[269] c_dst[268]=c_dst[268]
+ c_dst[267]=c_dst[267] c_dst[266]=c_dst[266] c_dst[265]=c_dst[265]
+ c_dst[264]=c_dst[264] c_dst[263]=c_dst[263] c_dst[262]=c_dst[262]
+ c_dst[261]=c_dst[261] c_dst[260]=c_dst[260] c_dst[259]=c_dst[259]
+ c_dst[258]=c_dst[258] c_dst[257]=c_dst[257] c_dst[256]=c_dst[256]
+ c_dst[255]=c_dst[255] c_dst[254]=c_dst[254] c_dst[253]=c_dst[253]
+ c_dst[252]=c_dst[252] c_dst[251]=c_dst[251] c_dst[250]=c_dst[250]
+ c_dst[249]=c_dst[249] c_dst[248]=c_dst[248] c_dst[247]=c_dst[247]
+ c_dst[246]=c_dst[246] c_dst[245]=c_dst[245] c_dst[244]=c_dst[244]
+ c_dst[243]=c_dst[243] c_dst[242]=c_dst[242] c_dst[241]=c_dst[241]
+ c_dst[240]=c_dst[240] c_dst[239]=c_dst[239] c_dst[238]=c_dst[238]
+ c_dst[237]=c_dst[237] c_dst[236]=c_dst[236] c_dst[235]=c_dst[235]
+ c_dst[234]=c_dst[234] c_dst[233]=c_dst[233] c_dst[232]=c_dst[232]
+ c_dst[231]=c_dst[231] c_dst[230]=c_dst[230] c_dst[229]=c_dst[229]
+ c_dst[228]=c_dst[228] c_dst[227]=c_dst[227] c_dst[226]=c_dst[226]
+ c_dst[225]=c_dst[225] c_dst[224]=c_dst[224] c_dst[223]=c_dst[223]
+ c_dst[222]=c_dst[222] c_dst[221]=c_dst[221] c_dst[220]=c_dst[220]
+ c_dst[219]=c_dst[219] c_dst[218]=c_dst[218] c_dst[217]=c_dst[217]
+ c_dst[216]=c_dst[216] c_dst[215]=c_dst[215] c_dst[214]=c_dst[214]
+ c_dst[213]=c_dst[213] c_dst[212]=c_dst[212] c_dst[211]=c_dst[211]
+ c_dst[210]=c_dst[210] c_dst[209]=c_dst[209] c_dst[208]=c_dst[208]
+ c_dst[207]=c_dst[207] c_dst[206]=c_dst[206] c_dst[205]=c_dst[205]
+ c_dst[204]=c_dst[204] c_dst[203]=c_dst[203] c_dst[202]=c_dst[202]
+ c_dst[201]=c_dst[201] c_dst[200]=c_dst[200] c_dst[199]=c_dst[199]
+ c_dst[198]=c_dst[198] c_dst[197]=c_dst[197] c_dst[196]=c_dst[196]
+ c_dst[195]=c_dst[195] c_dst[194]=c_dst[194] c_dst[193]=c_dst[193]
+ c_dst[192]=c_dst[192] c_dst[191]=c_dst[191] c_dst[190]=c_dst[190]
+ c_dst[189]=c_dst[189] c_dst[188]=c_dst[188] c_dst[187]=c_dst[187]
+ c_dst[186]=c_dst[186] c_dst[185]=c_dst[185] c_dst[184]=c_dst[184]
+ c_dst[183]=c_dst[183] c_dst[182]=c_dst[182] c_dst[181]=c_dst[181]
+ c_dst[180]=c_dst[180] c_dst[179]=c_dst[179] c_dst[178]=c_dst[178]
+ c_dst[177]=c_dst[177] c_dst[176]=c_dst[176] c_dst[175]=c_dst[175]
+ c_dst[174]=c_dst[174] c_dst[173]=c_dst[173] c_dst[172]=c_dst[172]
+ c_dst[171]=c_dst[171] c_dst[170]=c_dst[170] c_dst[169]=c_dst[169]
+ c_dst[168]=c_dst[168] c_dst[167]=c_dst[167] c_dst[166]=c_dst[166]
+ c_dst[165]=c_dst[165] c_dst[164]=c_dst[164] c_dst[163]=c_dst[163]
+ c_dst[162]=c_dst[162] c_dst[161]=c_dst[161] c_dst[160]=c_dst[160]
+ c_dst[159]=c_dst[159] c_dst[158]=c_dst[158] c_dst[157]=c_dst[157]
+ c_dst[156]=c_dst[156] c_dst[155]=c_dst[155] c_dst[154]=c_dst[154]
+ c_dst[153]=c_dst[153] c_dst[152]=c_dst[152] c_dst[151]=c_dst[151]
+ c_dst[150]=c_dst[150] c_dst[149]=c_dst[149] c_dst[148]=c_dst[148]
+ c_dst[147]=c_dst[147] c_dst[146]=c_dst[146] c_dst[145]=c_dst[145]
+ c_dst[144]=c_dst[144] c_dst[143]=c_dst[143] c_dst[142]=c_dst[142]
+ c_dst[141]=c_dst[141] c_dst[140]=c_dst[140] c_dst[139]=c_dst[139]
+ c_dst[138]=c_dst[138] c_dst[137]=c_dst[137] c_dst[136]=c_dst[136]
+ c_dst[135]=c_dst[135] c_dst[134]=c_dst[134] c_dst[133]=c_dst[133]
+ c_dst[132]=c_dst[132] c_dst[131]=c_dst[131] c_dst[130]=c_dst[130]
+ c_dst[129]=c_dst[129] c_dst[128]=c_dst[128] c_dst[127]=c_dst[127]
+ c_dst[126]=c_dst[126] c_dst[125]=c_dst[125] c_dst[124]=c_dst[124]
+ c_dst[123]=c_dst[123] c_dst[122]=c_dst[122] c_dst[121]=c_dst[121]
+ c_dst[120]=c_dst[120] c_dst[119]=c_dst[119] c_dst[118]=c_dst[118]
+ c_dst[117]=c_dst[117] c_dst[116]=c_dst[116] c_dst[115]=c_dst[115]
+ c_dst[114]=c_dst[114] c_dst[113]=c_dst[113] c_dst[112]=c_dst[112]
+ c_dst[111]=c_dst[111] c_dst[110]=c_dst[110] c_dst[109]=c_dst[109]
+ c_dst[108]=c_dst[108] c_dst[107]=c_dst[107] c_dst[106]=c_dst[106]
+ c_dst[105]=c_dst[105] c_dst[104]=c_dst[104] c_dst[103]=c_dst[103]
+ c_dst[102]=c_dst[102] c_dst[101]=c_dst[101] c_dst[100]=c_dst[100]
+ c_dst[99]=c_dst[99] c_dst[98]=c_dst[98] c_dst[97]=c_dst[97] c_dst[96]=c_dst[96]
+ c_dst[95]=c_dst[95] c_dst[94]=c_dst[94] c_dst[93]=c_dst[93] c_dst[92]=c_dst[92]
+ c_dst[91]=c_dst[91] c_dst[90]=c_dst[90] c_dst[89]=c_dst[89] c_dst[88]=c_dst[88]
+ c_dst[87]=c_dst[87] c_dst[86]=c_dst[86] c_dst[85]=c_dst[85] c_dst[84]=c_dst[84]
+ c_dst[83]=c_dst[83] c_dst[82]=c_dst[82] c_dst[81]=c_dst[81] c_dst[80]=c_dst[80]
+ c_dst[79]=c_dst[79] c_dst[78]=c_dst[78] c_dst[77]=c_dst[77] c_dst[76]=c_dst[76]
+ c_dst[75]=c_dst[75] c_dst[74]=c_dst[74] c_dst[73]=c_dst[73] c_dst[72]=c_dst[72]
+ c_dst[71]=c_dst[71] c_dst[70]=c_dst[70] c_dst[69]=c_dst[69] c_dst[68]=c_dst[68]
+ c_dst[67]=c_dst[67] c_dst[66]=c_dst[66] c_dst[65]=c_dst[65] c_dst[64]=c_dst[64]
+ c_dst[63]=c_dst[63] c_dst[62]=c_dst[62] c_dst[61]=c_dst[61] c_dst[60]=c_dst[60]
+ c_dst[59]=c_dst[59] c_dst[58]=c_dst[58] c_dst[57]=c_dst[57] c_dst[56]=c_dst[56]
+ c_dst[55]=c_dst[55] c_dst[54]=c_dst[54] c_dst[53]=c_dst[53] c_dst[52]=c_dst[52]
+ c_dst[51]=c_dst[51] c_dst[50]=c_dst[50] c_dst[49]=c_dst[49] c_dst[48]=c_dst[48]
+ c_dst[47]=c_dst[47] c_dst[46]=c_dst[46] c_dst[45]=c_dst[45] c_dst[44]=c_dst[44]
+ c_dst[43]=c_dst[43] c_dst[42]=c_dst[42] c_dst[41]=c_dst[41] c_dst[40]=c_dst[40]
+ c_dst[39]=c_dst[39] c_dst[38]=c_dst[38] c_dst[37]=c_dst[37] c_dst[36]=c_dst[36]
+ c_dst[35]=c_dst[35] c_dst[34]=c_dst[34] c_dst[33]=c_dst[33] c_dst[32]=c_dst[32]
+ c_dst[31]=c_dst[31] c_dst[30]=c_dst[30] c_dst[29]=c_dst[29] c_dst[28]=c_dst[28]
+ c_dst[27]=c_dst[27] c_dst[26]=c_dst[26] c_dst[25]=c_dst[25] c_dst[24]=c_dst[24]
+ c_dst[23]=c_dst[23] c_dst[22]=c_dst[22] c_dst[21]=c_dst[21] c_dst[20]=c_dst[20]
+ c_dst[19]=c_dst[19] c_dst[18]=c_dst[18] c_dst[17]=c_dst[17] c_dst[16]=c_dst[16]
+ c_dst[15]=c_dst[15] c_dst[14]=c_dst[14] c_dst[13]=c_dst[13] c_dst[12]=c_dst[12]
+ c_dst[11]=c_dst[11] c_dst[10]=c_dst[10] c_dst[9]=c_dst[9] c_dst[8]=c_dst[8]
+ c_dst[7]=c_dst[7] c_dst[6]=c_dst[6] c_dst[5]=c_dst[5] c_dst[4]=c_dst[4]
+ c_dst[3]=c_dst[3] c_dst[2]=c_dst[2] c_dst[1]=c_dst[1] c_dst[0]=c_dst[0]
+ done=seq_done error=seq_error error_code[2]=SYNOPSYS_UNCONNECTED_29
+ error_code[1]=SYNOPSYS_UNCONNECTED_30 error_code[0]=seq_error_code[0]
+ array_en=array_en mode_unsigned_o=mode_unsigned_o job_start=job_start
+ job_kind[1]=job_kind[1] job_kind[0]=job_kind[0]
+ job_base_addr[31]=job_base_addr[31] job_base_addr[30]=job_base_addr[30]
+ job_base_addr[29]=job_base_addr[29] job_base_addr[28]=job_base_addr[28]
+ job_base_addr[27]=job_base_addr[27] job_base_addr[26]=job_base_addr[26]
+ job_base_addr[25]=job_base_addr[25] job_base_addr[24]=job_base_addr[24]
+ job_base_addr[23]=job_base_addr[23] job_base_addr[22]=job_base_addr[22]
+ job_base_addr[21]=job_base_addr[21] job_base_addr[20]=job_base_addr[20]
+ job_base_addr[19]=job_base_addr[19] job_base_addr[18]=job_base_addr[18]
+ job_base_addr[17]=job_base_addr[17] job_base_addr[16]=job_base_addr[16]
+ job_base_addr[15]=job_base_addr[15] job_base_addr[14]=job_base_addr[14]
+ job_base_addr[13]=job_base_addr[13] job_base_addr[12]=job_base_addr[12]
+ job_base_addr[11]=job_base_addr[11] job_base_addr[10]=job_base_addr[10]
+ job_base_addr[9]=job_base_addr[9] job_base_addr[8]=job_base_addr[8]
+ job_base_addr[7]=job_base_addr[7] job_base_addr[6]=job_base_addr[6]
+ job_base_addr[5]=job_base_addr[5] job_base_addr[4]=job_base_addr[4]
+ job_base_addr[3]=job_base_addr[3] job_base_addr[2]=job_base_addr[2]
+ job_base_addr[1]=job_base_addr[1] job_base_addr[0]=job_base_addr[0]
+ job_m[2]=job_m[2] job_m[1]=job_m[1] job_m[0]=job_m[0] job_n[2]=job_n[2]
+ job_n[1]=job_n[1] job_n[0]=job_n[0] job_k[2]=job_k[2] job_k[1]=job_k[1]
+ job_k[0]=job_k[0] job_done=job_done w_swap=w_swap a_swap=a_swap
+ rd_row[1]=rd_row[1] rd_row[0]=rd_row[0] c_in[127]=c_in[127] c_in[126]=c_in[126]
+ c_in[125]=c_in[125] c_in[124]=c_in[124] c_in[123]=c_in[123] c_in[122]=c_in[122]
+ c_in[121]=c_in[121] c_in[120]=c_in[120] c_in[119]=c_in[119] c_in[118]=c_in[118]
+ c_in[117]=c_in[117] c_in[116]=c_in[116] c_in[115]=c_in[115] c_in[114]=c_in[114]
+ c_in[113]=c_in[113] c_in[112]=c_in[112] c_in[111]=c_in[111] c_in[110]=c_in[110]
+ c_in[109]=c_in[109] c_in[108]=c_in[108] c_in[107]=c_in[107] c_in[106]=c_in[106]
+ c_in[105]=c_in[105] c_in[104]=c_in[104] c_in[103]=c_in[103] c_in[102]=c_in[102]
+ c_in[101]=c_in[101] c_in[100]=c_in[100] c_in[99]=c_in[99] c_in[98]=c_in[98]
+ c_in[97]=c_in[97] c_in[96]=c_in[96] c_in[95]=c_in[95] c_in[94]=c_in[94]
+ c_in[93]=c_in[93] c_in[92]=c_in[92] c_in[91]=c_in[91] c_in[90]=c_in[90]
+ c_in[89]=c_in[89] c_in[88]=c_in[88] c_in[87]=c_in[87] c_in[86]=c_in[86]
+ c_in[85]=c_in[85] c_in[84]=c_in[84] c_in[83]=c_in[83] c_in[82]=c_in[82]
+ c_in[81]=c_in[81] c_in[80]=c_in[80] c_in[79]=c_in[79] c_in[78]=c_in[78]
+ c_in[77]=c_in[77] c_in[76]=c_in[76] c_in[75]=c_in[75] c_in[74]=c_in[74]
+ c_in[73]=c_in[73] c_in[72]=c_in[72] c_in[71]=c_in[71] c_in[70]=c_in[70]
+ c_in[69]=c_in[69] c_in[68]=c_in[68] c_in[67]=c_in[67] c_in[66]=c_in[66]
+ c_in[65]=c_in[65] c_in[64]=c_in[64] c_in[63]=c_in[63] c_in[62]=c_in[62]
+ c_in[61]=c_in[61] c_in[60]=c_in[60] c_in[59]=c_in[59] c_in[58]=c_in[58]
+ c_in[57]=c_in[57] c_in[56]=c_in[56] c_in[55]=c_in[55] c_in[54]=c_in[54]
+ c_in[53]=c_in[53] c_in[52]=c_in[52] c_in[51]=c_in[51] c_in[50]=c_in[50]
+ c_in[49]=c_in[49] c_in[48]=c_in[48] c_in[47]=c_in[47] c_in[46]=c_in[46]
+ c_in[45]=c_in[45] c_in[44]=c_in[44] c_in[43]=c_in[43] c_in[42]=c_in[42]
+ c_in[41]=c_in[41] c_in[40]=c_in[40] c_in[39]=c_in[39] c_in[38]=c_in[38]
+ c_in[37]=c_in[37] c_in[36]=c_in[36] c_in[35]=c_in[35] c_in[34]=c_in[34]
+ c_in[33]=c_in[33] c_in[32]=c_in[32] c_in[31]=c_in[31] c_in[30]=c_in[30]
+ c_in[29]=c_in[29] c_in[28]=c_in[28] c_in[27]=c_in[27] c_in[26]=c_in[26]
+ c_in[25]=c_in[25] c_in[24]=c_in[24] c_in[23]=c_in[23] c_in[22]=c_in[22]
+ c_in[21]=c_in[21] c_in[20]=c_in[20] c_in[19]=c_in[19] c_in[18]=c_in[18]
+ c_in[17]=c_in[17] c_in[16]=c_in[16] c_in[15]=c_in[15] c_in[14]=c_in[14]
+ c_in[13]=c_in[13] c_in[12]=c_in[12] c_in[11]=c_in[11] c_in[10]=c_in[10]
+ c_in[9]=c_in[9] c_in[8]=c_in[8] c_in[7]=c_in[7] c_in[6]=c_in[6] c_in[5]=c_in[5]
+ c_in[4]=c_in[4] c_in[3]=c_in[3] c_in[2]=c_in[2] c_in[1]=c_in[1] c_in[0]=c_in[0]
+ VDD=VDD VSS=VSS ZCTSNET_204=ZCTSNET_34 ZCTSNET_206=ZCTSNET_28
+ ZCTSNET_207=ZCTSNET_14 ZCTSNET_208=ZCTSNET_27 ZCTSNET_8=ZCTSNET_17
+ ZCTSNET_210=ZCTSNET_26 ZCTSNET_211=ZCTSNET_25 ZCTSNET_212=ZCTSNET_38
+ ZCTSNET_216=ZCTSNET_33 ZCTSNET_217=ZCTSNET_31 ZCTSNET_218=ZCTSNET_41
+ ZCTSNET_219=ZCTSNET_37 ZCTSNET_220=ZCTSNET_36 ZCTSNET_221=ZCTSNET_12
+ HFSNET_171=HFSNET_38 HFSNET_174=HFSNET_57 HFSNET_176=HFSNET_58
+ HFSNET_177=HFSNET_59 HFSNET_178=HFSNET_60 HFSNET_180=HFSNET_61
+ HFSNET_183=HFSNET_62 HFSNET_184=HFSNET_63 HFSNET_185=HFSNET_64
+ HFSNET_186=HFSNET_65 HFSNET_188=HFSNET_66 HFSNET_191=HFSNET_67
+ HFSNET_194=HFSNET_68 HFSNET_195=HFSNET_69 HFSNET_196=HFSNET_70
+ HFSNET_199=HFSNET_72 HFSNET_200=HFSNET_73 HFSNET_201=HFSNET_84
+ ZCTSNET_4=ZCTSNET_30 ZCTSNET_6=ZCTSNET_43 ZCTSNET_11=ZCTSNET_39
+ ZCTSNET_12=ZCTSNET_40 ZCTSNET_13=ZCTSNET_42 ZCTSNET_17=ZCTSNET_48
+ ZCTSNET_18=ZCTSNET_50
Xu_dma unpu_dma $PINS ZCTSNET_49=ZCTSNET_55 rst_n=HFSNET_62
+ dma_addr[31]=aps_rename_2_ dma_addr[30]=dma_addr[30] dma_addr[29]=dma_addr[29]
+ dma_addr[28]=dma_addr[28] dma_addr[27]=dma_addr[27] dma_addr[26]=dma_addr[26]
+ dma_addr[25]=dma_addr[25] dma_addr[24]=dma_addr[24] dma_addr[23]=dma_addr[23]
+ dma_addr[22]=dma_addr[22] dma_addr[21]=dma_addr[21] dma_addr[20]=dma_addr[20]
+ dma_addr[19]=dma_addr[19] dma_addr[18]=dma_addr[18] dma_addr[17]=dma_addr[17]
+ dma_addr[16]=dma_addr[16] dma_addr[15]=dma_addr[15] dma_addr[14]=dma_addr[14]
+ dma_addr[13]=aps_rename_3_ dma_addr[12]=dma_addr[12] dma_addr[11]=aps_rename_4_
+ dma_addr[10]=dma_addr[10] dma_addr[9]=dma_addr[9] dma_addr[8]=dma_addr[8]
+ dma_addr[7]=dma_addr[7] dma_addr[6]=dma_addr[6] dma_addr[5]=dma_addr[5]
+ dma_addr[4]=dma_addr[4] dma_addr[3]=dma_addr[3] dma_addr[2]=dma_addr[2]
+ dma_addr[1]=aps_rename_6_ dma_addr[0]=dma_addr[0] dma_wdata[31]=dma_wdata[31]
+ dma_wdata[30]=dma_wdata[30] dma_wdata[29]=dma_wdata[29]
+ dma_wdata[28]=dma_wdata[28] dma_wdata[27]=dma_wdata[27]
+ dma_wdata[26]=dma_wdata[26] dma_wdata[25]=dma_wdata[25]
+ dma_wdata[24]=dma_wdata[24] dma_wdata[23]=dma_wdata[23]
+ dma_wdata[22]=dma_wdata[22] dma_wdata[21]=dma_wdata[21]
+ dma_wdata[20]=dma_wdata[20] dma_wdata[19]=dma_wdata[19]
+ dma_wdata[18]=dma_wdata[18] dma_wdata[17]=dma_wdata[17]
+ dma_wdata[16]=dma_wdata[16] dma_wdata[15]=dma_wdata[15]
+ dma_wdata[14]=dma_wdata[14] dma_wdata[13]=dma_wdata[13]
+ dma_wdata[12]=dma_wdata[12] dma_wdata[11]=dma_wdata[11]
+ dma_wdata[10]=dma_wdata[10] dma_wdata[9]=dma_wdata[9] dma_wdata[8]=dma_wdata[8]
+ dma_wdata[7]=dma_wdata[7] dma_wdata[6]=dma_wdata[6] dma_wdata[5]=dma_wdata[5]
+ dma_wdata[4]=dma_wdata[4] dma_wdata[3]=dma_wdata[3] dma_wdata[2]=dma_wdata[2]
+ dma_wdata[1]=dma_wdata[1] dma_wdata[0]=dma_wdata[0]
+ dma_rdata[31]=earlybuf_dma_rdata_31__27_a1_n
+ dma_rdata[30]=earlybuf_dma_rdata_30__28_a1_n
+ dma_rdata[29]=earlybuf_dma_rdata_29__29_a1_n
+ dma_rdata[28]=earlybuf_dma_rdata_28__30_a1_n
+ dma_rdata[27]=earlybuf_dma_rdata_27__31_a1_n
+ dma_rdata[26]=earlybuf_dma_rdata_26__32_a1_n
+ dma_rdata[25]=earlybuf_dma_rdata_25__33_a1_n
+ dma_rdata[24]=earlybuf_dma_rdata_24__34_a1_n
+ dma_rdata[23]=earlybuf_dma_rdata_23__35_a1_n
+ dma_rdata[22]=earlybuf_dma_rdata_22__36_a1_n dma_rdata[21]=dma_rdata[21]
+ dma_rdata[20]=earlybuf_dma_rdata_20__37_a1_n
+ dma_rdata[19]=earlybuf_dma_rdata_19__38_a1_n
+ dma_rdata[18]=earlybuf_dma_rdata_18__39_a1_n
+ dma_rdata[17]=earlybuf_dma_rdata_17__40_a1_n
+ dma_rdata[16]=earlybuf_dma_rdata_16__41_a1_n
+ dma_rdata[15]=earlybuf_dma_rdata_15__42_a1_n
+ dma_rdata[14]=earlybuf_dma_rdata_14__43_a1_n
+ dma_rdata[13]=earlybuf_dma_rdata_13__44_a1_n
+ dma_rdata[12]=earlybuf_dma_rdata_12__45_a1_n dma_rdata[11]=dma_rdata[11]
+ dma_rdata[10]=earlybuf_dma_rdata_10__46_a1_n
+ dma_rdata[9]=earlybuf_dma_rdata_9__47_a1_n
+ dma_rdata[8]=earlybuf_dma_rdata_8__48_a1_n
+ dma_rdata[7]=earlybuf_dma_rdata_7__49_a1_n
+ dma_rdata[6]=earlybuf_dma_rdata_6__50_a1_n
+ dma_rdata[5]=earlybuf_dma_rdata_5__51_a1_n
+ dma_rdata[4]=earlybuf_dma_rdata_4__52_a1_n dma_rdata[3]=dma_rdata[3]
+ dma_rdata[2]=dma_rdata[2] dma_rdata[1]=dma_rdata[1]
+ dma_rdata[0]=earlybuf_dma_rdata_0__53_a1_n dma_wstrb[3]=dma_wstrb[3]
+ dma_wstrb[2]=dma_wstrb[2] dma_wstrb[1]=dma_wstrb[1] dma_wstrb[0]=dma_wstrb[0]
+ dma_valid=aps_rename_140_ dma_ready=earlybuf_dma_ready_54_a1_n
+ job_start=job_start job_kind[1]=job_kind[1] job_kind[0]=job_kind[0]
+ job_base_addr[31]=job_base_addr[31] job_base_addr[30]=job_base_addr[30]
+ job_base_addr[29]=job_base_addr[29] job_base_addr[28]=job_base_addr[28]
+ job_base_addr[27]=job_base_addr[27] job_base_addr[26]=job_base_addr[26]
+ job_base_addr[25]=job_base_addr[25] job_base_addr[24]=job_base_addr[24]
+ job_base_addr[23]=job_base_addr[23] job_base_addr[22]=job_base_addr[22]
+ job_base_addr[21]=job_base_addr[21] job_base_addr[20]=job_base_addr[20]
+ job_base_addr[19]=job_base_addr[19] job_base_addr[18]=job_base_addr[18]
+ job_base_addr[17]=job_base_addr[17] job_base_addr[16]=job_base_addr[16]
+ job_base_addr[15]=job_base_addr[15] job_base_addr[14]=job_base_addr[14]
+ job_base_addr[13]=job_base_addr[13] job_base_addr[12]=job_base_addr[12]
+ job_base_addr[11]=job_base_addr[11] job_base_addr[10]=job_base_addr[10]
+ job_base_addr[9]=job_base_addr[9] job_base_addr[8]=job_base_addr[8]
+ job_base_addr[7]=job_base_addr[7] job_base_addr[6]=job_base_addr[6]
+ job_base_addr[5]=job_base_addr[5] job_base_addr[4]=job_base_addr[4]
+ job_base_addr[3]=job_base_addr[3] job_base_addr[2]=job_base_addr[2]
+ job_base_addr[1]=job_base_addr[1] job_base_addr[0]=job_base_addr[0]
+ job_m[2]=job_m[2] job_m[1]=job_m[1] job_m[0]=job_m[0] job_n[2]=job_n[2]
+ job_n[1]=job_n[1] job_n[0]=job_n[0] job_k[2]=job_k[2] job_k[1]=job_k[1]
+ job_k[0]=job_k[0] job_done=job_done a_load_start=a_load_start
+ a_load_m[2]=a_load_m[2] a_load_m[1]=a_load_m[1] a_load_m[0]=a_load_m[0]
+ a_load_k[2]=a_load_k[2] a_load_k[1]=a_load_k[1] a_load_k[0]=a_load_k[0]
+ a_load_row[31]=a_load_row[31] a_load_row[30]=a_load_row[30]
+ a_load_row[29]=a_load_row[29] a_load_row[28]=a_load_row[28]
+ a_load_row[27]=a_load_row[27] a_load_row[26]=a_load_row[26]
+ a_load_row[25]=a_load_row[25] a_load_row[24]=a_load_row[24]
+ a_load_row[23]=a_load_row[23] a_load_row[22]=a_load_row[22]
+ a_load_row[21]=a_load_row[21] a_load_row[20]=a_load_row[20]
+ a_load_row[19]=a_load_row[19] a_load_row[18]=a_load_row[18]
+ a_load_row[17]=a_load_row[17] a_load_row[16]=a_load_row[16]
+ a_load_row[15]=a_load_row[15] a_load_row[14]=a_load_row[14]
+ a_load_row[13]=a_load_row[13] a_load_row[12]=a_load_row[12]
+ a_load_row[11]=a_load_row[11] a_load_row[10]=a_load_row[10]
+ a_load_row[9]=a_load_row[9] a_load_row[8]=a_load_row[8]
+ a_load_row[7]=a_load_row[7] a_load_row[6]=a_load_row[6]
+ a_load_row[5]=a_load_row[5] a_load_row[4]=a_load_row[4]
+ a_load_row[3]=a_load_row[3] a_load_row[2]=a_load_row[2]
+ a_load_row[1]=a_load_row[1] a_load_row[0]=a_load_row[0]
+ w_load_start=w_load_start w_load_k[2]=w_load_k[2] w_load_k[1]=w_load_k[1]
+ w_load_k[0]=w_load_k[0] w_load_n[2]=w_load_n[2] w_load_n[1]=w_load_n[1]
+ w_load_n[0]=w_load_n[0] w_load_row[31]=w_load_row[31]
+ w_load_row[30]=w_load_row[30] w_load_row[29]=w_load_row[29]
+ w_load_row[28]=w_load_row[28] w_load_row[27]=w_load_row[27]
+ w_load_row[26]=w_load_row[26] w_load_row[25]=w_load_row[25]
+ w_load_row[24]=w_load_row[24] w_load_row[23]=w_load_row[23]
+ w_load_row[22]=w_load_row[22] w_load_row[21]=w_load_row[21]
+ w_load_row[20]=w_load_row[20] w_load_row[19]=w_load_row[19]
+ w_load_row[18]=w_load_row[18] w_load_row[17]=w_load_row[17]
+ w_load_row[16]=w_load_row[16] w_load_row[15]=w_load_row[15]
+ w_load_row[14]=w_load_row[14] w_load_row[13]=w_load_row[13]
+ w_load_row[12]=w_load_row[12] w_load_row[11]=w_load_row[11]
+ w_load_row[10]=w_load_row[10] w_load_row[9]=w_load_row[9]
+ w_load_row[8]=w_load_row[8] w_load_row[7]=w_load_row[7]
+ w_load_row[6]=w_load_row[6] w_load_row[5]=w_load_row[5]
+ w_load_row[4]=w_load_row[4] w_load_row[3]=w_load_row[3]
+ w_load_row[2]=w_load_row[2] w_load_row[1]=w_load_row[1]
+ w_load_row[0]=w_load_row[0] c_src[511]=c_dst[511] c_src[510]=c_dst[510]
+ c_src[509]=c_dst[509] c_src[508]=c_dst[508] c_src[507]=c_dst[507]
+ c_src[506]=c_dst[506] c_src[505]=c_dst[505] c_src[504]=c_dst[504]
+ c_src[503]=c_dst[503] c_src[502]=c_dst[502] c_src[501]=c_dst[501]
+ c_src[500]=c_dst[500] c_src[499]=c_dst[499] c_src[498]=c_dst[498]
+ c_src[497]=c_dst[497] c_src[496]=c_dst[496] c_src[495]=c_dst[495]
+ c_src[494]=c_dst[494] c_src[493]=c_dst[493] c_src[492]=c_dst[492]
+ c_src[491]=c_dst[491] c_src[490]=c_dst[490] c_src[489]=c_dst[489]
+ c_src[488]=c_dst[488] c_src[487]=c_dst[487] c_src[486]=c_dst[486]
+ c_src[485]=c_dst[485] c_src[484]=c_dst[484] c_src[483]=c_dst[483]
+ c_src[482]=c_dst[482] c_src[481]=c_dst[481] c_src[480]=c_dst[480]
+ c_src[479]=c_dst[479] c_src[478]=c_dst[478] c_src[477]=c_dst[477]
+ c_src[476]=c_dst[476] c_src[475]=c_dst[475] c_src[474]=c_dst[474]
+ c_src[473]=c_dst[473] c_src[472]=c_dst[472] c_src[471]=c_dst[471]
+ c_src[470]=c_dst[470] c_src[469]=c_dst[469] c_src[468]=c_dst[468]
+ c_src[467]=c_dst[467] c_src[466]=c_dst[466] c_src[465]=c_dst[465]
+ c_src[464]=c_dst[464] c_src[463]=c_dst[463] c_src[462]=c_dst[462]
+ c_src[461]=c_dst[461] c_src[460]=c_dst[460] c_src[459]=c_dst[459]
+ c_src[458]=c_dst[458] c_src[457]=c_dst[457] c_src[456]=c_dst[456]
+ c_src[455]=c_dst[455] c_src[454]=c_dst[454] c_src[453]=c_dst[453]
+ c_src[452]=c_dst[452] c_src[451]=c_dst[451] c_src[450]=c_dst[450]
+ c_src[449]=c_dst[449] c_src[448]=c_dst[448] c_src[447]=c_dst[447]
+ c_src[446]=c_dst[446] c_src[445]=c_dst[445] c_src[444]=c_dst[444]
+ c_src[443]=c_dst[443] c_src[442]=c_dst[442] c_src[441]=c_dst[441]
+ c_src[440]=c_dst[440] c_src[439]=c_dst[439] c_src[438]=c_dst[438]
+ c_src[437]=c_dst[437] c_src[436]=c_dst[436] c_src[435]=c_dst[435]
+ c_src[434]=c_dst[434] c_src[433]=c_dst[433] c_src[432]=c_dst[432]
+ c_src[431]=c_dst[431] c_src[430]=c_dst[430] c_src[429]=c_dst[429]
+ c_src[428]=c_dst[428] c_src[427]=c_dst[427] c_src[426]=c_dst[426]
+ c_src[425]=c_dst[425] c_src[424]=c_dst[424] c_src[423]=c_dst[423]
+ c_src[422]=c_dst[422] c_src[421]=c_dst[421] c_src[420]=c_dst[420]
+ c_src[419]=c_dst[419] c_src[418]=c_dst[418] c_src[417]=c_dst[417]
+ c_src[416]=c_dst[416] c_src[415]=c_dst[415] c_src[414]=c_dst[414]
+ c_src[413]=c_dst[413] c_src[412]=c_dst[412] c_src[411]=c_dst[411]
+ c_src[410]=c_dst[410] c_src[409]=c_dst[409] c_src[408]=c_dst[408]
+ c_src[407]=c_dst[407] c_src[406]=c_dst[406] c_src[405]=c_dst[405]
+ c_src[404]=c_dst[404] c_src[403]=c_dst[403] c_src[402]=c_dst[402]
+ c_src[401]=c_dst[401] c_src[400]=c_dst[400] c_src[399]=c_dst[399]
+ c_src[398]=c_dst[398] c_src[397]=c_dst[397] c_src[396]=c_dst[396]
+ c_src[395]=c_dst[395] c_src[394]=c_dst[394] c_src[393]=c_dst[393]
+ c_src[392]=c_dst[392] c_src[391]=c_dst[391] c_src[390]=c_dst[390]
+ c_src[389]=c_dst[389] c_src[388]=c_dst[388] c_src[387]=c_dst[387]
+ c_src[386]=c_dst[386] c_src[385]=c_dst[385] c_src[384]=c_dst[384]
+ c_src[383]=c_dst[383] c_src[382]=c_dst[382] c_src[381]=c_dst[381]
+ c_src[380]=c_dst[380] c_src[379]=c_dst[379] c_src[378]=c_dst[378]
+ c_src[377]=c_dst[377] c_src[376]=c_dst[376] c_src[375]=c_dst[375]
+ c_src[374]=c_dst[374] c_src[373]=c_dst[373] c_src[372]=c_dst[372]
+ c_src[371]=c_dst[371] c_src[370]=c_dst[370] c_src[369]=c_dst[369]
+ c_src[368]=c_dst[368] c_src[367]=c_dst[367] c_src[366]=c_dst[366]
+ c_src[365]=c_dst[365] c_src[364]=c_dst[364] c_src[363]=c_dst[363]
+ c_src[362]=c_dst[362] c_src[361]=c_dst[361] c_src[360]=c_dst[360]
+ c_src[359]=c_dst[359] c_src[358]=c_dst[358] c_src[357]=c_dst[357]
+ c_src[356]=c_dst[356] c_src[355]=c_dst[355] c_src[354]=c_dst[354]
+ c_src[353]=c_dst[353] c_src[352]=c_dst[352] c_src[351]=c_dst[351]
+ c_src[350]=c_dst[350] c_src[349]=c_dst[349] c_src[348]=c_dst[348]
+ c_src[347]=c_dst[347] c_src[346]=c_dst[346] c_src[345]=c_dst[345]
+ c_src[344]=c_dst[344] c_src[343]=c_dst[343] c_src[342]=c_dst[342]
+ c_src[341]=c_dst[341] c_src[340]=c_dst[340] c_src[339]=c_dst[339]
+ c_src[338]=c_dst[338] c_src[337]=c_dst[337] c_src[336]=c_dst[336]
+ c_src[335]=c_dst[335] c_src[334]=c_dst[334] c_src[333]=c_dst[333]
+ c_src[332]=c_dst[332] c_src[331]=c_dst[331] c_src[330]=c_dst[330]
+ c_src[329]=c_dst[329] c_src[328]=c_dst[328] c_src[327]=c_dst[327]
+ c_src[326]=c_dst[326] c_src[325]=c_dst[325] c_src[324]=c_dst[324]
+ c_src[323]=c_dst[323] c_src[322]=c_dst[322] c_src[321]=c_dst[321]
+ c_src[320]=c_dst[320] c_src[319]=c_dst[319] c_src[318]=c_dst[318]
+ c_src[317]=c_dst[317] c_src[316]=c_dst[316] c_src[315]=c_dst[315]
+ c_src[314]=c_dst[314] c_src[313]=c_dst[313] c_src[312]=c_dst[312]
+ c_src[311]=c_dst[311] c_src[310]=c_dst[310] c_src[309]=c_dst[309]
+ c_src[308]=c_dst[308] c_src[307]=c_dst[307] c_src[306]=c_dst[306]
+ c_src[305]=c_dst[305] c_src[304]=c_dst[304] c_src[303]=c_dst[303]
+ c_src[302]=c_dst[302] c_src[301]=c_dst[301] c_src[300]=c_dst[300]
+ c_src[299]=c_dst[299] c_src[298]=c_dst[298] c_src[297]=c_dst[297]
+ c_src[296]=c_dst[296] c_src[295]=c_dst[295] c_src[294]=c_dst[294]
+ c_src[293]=c_dst[293] c_src[292]=c_dst[292] c_src[291]=c_dst[291]
+ c_src[290]=c_dst[290] c_src[289]=c_dst[289] c_src[288]=c_dst[288]
+ c_src[287]=c_dst[287] c_src[286]=c_dst[286] c_src[285]=c_dst[285]
+ c_src[284]=c_dst[284] c_src[283]=c_dst[283] c_src[282]=c_dst[282]
+ c_src[281]=c_dst[281] c_src[280]=c_dst[280] c_src[279]=c_dst[279]
+ c_src[278]=c_dst[278] c_src[277]=c_dst[277] c_src[276]=c_dst[276]
+ c_src[275]=c_dst[275] c_src[274]=c_dst[274] c_src[273]=c_dst[273]
+ c_src[272]=c_dst[272] c_src[271]=c_dst[271] c_src[270]=c_dst[270]
+ c_src[269]=c_dst[269] c_src[268]=c_dst[268] c_src[267]=c_dst[267]
+ c_src[266]=c_dst[266] c_src[265]=c_dst[265] c_src[264]=c_dst[264]
+ c_src[263]=c_dst[263] c_src[262]=c_dst[262] c_src[261]=c_dst[261]
+ c_src[260]=c_dst[260] c_src[259]=c_dst[259] c_src[258]=c_dst[258]
+ c_src[257]=c_dst[257] c_src[256]=c_dst[256] c_src[255]=c_dst[255]
+ c_src[254]=c_dst[254] c_src[253]=c_dst[253] c_src[252]=c_dst[252]
+ c_src[251]=c_dst[251] c_src[250]=c_dst[250] c_src[249]=c_dst[249]
+ c_src[248]=c_dst[248] c_src[247]=c_dst[247] c_src[246]=c_dst[246]
+ c_src[245]=c_dst[245] c_src[244]=c_dst[244] c_src[243]=c_dst[243]
+ c_src[242]=c_dst[242] c_src[241]=c_dst[241] c_src[240]=c_dst[240]
+ c_src[239]=c_dst[239] c_src[238]=c_dst[238] c_src[237]=c_dst[237]
+ c_src[236]=c_dst[236] c_src[235]=c_dst[235] c_src[234]=c_dst[234]
+ c_src[233]=c_dst[233] c_src[232]=c_dst[232] c_src[231]=c_dst[231]
+ c_src[230]=c_dst[230] c_src[229]=c_dst[229] c_src[228]=c_dst[228]
+ c_src[227]=c_dst[227] c_src[226]=c_dst[226] c_src[225]=c_dst[225]
+ c_src[224]=c_dst[224] c_src[223]=c_dst[223] c_src[222]=c_dst[222]
+ c_src[221]=c_dst[221] c_src[220]=c_dst[220] c_src[219]=c_dst[219]
+ c_src[218]=c_dst[218] c_src[217]=c_dst[217] c_src[216]=c_dst[216]
+ c_src[215]=c_dst[215] c_src[214]=c_dst[214] c_src[213]=c_dst[213]
+ c_src[212]=c_dst[212] c_src[211]=c_dst[211] c_src[210]=c_dst[210]
+ c_src[209]=c_dst[209] c_src[208]=c_dst[208] c_src[207]=c_dst[207]
+ c_src[206]=c_dst[206] c_src[205]=c_dst[205] c_src[204]=c_dst[204]
+ c_src[203]=c_dst[203] c_src[202]=c_dst[202] c_src[201]=c_dst[201]
+ c_src[200]=c_dst[200] c_src[199]=c_dst[199] c_src[198]=c_dst[198]
+ c_src[197]=c_dst[197] c_src[196]=c_dst[196] c_src[195]=c_dst[195]
+ c_src[194]=c_dst[194] c_src[193]=c_dst[193] c_src[192]=c_dst[192]
+ c_src[191]=c_dst[191] c_src[190]=c_dst[190] c_src[189]=c_dst[189]
+ c_src[188]=c_dst[188] c_src[187]=c_dst[187] c_src[186]=c_dst[186]
+ c_src[185]=c_dst[185] c_src[184]=c_dst[184] c_src[183]=c_dst[183]
+ c_src[182]=c_dst[182] c_src[181]=c_dst[181] c_src[180]=c_dst[180]
+ c_src[179]=c_dst[179] c_src[178]=c_dst[178] c_src[177]=c_dst[177]
+ c_src[176]=c_dst[176] c_src[175]=c_dst[175] c_src[174]=c_dst[174]
+ c_src[173]=c_dst[173] c_src[172]=c_dst[172] c_src[171]=c_dst[171]
+ c_src[170]=c_dst[170] c_src[169]=c_dst[169] c_src[168]=c_dst[168]
+ c_src[167]=c_dst[167] c_src[166]=c_dst[166] c_src[165]=c_dst[165]
+ c_src[164]=c_dst[164] c_src[163]=c_dst[163] c_src[162]=c_dst[162]
+ c_src[161]=c_dst[161] c_src[160]=c_dst[160] c_src[159]=c_dst[159]
+ c_src[158]=c_dst[158] c_src[157]=c_dst[157] c_src[156]=c_dst[156]
+ c_src[155]=c_dst[155] c_src[154]=c_dst[154] c_src[153]=c_dst[153]
+ c_src[152]=c_dst[152] c_src[151]=c_dst[151] c_src[150]=c_dst[150]
+ c_src[149]=c_dst[149] c_src[148]=c_dst[148] c_src[147]=c_dst[147]
+ c_src[146]=c_dst[146] c_src[145]=c_dst[145] c_src[144]=c_dst[144]
+ c_src[143]=c_dst[143] c_src[142]=c_dst[142] c_src[141]=c_dst[141]
+ c_src[140]=c_dst[140] c_src[139]=c_dst[139] c_src[138]=c_dst[138]
+ c_src[137]=c_dst[137] c_src[136]=c_dst[136] c_src[135]=c_dst[135]
+ c_src[134]=c_dst[134] c_src[133]=c_dst[133] c_src[132]=c_dst[132]
+ c_src[131]=c_dst[131] c_src[130]=c_dst[130] c_src[129]=c_dst[129]
+ c_src[128]=c_dst[128] c_src[127]=c_dst[127] c_src[126]=c_dst[126]
+ c_src[125]=c_dst[125] c_src[124]=c_dst[124] c_src[123]=c_dst[123]
+ c_src[122]=c_dst[122] c_src[121]=c_dst[121] c_src[120]=c_dst[120]
+ c_src[119]=c_dst[119] c_src[118]=c_dst[118] c_src[117]=c_dst[117]
+ c_src[116]=c_dst[116] c_src[115]=c_dst[115] c_src[114]=c_dst[114]
+ c_src[113]=c_dst[113] c_src[112]=c_dst[112] c_src[111]=c_dst[111]
+ c_src[110]=c_dst[110] c_src[109]=c_dst[109] c_src[108]=c_dst[108]
+ c_src[107]=c_dst[107] c_src[106]=c_dst[106] c_src[105]=c_dst[105]
+ c_src[104]=c_dst[104] c_src[103]=c_dst[103] c_src[102]=c_dst[102]
+ c_src[101]=c_dst[101] c_src[100]=c_dst[100] c_src[99]=c_dst[99]
+ c_src[98]=c_dst[98] c_src[97]=c_dst[97] c_src[96]=c_dst[96] c_src[95]=c_dst[95]
+ c_src[94]=c_dst[94] c_src[93]=c_dst[93] c_src[92]=c_dst[92] c_src[91]=c_dst[91]
+ c_src[90]=c_dst[90] c_src[89]=c_dst[89] c_src[88]=c_dst[88] c_src[87]=c_dst[87]
+ c_src[86]=c_dst[86] c_src[85]=c_dst[85] c_src[84]=c_dst[84] c_src[83]=c_dst[83]
+ c_src[82]=c_dst[82] c_src[81]=c_dst[81] c_src[80]=c_dst[80] c_src[79]=c_dst[79]
+ c_src[78]=c_dst[78] c_src[77]=c_dst[77] c_src[76]=c_dst[76] c_src[75]=c_dst[75]
+ c_src[74]=c_dst[74] c_src[73]=c_dst[73] c_src[72]=c_dst[72] c_src[71]=c_dst[71]
+ c_src[70]=c_dst[70] c_src[69]=c_dst[69] c_src[68]=c_dst[68] c_src[67]=c_dst[67]
+ c_src[66]=c_dst[66] c_src[65]=c_dst[65] c_src[64]=c_dst[64] c_src[63]=c_dst[63]
+ c_src[62]=c_dst[62] c_src[61]=c_dst[61] c_src[60]=c_dst[60] c_src[59]=c_dst[59]
+ c_src[58]=c_dst[58] c_src[57]=c_dst[57] c_src[56]=c_dst[56] c_src[55]=c_dst[55]
+ c_src[54]=c_dst[54] c_src[53]=c_dst[53] c_src[52]=c_dst[52] c_src[51]=c_dst[51]
+ c_src[50]=c_dst[50] c_src[49]=c_dst[49] c_src[48]=c_dst[48] c_src[47]=c_dst[47]
+ c_src[46]=c_dst[46] c_src[45]=c_dst[45] c_src[44]=c_dst[44] c_src[43]=c_dst[43]
+ c_src[42]=c_dst[42] c_src[41]=c_dst[41] c_src[40]=c_dst[40] c_src[39]=c_dst[39]
+ c_src[38]=c_dst[38] c_src[37]=c_dst[37] c_src[36]=c_dst[36] c_src[35]=c_dst[35]
+ c_src[34]=c_dst[34] c_src[33]=c_dst[33] c_src[32]=c_dst[32] c_src[31]=c_dst[31]
+ c_src[30]=c_dst[30] c_src[29]=c_dst[29] c_src[28]=c_dst[28] c_src[27]=c_dst[27]
+ c_src[26]=c_dst[26] c_src[25]=c_dst[25] c_src[24]=c_dst[24] c_src[23]=c_dst[23]
+ c_src[22]=c_dst[22] c_src[21]=c_dst[21] c_src[20]=c_dst[20] c_src[19]=c_dst[19]
+ c_src[18]=c_dst[18] c_src[17]=c_dst[17] c_src[16]=c_dst[16] c_src[15]=c_dst[15]
+ c_src[14]=c_dst[14] c_src[13]=c_dst[13] c_src[12]=c_dst[12] c_src[11]=c_dst[11]
+ c_src[10]=c_dst[10] c_src[9]=c_dst[9] c_src[8]=c_dst[8] c_src[7]=c_dst[7]
+ c_src[6]=c_dst[6] c_src[5]=c_dst[5] c_src[4]=c_dst[4] c_src[3]=c_dst[3]
+ c_src[2]=c_dst[2] c_src[1]=c_dst[1] c_src[0]=c_dst[0] VDD=VDD VSS=VSS
+ ZCTSNET_50=ZCTSNET_48 ZCTSNET_52=ZCTSNET_33 ZCTSNET_54=ZCTSNET_50
+ ZCTSNET_55=ZCTSNET_37 HFSNET_38=HFSNET_65 HFSNET_39=HFSNET_66
+ HFSNET_40=HFSNET_67 HFSNET_41=HFSNET_68 HFSNET_42=HFSNET_69 HFSNET_45=HFSNET_70
+ HFSNET_46=HFSNET_79 HFSNET_47=HFSNET_80 ZCTSNET_0=ZCTSNET_34
+ ZCTSNET_2=ZCTSNET_45 ZCTSNET_3=ZCTSNET_49 ZCTSNET_5=ZCTSNET_54
+ ZCTSNET_6=ZCTSNET_57
Xu_wbuf unpu_wbuf $PINS ZCTSNET_58=ZCTSNET_10 rst_n=HFSNET_85
+ array_en=HFSNET_46 load_start=w_load_start load_k[2]=w_load_k[2]
+ load_k[1]=w_load_k[1] load_k[0]=w_load_k[0] load_n[2]=w_load_n[2]
+ load_n[1]=w_load_n[1] load_n[0]=w_load_n[0] load_row[31]=w_load_row[31]
+ load_row[30]=w_load_row[30] load_row[29]=w_load_row[29]
+ load_row[28]=w_load_row[28] load_row[27]=w_load_row[27]
+ load_row[26]=w_load_row[26] load_row[25]=w_load_row[25]
+ load_row[24]=w_load_row[24] load_row[23]=w_load_row[23]
+ load_row[22]=w_load_row[22] load_row[21]=w_load_row[21]
+ load_row[20]=w_load_row[20] load_row[19]=w_load_row[19]
+ load_row[18]=w_load_row[18] load_row[17]=w_load_row[17]
+ load_row[16]=w_load_row[16] load_row[15]=w_load_row[15]
+ load_row[14]=w_load_row[14] load_row[13]=w_load_row[13]
+ load_row[12]=w_load_row[12] load_row[11]=w_load_row[11]
+ load_row[10]=w_load_row[10] load_row[9]=w_load_row[9] load_row[8]=w_load_row[8]
+ load_row[7]=w_load_row[7] load_row[6]=w_load_row[6] load_row[5]=w_load_row[5]
+ load_row[4]=w_load_row[4] load_row[3]=w_load_row[3] load_row[2]=w_load_row[2]
+ load_row[1]=w_load_row[1] load_row[0]=w_load_row[0] swap=w_swap
+ weight_load[15]=weight_load[15] weight_load[14]=weight_load[14]
+ weight_load[13]=weight_load[13] weight_load[12]=weight_load[12]
+ weight_load[11]=weight_load[11] weight_load[10]=weight_load[10]
+ weight_load[9]=weight_load[9] weight_load[8]=weight_load[8]
+ weight_load[7]=weight_load[7] weight_load[6]=weight_load[6]
+ weight_load[5]=weight_load[5] weight_load[4]=weight_load[4]
+ weight_load[3]=weight_load[3] weight_load[2]=weight_load[2]
+ weight_load[1]=weight_load[1] weight_load[0]=weight_load[0]
+ weight_in[127]=weight_in[127] weight_in[126]=weight_in[126]
+ weight_in[125]=weight_in[125] weight_in[124]=weight_in[124]
+ weight_in[123]=weight_in[123] weight_in[122]=weight_in[122]
+ weight_in[121]=weight_in[121] weight_in[120]=weight_in[120]
+ weight_in[119]=weight_in[119] weight_in[118]=weight_in[118]
+ weight_in[117]=weight_in[117] weight_in[116]=weight_in[116]
+ weight_in[115]=weight_in[115] weight_in[114]=weight_in[114]
+ weight_in[113]=weight_in[113] weight_in[112]=weight_in[112]
+ weight_in[111]=weight_in[111] weight_in[110]=weight_in[110]
+ weight_in[109]=weight_in[109] weight_in[108]=weight_in[108]
+ weight_in[107]=weight_in[107] weight_in[106]=weight_in[106]
+ weight_in[105]=weight_in[105] weight_in[104]=weight_in[104]
+ weight_in[103]=weight_in[103] weight_in[102]=weight_in[102]
+ weight_in[101]=weight_in[101] weight_in[100]=weight_in[100]
+ weight_in[99]=weight_in[99] weight_in[98]=weight_in[98]
+ weight_in[97]=weight_in[97] weight_in[96]=weight_in[96]
+ weight_in[95]=weight_in[95] weight_in[94]=weight_in[94]
+ weight_in[93]=weight_in[93] weight_in[92]=weight_in[92]
+ weight_in[91]=weight_in[91] weight_in[90]=weight_in[90]
+ weight_in[89]=weight_in[89] weight_in[88]=weight_in[88]
+ weight_in[87]=weight_in[87] weight_in[86]=weight_in[86]
+ weight_in[85]=weight_in[85] weight_in[84]=weight_in[84]
+ weight_in[83]=weight_in[83] weight_in[82]=weight_in[82]
+ weight_in[81]=weight_in[81] weight_in[80]=weight_in[80]
+ weight_in[79]=weight_in[79] weight_in[78]=weight_in[78]
+ weight_in[77]=weight_in[77] weight_in[76]=weight_in[76]
+ weight_in[75]=weight_in[75] weight_in[74]=weight_in[74]
+ weight_in[73]=weight_in[73] weight_in[72]=weight_in[72]
+ weight_in[71]=weight_in[71] weight_in[70]=weight_in[70]
+ weight_in[69]=weight_in[69] weight_in[68]=weight_in[68]
+ weight_in[67]=weight_in[67] weight_in[66]=weight_in[66]
+ weight_in[65]=weight_in[65] weight_in[64]=weight_in[64]
+ weight_in[63]=weight_in[63] weight_in[62]=weight_in[62]
+ weight_in[61]=weight_in[61] weight_in[60]=weight_in[60]
+ weight_in[59]=weight_in[59] weight_in[58]=weight_in[58]
+ weight_in[57]=weight_in[57] weight_in[56]=weight_in[56]
+ weight_in[55]=weight_in[55] weight_in[54]=weight_in[54]
+ weight_in[53]=weight_in[53] weight_in[52]=weight_in[52]
+ weight_in[51]=weight_in[51] weight_in[50]=weight_in[50]
+ weight_in[49]=weight_in[49] weight_in[48]=weight_in[48]
+ weight_in[47]=weight_in[47] weight_in[46]=weight_in[46]
+ weight_in[45]=weight_in[45] weight_in[44]=weight_in[44]
+ weight_in[43]=weight_in[43] weight_in[42]=weight_in[42]
+ weight_in[41]=weight_in[41] weight_in[40]=weight_in[40]
+ weight_in[39]=weight_in[39] weight_in[38]=weight_in[38]
+ weight_in[37]=weight_in[37] weight_in[36]=weight_in[36]
+ weight_in[35]=weight_in[35] weight_in[34]=weight_in[34]
+ weight_in[33]=weight_in[33] weight_in[32]=weight_in[32]
+ weight_in[31]=weight_in[31] weight_in[30]=weight_in[30]
+ weight_in[29]=weight_in[29] weight_in[28]=weight_in[28]
+ weight_in[27]=weight_in[27] weight_in[26]=weight_in[26]
+ weight_in[25]=weight_in[25] weight_in[24]=weight_in[24]
+ weight_in[23]=weight_in[23] weight_in[22]=weight_in[22]
+ weight_in[21]=weight_in[21] weight_in[20]=weight_in[20]
+ weight_in[19]=weight_in[19] weight_in[18]=weight_in[18]
+ weight_in[17]=weight_in[17] weight_in[16]=weight_in[16]
+ weight_in[15]=weight_in[15] weight_in[14]=weight_in[14]
+ weight_in[13]=weight_in[13] weight_in[12]=weight_in[12]
+ weight_in[11]=weight_in[11] weight_in[10]=weight_in[10]
+ weight_in[9]=weight_in[9] weight_in[8]=weight_in[8] weight_in[7]=weight_in[7]
+ weight_in[6]=weight_in[6] weight_in[5]=weight_in[5] weight_in[4]=weight_in[4]
+ weight_in[3]=weight_in[3] weight_in[2]=weight_in[2] weight_in[1]=weight_in[1]
+ weight_in[0]=weight_in[0] VDD=VDD VSS=VSS ZCTSNET_60=ZCTSNET_9
+ ZCTSNET_61=ZCTSNET_7 ZCTSNET_62=ZCTSNET_22 ZCTSNET_63=ZCTSNET_3
+ ZCTSNET_64=ZCTSNET_14 ZCTSNET_65=ZCTSNET_8 ZCTSNET_66=ZCTSNET_2
+ ZCTSNET_68=ZCTSNET_6 ZCTSNET_70=ZCTSNET_1 HFSNET_41=HFSNET_50
+ HFSNET_42=HFSNET_86 HFSNET_43=HFSNET_87 HFSNET_44=HFSNET_88 HFSNET_46=HFSNET_89
+ HFSNET_47=HFSNET_90 HFSNET_48=HFSNET_91 HFSNET_49=HFSNET_92 HFSNET_51=HFSNET_93
+ HFSNET_52=HFSNET_94 HFSNET_54=HFSNET_95 HFSNET_55=HFSNET_96 HFSNET_56=HFSNET_99
+ ZCTSNET_3=ZCTSNET_4 ZCTSNET_4=ZCTSNET_5 ZCTSNET_6=ZCTSNET_16
+ ZCTSNET_9=ZCTSNET_21
Xu_actbuf unpu_actbuf $PINS ZCTSNET_48=ZCTSNET_57 rst_n=HFSNET_76
+ array_en=HFSNET_41 load_start=a_load_start load_m[2]=a_load_m[2]
+ load_m[1]=a_load_m[1] load_m[0]=a_load_m[0] load_k[2]=a_load_k[2]
+ load_k[1]=a_load_k[1] load_k[0]=a_load_k[0] load_row[31]=a_load_row[31]
+ load_row[30]=a_load_row[30] load_row[29]=a_load_row[29]
+ load_row[28]=a_load_row[28] load_row[27]=a_load_row[27]
+ load_row[26]=a_load_row[26] load_row[25]=a_load_row[25]
+ load_row[24]=a_load_row[24] load_row[23]=a_load_row[23]
+ load_row[22]=a_load_row[22] load_row[21]=a_load_row[21]
+ load_row[20]=a_load_row[20] load_row[19]=a_load_row[19]
+ load_row[18]=a_load_row[18] load_row[17]=a_load_row[17]
+ load_row[16]=a_load_row[16] load_row[15]=a_load_row[15]
+ load_row[14]=a_load_row[14] load_row[13]=a_load_row[13]
+ load_row[12]=a_load_row[12] load_row[11]=a_load_row[11]
+ load_row[10]=a_load_row[10] load_row[9]=a_load_row[9] load_row[8]=a_load_row[8]
+ load_row[7]=a_load_row[7] load_row[6]=a_load_row[6] load_row[5]=a_load_row[5]
+ load_row[4]=a_load_row[4] load_row[3]=a_load_row[3] load_row[2]=a_load_row[2]
+ load_row[1]=a_load_row[1] load_row[0]=a_load_row[0] swap=a_swap
+ rd_row[1]=rd_row[1] rd_row[0]=rd_row[0] rd_data[31]=a_rd_data[31]
+ rd_data[30]=a_rd_data[30] rd_data[29]=a_rd_data[29] rd_data[28]=a_rd_data[28]
+ rd_data[27]=a_rd_data[27] rd_data[26]=a_rd_data[26] rd_data[25]=a_rd_data[25]
+ rd_data[24]=a_rd_data[24] rd_data[23]=a_rd_data[23] rd_data[22]=a_rd_data[22]
+ rd_data[21]=a_rd_data[21] rd_data[20]=a_rd_data[20] rd_data[19]=a_rd_data[19]
+ rd_data[18]=a_rd_data[18] rd_data[17]=a_rd_data[17] rd_data[16]=a_rd_data[16]
+ rd_data[15]=a_rd_data[15] rd_data[14]=a_rd_data[14] rd_data[13]=a_rd_data[13]
+ rd_data[12]=a_rd_data[12] rd_data[11]=a_rd_data[11] rd_data[10]=a_rd_data[10]
+ rd_data[9]=a_rd_data[9] rd_data[8]=a_rd_data[8] rd_data[7]=a_rd_data[7]
+ rd_data[6]=a_rd_data[6] rd_data[5]=a_rd_data[5] rd_data[4]=a_rd_data[4]
+ rd_data[3]=a_rd_data[3] rd_data[2]=a_rd_data[2] rd_data[1]=a_rd_data[1]
+ rd_data[0]=a_rd_data[0] VDD=VDD VSS=VSS ZCTSNET_53=ZCTSNET_56
+ ZCTSNET_54=ZCTSNET_55 ZCTSNET_55=ZCTSNET_54 HFSNET_36=HFSNET_44
+ HFSNET_37=HFSNET_49 HFSNET_38=HFSNET_78 HFSNET_39=HFSNET_79 HFSNET_42=HFSNET_80
+ HFSNET_43=HFSNET_83 ZCTSNET_0=ZCTSNET_58 sbcto_ht1_0=sbcto_ht1_2
Xu_skew unpu_skew $PINS ZCTSNET_10=ZCTSNET_58 rst_n=HFSNET_76
+ array_en=HFSNET_41 a_raw[31]=a_rd_data[31] a_raw[30]=a_rd_data[30]
+ a_raw[29]=a_rd_data[29] a_raw[28]=a_rd_data[28] a_raw[27]=a_rd_data[27]
+ a_raw[26]=a_rd_data[26] a_raw[25]=a_rd_data[25] a_raw[24]=a_rd_data[24]
+ a_raw[23]=a_rd_data[23] a_raw[22]=a_rd_data[22] a_raw[21]=a_rd_data[21]
+ a_raw[20]=a_rd_data[20] a_raw[19]=a_rd_data[19] a_raw[18]=a_rd_data[18]
+ a_raw[17]=a_rd_data[17] a_raw[16]=a_rd_data[16] a_raw[15]=a_rd_data[15]
+ a_raw[14]=a_rd_data[14] a_raw[13]=a_rd_data[13] a_raw[12]=a_rd_data[12]
+ a_raw[11]=a_rd_data[11] a_raw[10]=a_rd_data[10] a_raw[9]=a_rd_data[9]
+ a_raw[8]=a_rd_data[8] a_raw[7]=a_rd_data[7] a_raw[6]=a_rd_data[6]
+ a_raw[5]=a_rd_data[5] a_raw[4]=a_rd_data[4] a_raw[3]=a_rd_data[3]
+ a_raw[2]=a_rd_data[2] a_raw[1]=a_rd_data[1] a_raw[0]=a_rd_data[0]
+ act_out[31]=skew_act_out[31] act_out[30]=skew_act_out[30]
+ act_out[29]=skew_act_out[29] act_out[28]=skew_act_out[28]
+ act_out[27]=skew_act_out[27] act_out[26]=skew_act_out[26]
+ act_out[25]=skew_act_out[25] act_out[24]=skew_act_out[24]
+ act_out[23]=skew_act_out[23] act_out[22]=skew_act_out[22]
+ act_out[21]=skew_act_out[21] act_out[20]=skew_act_out[20]
+ act_out[19]=skew_act_out[19] act_out[18]=skew_act_out[18]
+ act_out[17]=skew_act_out[17] act_out[16]=skew_act_out[16]
+ act_out[15]=skew_act_out[15] act_out[14]=skew_act_out[14]
+ act_out[13]=skew_act_out[13] act_out[12]=skew_act_out[12]
+ act_out[11]=skew_act_out[11] act_out[10]=skew_act_out[10]
+ act_out[9]=skew_act_out[9] act_out[8]=skew_act_out[8]
+ act_out[7]=skew_act_out[7] act_out[6]=skew_act_out[6]
+ act_out[5]=skew_act_out[5] act_out[4]=skew_act_out[4]
+ act_out[3]=skew_act_out[3] act_out[2]=skew_act_out[2]
+ act_out[1]=skew_act_out[1] act_out[0]=skew_act_out[0] VDD=VDD VSS=VSS
+ ZCTSNET_0=ZCTSNET_19 HFSNET_2=HFSNET_42 HFSNET_3=HFSNET_43 HFSNET_4=HFSNET_44
+ HFSNET_6=HFSNET_45 HFSNET_7=HFSNET_77 HFSNET_8=HFSNET_78 HFSNET_9=HFSNET_82
+ sbcto_ht1_0=sbcto_ht1_2
Xu_grid unpu_grid $PINS ZCTSNET_107=ZCTSNET_7 rst_n=HFSNET_56
+ array_en=HFSNET_39 mode_unsigned=mode_unsigned_o
+ weight_load[15]=weight_load[15] weight_load[14]=weight_load[14]
+ weight_load[13]=weight_load[13] weight_load[12]=weight_load[12]
+ weight_load[11]=weight_load[11] weight_load[10]=weight_load[10]
+ weight_load[9]=weight_load[9] weight_load[8]=weight_load[8]
+ weight_load[7]=weight_load[7] weight_load[6]=weight_load[6]
+ weight_load[5]=weight_load[5] weight_load[4]=weight_load[4]
+ weight_load[3]=weight_load[3] weight_load[2]=weight_load[2]
+ weight_load[1]=weight_load[1] weight_load[0]=weight_load[0]
+ weight_in[127]=weight_in[127] weight_in[126]=weight_in[126]
+ weight_in[125]=weight_in[125] weight_in[124]=weight_in[124]
+ weight_in[123]=weight_in[123] weight_in[122]=weight_in[122]
+ weight_in[121]=weight_in[121] weight_in[120]=weight_in[120]
+ weight_in[119]=weight_in[119] weight_in[118]=weight_in[118]
+ weight_in[117]=weight_in[117] weight_in[116]=weight_in[116]
+ weight_in[115]=weight_in[115] weight_in[114]=weight_in[114]
+ weight_in[113]=weight_in[113] weight_in[112]=weight_in[112]
+ weight_in[111]=weight_in[111] weight_in[110]=weight_in[110]
+ weight_in[109]=weight_in[109] weight_in[108]=weight_in[108]
+ weight_in[107]=weight_in[107] weight_in[106]=weight_in[106]
+ weight_in[105]=weight_in[105] weight_in[104]=weight_in[104]
+ weight_in[103]=weight_in[103] weight_in[102]=weight_in[102]
+ weight_in[101]=weight_in[101] weight_in[100]=weight_in[100]
+ weight_in[99]=weight_in[99] weight_in[98]=weight_in[98]
+ weight_in[97]=weight_in[97] weight_in[96]=weight_in[96]
+ weight_in[95]=weight_in[95] weight_in[94]=weight_in[94]
+ weight_in[93]=weight_in[93] weight_in[92]=weight_in[92]
+ weight_in[91]=weight_in[91] weight_in[90]=weight_in[90]
+ weight_in[89]=weight_in[89] weight_in[88]=weight_in[88]
+ weight_in[87]=weight_in[87] weight_in[86]=weight_in[86]
+ weight_in[85]=weight_in[85] weight_in[84]=weight_in[84]
+ weight_in[83]=weight_in[83] weight_in[82]=weight_in[82]
+ weight_in[81]=weight_in[81] weight_in[80]=weight_in[80]
+ weight_in[79]=weight_in[79] weight_in[78]=weight_in[78]
+ weight_in[77]=weight_in[77] weight_in[76]=weight_in[76]
+ weight_in[75]=weight_in[75] weight_in[74]=weight_in[74]
+ weight_in[73]=weight_in[73] weight_in[72]=weight_in[72]
+ weight_in[71]=weight_in[71] weight_in[70]=weight_in[70]
+ weight_in[69]=weight_in[69] weight_in[68]=weight_in[68]
+ weight_in[67]=weight_in[67] weight_in[66]=weight_in[66]
+ weight_in[65]=weight_in[65] weight_in[64]=weight_in[64]
+ weight_in[63]=weight_in[63] weight_in[62]=weight_in[62]
+ weight_in[61]=weight_in[61] weight_in[60]=weight_in[60]
+ weight_in[59]=weight_in[59] weight_in[58]=weight_in[58]
+ weight_in[57]=weight_in[57] weight_in[56]=weight_in[56]
+ weight_in[55]=weight_in[55] weight_in[54]=weight_in[54]
+ weight_in[53]=weight_in[53] weight_in[52]=weight_in[52]
+ weight_in[51]=weight_in[51] weight_in[50]=weight_in[50]
+ weight_in[49]=weight_in[49] weight_in[48]=weight_in[48]
+ weight_in[47]=weight_in[47] weight_in[46]=weight_in[46]
+ weight_in[45]=weight_in[45] weight_in[44]=weight_in[44]
+ weight_in[43]=weight_in[43] weight_in[42]=weight_in[42]
+ weight_in[41]=weight_in[41] weight_in[40]=weight_in[40]
+ weight_in[39]=weight_in[39] weight_in[38]=weight_in[38]
+ weight_in[37]=weight_in[37] weight_in[36]=weight_in[36]
+ weight_in[35]=weight_in[35] weight_in[34]=weight_in[34]
+ weight_in[33]=weight_in[33] weight_in[32]=weight_in[32]
+ weight_in[31]=weight_in[31] weight_in[30]=weight_in[30]
+ weight_in[29]=weight_in[29] weight_in[28]=weight_in[28]
+ weight_in[27]=weight_in[27] weight_in[26]=weight_in[26]
+ weight_in[25]=weight_in[25] weight_in[24]=weight_in[24]
+ weight_in[23]=weight_in[23] weight_in[22]=weight_in[22]
+ weight_in[21]=weight_in[21] weight_in[20]=weight_in[20]
+ weight_in[19]=weight_in[19] weight_in[18]=weight_in[18]
+ weight_in[17]=weight_in[17] weight_in[16]=weight_in[16]
+ weight_in[15]=weight_in[15] weight_in[14]=weight_in[14]
+ weight_in[13]=weight_in[13] weight_in[12]=weight_in[12]
+ weight_in[11]=weight_in[11] weight_in[10]=weight_in[10]
+ weight_in[9]=weight_in[9] weight_in[8]=weight_in[8] weight_in[7]=weight_in[7]
+ weight_in[6]=weight_in[6] weight_in[5]=weight_in[5] weight_in[4]=weight_in[4]
+ weight_in[3]=weight_in[3] weight_in[2]=weight_in[2] weight_in[1]=weight_in[1]
+ weight_in[0]=weight_in[0] act_in[31]=skew_act_out[31]
+ act_in[30]=skew_act_out[30] act_in[29]=skew_act_out[29]
+ act_in[28]=skew_act_out[28] act_in[27]=skew_act_out[27]
+ act_in[26]=skew_act_out[26] act_in[25]=skew_act_out[25]
+ act_in[24]=skew_act_out[24] act_in[23]=skew_act_out[23]
+ act_in[22]=skew_act_out[22] act_in[21]=skew_act_out[21]
+ act_in[20]=skew_act_out[20] act_in[19]=skew_act_out[19]
+ act_in[18]=skew_act_out[18] act_in[17]=skew_act_out[17]
+ act_in[16]=skew_act_out[16] act_in[15]=skew_act_out[15]
+ act_in[14]=skew_act_out[14] act_in[13]=skew_act_out[13]
+ act_in[12]=skew_act_out[12] act_in[11]=skew_act_out[11]
+ act_in[10]=skew_act_out[10] act_in[9]=skew_act_out[9] act_in[8]=skew_act_out[8]
+ act_in[7]=skew_act_out[7] act_in[6]=skew_act_out[6] act_in[5]=skew_act_out[5]
+ act_in[4]=skew_act_out[4] act_in[3]=skew_act_out[3] act_in[2]=skew_act_out[2]
+ act_in[1]=skew_act_out[1] act_in[0]=skew_act_out[0] psum_in[127]=VSS
+ psum_in[126]=VSS psum_in[125]=VSS psum_in[124]=VSS psum_in[123]=VSS
+ psum_in[122]=VSS psum_in[121]=VSS psum_in[120]=VSS psum_in[119]=VSS
+ psum_in[118]=VSS psum_in[117]=VSS psum_in[116]=VSS psum_in[115]=VSS
+ psum_in[114]=VSS psum_in[113]=VSS psum_in[112]=VSS psum_in[111]=VSS
+ psum_in[110]=VSS psum_in[109]=VSS psum_in[108]=VSS psum_in[107]=VSS
+ psum_in[106]=VSS psum_in[105]=VSS psum_in[104]=VSS psum_in[103]=VSS
+ psum_in[102]=VSS psum_in[101]=VSS psum_in[100]=VSS psum_in[99]=VSS
+ psum_in[98]=VSS psum_in[97]=VSS psum_in[96]=VSS psum_in[95]=VSS psum_in[94]=VSS
+ psum_in[93]=VSS psum_in[92]=VSS psum_in[91]=VSS psum_in[90]=VSS psum_in[89]=VSS
+ psum_in[88]=VSS psum_in[87]=VSS psum_in[86]=VSS psum_in[85]=VSS psum_in[84]=VSS
+ psum_in[83]=VSS psum_in[82]=VSS psum_in[81]=VSS psum_in[80]=VSS psum_in[79]=VSS
+ psum_in[78]=VSS psum_in[77]=VSS psum_in[76]=VSS psum_in[75]=VSS psum_in[74]=VSS
+ psum_in[73]=VSS psum_in[72]=VSS psum_in[71]=VSS psum_in[70]=VSS psum_in[69]=VSS
+ psum_in[68]=VSS psum_in[67]=VSS psum_in[66]=VSS psum_in[65]=VSS psum_in[64]=VSS
+ psum_in[63]=VSS psum_in[62]=VSS psum_in[61]=VSS psum_in[60]=VSS psum_in[59]=VSS
+ psum_in[58]=VSS psum_in[57]=VSS psum_in[56]=VSS psum_in[55]=VSS psum_in[54]=VSS
+ psum_in[53]=VSS psum_in[52]=VSS psum_in[51]=VSS psum_in[50]=VSS psum_in[49]=VSS
+ psum_in[48]=VSS psum_in[47]=VSS psum_in[46]=VSS psum_in[45]=VSS psum_in[44]=VSS
+ psum_in[43]=VSS psum_in[42]=VSS psum_in[41]=VSS psum_in[40]=VSS psum_in[39]=VSS
+ psum_in[38]=VSS psum_in[37]=VSS psum_in[36]=VSS psum_in[35]=VSS psum_in[34]=VSS
+ psum_in[33]=VSS psum_in[32]=VSS psum_in[31]=VSS psum_in[30]=VSS psum_in[29]=VSS
+ psum_in[28]=VSS psum_in[27]=VSS psum_in[26]=VSS psum_in[25]=VSS psum_in[24]=VSS
+ psum_in[23]=VSS psum_in[22]=VSS psum_in[21]=VSS psum_in[20]=VSS psum_in[19]=VSS
+ psum_in[18]=VSS psum_in[17]=VSS psum_in[16]=VSS psum_in[15]=VSS psum_in[14]=VSS
+ psum_in[13]=VSS psum_in[12]=VSS psum_in[11]=VSS psum_in[10]=VSS psum_in[9]=VSS
+ psum_in[8]=VSS psum_in[7]=VSS psum_in[6]=VSS psum_in[5]=VSS psum_in[4]=VSS
+ psum_in[3]=VSS psum_in[2]=VSS psum_in[1]=VSS psum_in[0]=VSS
+ psum_out[127]=grid_psum_out[127] psum_out[126]=grid_psum_out[126]
+ psum_out[125]=grid_psum_out[125] psum_out[124]=grid_psum_out[124]
+ psum_out[123]=grid_psum_out[123] psum_out[122]=grid_psum_out[122]
+ psum_out[121]=grid_psum_out[121] psum_out[120]=grid_psum_out[120]
+ psum_out[119]=grid_psum_out[119] psum_out[118]=grid_psum_out[118]
+ psum_out[117]=grid_psum_out[117] psum_out[116]=grid_psum_out[116]
+ psum_out[115]=grid_psum_out[115] psum_out[114]=grid_psum_out[114]
+ psum_out[113]=grid_psum_out[113] psum_out[112]=grid_psum_out[112]
+ psum_out[111]=grid_psum_out[111] psum_out[110]=grid_psum_out[110]
+ psum_out[109]=grid_psum_out[109] psum_out[108]=grid_psum_out[108]
+ psum_out[107]=grid_psum_out[107] psum_out[106]=grid_psum_out[106]
+ psum_out[105]=grid_psum_out[105] psum_out[104]=grid_psum_out[104]
+ psum_out[103]=grid_psum_out[103] psum_out[102]=grid_psum_out[102]
+ psum_out[101]=grid_psum_out[101] psum_out[100]=grid_psum_out[100]
+ psum_out[99]=grid_psum_out[99] psum_out[98]=grid_psum_out[98]
+ psum_out[97]=grid_psum_out[97] psum_out[96]=grid_psum_out[96]
+ psum_out[95]=grid_psum_out[95] psum_out[94]=grid_psum_out[94]
+ psum_out[93]=grid_psum_out[93] psum_out[92]=grid_psum_out[92]
+ psum_out[91]=grid_psum_out[91] psum_out[90]=grid_psum_out[90]
+ psum_out[89]=grid_psum_out[89] psum_out[88]=grid_psum_out[88]
+ psum_out[87]=grid_psum_out[87] psum_out[86]=grid_psum_out[86]
+ psum_out[85]=grid_psum_out[85] psum_out[84]=grid_psum_out[84]
+ psum_out[83]=grid_psum_out[83] psum_out[82]=grid_psum_out[82]
+ psum_out[81]=grid_psum_out[81] psum_out[80]=grid_psum_out[80]
+ psum_out[79]=grid_psum_out[79] psum_out[78]=grid_psum_out[78]
+ psum_out[77]=grid_psum_out[77] psum_out[76]=grid_psum_out[76]
+ psum_out[75]=grid_psum_out[75] psum_out[74]=grid_psum_out[74]
+ psum_out[73]=grid_psum_out[73] psum_out[72]=grid_psum_out[72]
+ psum_out[71]=grid_psum_out[71] psum_out[70]=grid_psum_out[70]
+ psum_out[69]=grid_psum_out[69] psum_out[68]=grid_psum_out[68]
+ psum_out[67]=grid_psum_out[67] psum_out[66]=grid_psum_out[66]
+ psum_out[65]=grid_psum_out[65] psum_out[64]=grid_psum_out[64]
+ psum_out[63]=grid_psum_out[63] psum_out[62]=grid_psum_out[62]
+ psum_out[61]=grid_psum_out[61] psum_out[60]=grid_psum_out[60]
+ psum_out[59]=grid_psum_out[59] psum_out[58]=grid_psum_out[58]
+ psum_out[57]=grid_psum_out[57] psum_out[56]=grid_psum_out[56]
+ psum_out[55]=grid_psum_out[55] psum_out[54]=grid_psum_out[54]
+ psum_out[53]=grid_psum_out[53] psum_out[52]=grid_psum_out[52]
+ psum_out[51]=grid_psum_out[51] psum_out[50]=grid_psum_out[50]
+ psum_out[49]=grid_psum_out[49] psum_out[48]=grid_psum_out[48]
+ psum_out[47]=grid_psum_out[47] psum_out[46]=grid_psum_out[46]
+ psum_out[45]=grid_psum_out[45] psum_out[44]=grid_psum_out[44]
+ psum_out[43]=grid_psum_out[43] psum_out[42]=grid_psum_out[42]
+ psum_out[41]=grid_psum_out[41] psum_out[40]=grid_psum_out[40]
+ psum_out[39]=grid_psum_out[39] psum_out[38]=grid_psum_out[38]
+ psum_out[37]=grid_psum_out[37] psum_out[36]=grid_psum_out[36]
+ psum_out[35]=grid_psum_out[35] psum_out[34]=grid_psum_out[34]
+ psum_out[33]=grid_psum_out[33] psum_out[32]=grid_psum_out[32]
+ psum_out[31]=grid_psum_out[31] psum_out[30]=grid_psum_out[30]
+ psum_out[29]=grid_psum_out[29] psum_out[28]=grid_psum_out[28]
+ psum_out[27]=grid_psum_out[27] psum_out[26]=grid_psum_out[26]
+ psum_out[25]=grid_psum_out[25] psum_out[24]=grid_psum_out[24]
+ psum_out[23]=grid_psum_out[23] psum_out[22]=grid_psum_out[22]
+ psum_out[21]=grid_psum_out[21] psum_out[20]=grid_psum_out[20]
+ psum_out[19]=grid_psum_out[19] psum_out[18]=grid_psum_out[18]
+ psum_out[17]=grid_psum_out[17] psum_out[16]=grid_psum_out[16]
+ psum_out[15]=grid_psum_out[15] psum_out[14]=grid_psum_out[14]
+ psum_out[13]=grid_psum_out[13] psum_out[12]=grid_psum_out[12]
+ psum_out[11]=grid_psum_out[11] psum_out[10]=grid_psum_out[10]
+ psum_out[9]=grid_psum_out[9] psum_out[8]=grid_psum_out[8]
+ psum_out[7]=grid_psum_out[7] psum_out[6]=grid_psum_out[6]
+ psum_out[5]=grid_psum_out[5] psum_out[4]=grid_psum_out[4]
+ psum_out[3]=grid_psum_out[3] psum_out[2]=grid_psum_out[2]
+ psum_out[1]=grid_psum_out[1] psum_out[0]=grid_psum_out[0] VDD=VDD VSS=VSS
+ ZCTSNET_109=ZCTSNET_9 ZCTSNET_111=ZCTSNET_3 ZCTSNET_113=ZCTSNET_10
+ ZCTSNET_116=ZCTSNET_16 ZCTSNET_117=ZCTSNET_12 ZCTSNET_118=ZCTSNET_26
+ ZCTSNET_119=ZCTSNET_25 ZCTSNET_120=ZCTSNET_21 ZCTSNET_125=ZCTSNET_2
+ ZCTSNET_130=ZCTSNET_8 ctosc_gls_1=ZCTSNET_19 ctosc_gls_3=ZCTSNET_1
+ HFSNET_43=HFSNET_38 HFSNET_58=HFSNET_40 HFSNET_59=HFSNET_42 HFSNET_60=HFSNET_43
+ HFSNET_61=HFSNET_45 HFSNET_66=HFSNET_47 HFSNET_67=HFSNET_48 HFSNET_68=HFSNET_49
+ HFSNET_69=HFSNET_51 HFSNET_70=HFSNET_54 HFSNET_71=HFSNET_55 HFSNET_72=HFSNET_71
+ HFSNET_73=HFSNET_73 HFSNET_74=HFSNET_74 HFSNET_76=HFSNET_75 HFSNET_77=HFSNET_77
+ HFSNET_79=HFSNET_82 HFSNET_80=HFSNET_83 HFSNET_84=HFSNET_84 HFSNET_85=HFSNET_85
+ HFSNET_88=HFSNET_86 HFSNET_89=HFSNET_87 HFSNET_90=HFSNET_88 HFSNET_94=HFSNET_89
+ HFSNET_95=HFSNET_91 HFSNET_96=HFSNET_92 HFSNET_97=HFSNET_93 HFSNET_98=HFSNET_94
+ HFSNET_99=HFSNET_95 HFSNET_100=HFSNET_99 HFSNET_101=HFSNET_99
+ ZCTSNET_1=ZCTSNET_4 ZCTSNET_2=ZCTSNET_6 ZCTSNET_11=ZCTSNET_20
+ ZCTSNET_14=ZCTSNET_22 ZCTSNET_24=ZCTSNET_27 ZCTSNET_25=ZCTSNET_28
+ ZCTSNET_27=ZCTSNET_31 ZCTSNET_28=ZCTSNET_30 ZCTSNET_30=ZCTSNET_58
Xu_deskew unpu_deskew $PINS ZCTSNET_36=ZCTSNET_16 rst_n=HFSNET_56
+ array_en=HFSNET_39 psum_in[127]=grid_psum_out[127]
+ psum_in[126]=grid_psum_out[126] psum_in[125]=grid_psum_out[125]
+ psum_in[124]=grid_psum_out[124] psum_in[123]=grid_psum_out[123]
+ psum_in[122]=grid_psum_out[122] psum_in[121]=grid_psum_out[121]
+ psum_in[120]=grid_psum_out[120] psum_in[119]=grid_psum_out[119]
+ psum_in[118]=grid_psum_out[118] psum_in[117]=grid_psum_out[117]
+ psum_in[116]=grid_psum_out[116] psum_in[115]=grid_psum_out[115]
+ psum_in[114]=grid_psum_out[114] psum_in[113]=grid_psum_out[113]
+ psum_in[112]=grid_psum_out[112] psum_in[111]=grid_psum_out[111]
+ psum_in[110]=grid_psum_out[110] psum_in[109]=grid_psum_out[109]
+ psum_in[108]=grid_psum_out[108] psum_in[107]=grid_psum_out[107]
+ psum_in[106]=grid_psum_out[106] psum_in[105]=grid_psum_out[105]
+ psum_in[104]=grid_psum_out[104] psum_in[103]=grid_psum_out[103]
+ psum_in[102]=grid_psum_out[102] psum_in[101]=grid_psum_out[101]
+ psum_in[100]=grid_psum_out[100] psum_in[99]=grid_psum_out[99]
+ psum_in[98]=grid_psum_out[98] psum_in[97]=grid_psum_out[97]
+ psum_in[96]=grid_psum_out[96] psum_in[95]=grid_psum_out[95]
+ psum_in[94]=grid_psum_out[94] psum_in[93]=grid_psum_out[93]
+ psum_in[92]=grid_psum_out[92] psum_in[91]=grid_psum_out[91]
+ psum_in[90]=grid_psum_out[90] psum_in[89]=grid_psum_out[89]
+ psum_in[88]=grid_psum_out[88] psum_in[87]=grid_psum_out[87]
+ psum_in[86]=grid_psum_out[86] psum_in[85]=grid_psum_out[85]
+ psum_in[84]=grid_psum_out[84] psum_in[83]=grid_psum_out[83]
+ psum_in[82]=grid_psum_out[82] psum_in[81]=grid_psum_out[81]
+ psum_in[80]=grid_psum_out[80] psum_in[79]=grid_psum_out[79]
+ psum_in[78]=grid_psum_out[78] psum_in[77]=grid_psum_out[77]
+ psum_in[76]=grid_psum_out[76] psum_in[75]=grid_psum_out[75]
+ psum_in[74]=grid_psum_out[74] psum_in[73]=grid_psum_out[73]
+ psum_in[72]=grid_psum_out[72] psum_in[71]=grid_psum_out[71]
+ psum_in[70]=grid_psum_out[70] psum_in[69]=grid_psum_out[69]
+ psum_in[68]=grid_psum_out[68] psum_in[67]=grid_psum_out[67]
+ psum_in[66]=grid_psum_out[66] psum_in[65]=grid_psum_out[65]
+ psum_in[64]=grid_psum_out[64] psum_in[63]=grid_psum_out[63]
+ psum_in[62]=grid_psum_out[62] psum_in[61]=grid_psum_out[61]
+ psum_in[60]=grid_psum_out[60] psum_in[59]=grid_psum_out[59]
+ psum_in[58]=grid_psum_out[58] psum_in[57]=grid_psum_out[57]
+ psum_in[56]=grid_psum_out[56] psum_in[55]=grid_psum_out[55]
+ psum_in[54]=grid_psum_out[54] psum_in[53]=grid_psum_out[53]
+ psum_in[52]=grid_psum_out[52] psum_in[51]=grid_psum_out[51]
+ psum_in[50]=grid_psum_out[50] psum_in[49]=grid_psum_out[49]
+ psum_in[48]=grid_psum_out[48] psum_in[47]=grid_psum_out[47]
+ psum_in[46]=grid_psum_out[46] psum_in[45]=grid_psum_out[45]
+ psum_in[44]=grid_psum_out[44] psum_in[43]=grid_psum_out[43]
+ psum_in[42]=grid_psum_out[42] psum_in[41]=grid_psum_out[41]
+ psum_in[40]=grid_psum_out[40] psum_in[39]=grid_psum_out[39]
+ psum_in[38]=grid_psum_out[38] psum_in[37]=grid_psum_out[37]
+ psum_in[36]=grid_psum_out[36] psum_in[35]=grid_psum_out[35]
+ psum_in[34]=grid_psum_out[34] psum_in[33]=grid_psum_out[33]
+ psum_in[32]=grid_psum_out[32] psum_in[31]=grid_psum_out[31]
+ psum_in[30]=grid_psum_out[30] psum_in[29]=grid_psum_out[29]
+ psum_in[28]=grid_psum_out[28] psum_in[27]=grid_psum_out[27]
+ psum_in[26]=grid_psum_out[26] psum_in[25]=grid_psum_out[25]
+ psum_in[24]=grid_psum_out[24] psum_in[23]=grid_psum_out[23]
+ psum_in[22]=grid_psum_out[22] psum_in[21]=grid_psum_out[21]
+ psum_in[20]=grid_psum_out[20] psum_in[19]=grid_psum_out[19]
+ psum_in[18]=grid_psum_out[18] psum_in[17]=grid_psum_out[17]
+ psum_in[16]=grid_psum_out[16] psum_in[15]=grid_psum_out[15]
+ psum_in[14]=grid_psum_out[14] psum_in[13]=grid_psum_out[13]
+ psum_in[12]=grid_psum_out[12] psum_in[11]=grid_psum_out[11]
+ psum_in[10]=grid_psum_out[10] psum_in[9]=grid_psum_out[9]
+ psum_in[8]=grid_psum_out[8] psum_in[7]=grid_psum_out[7]
+ psum_in[6]=grid_psum_out[6] psum_in[5]=grid_psum_out[5]
+ psum_in[4]=grid_psum_out[4] psum_in[3]=grid_psum_out[3]
+ psum_in[2]=grid_psum_out[2] psum_in[1]=grid_psum_out[1]
+ psum_in[0]=grid_psum_out[0] c_out[127]=c_in[127] c_out[126]=c_in[126]
+ c_out[125]=c_in[125] c_out[124]=c_in[124] c_out[123]=c_in[123]
+ c_out[122]=c_in[122] c_out[121]=c_in[121] c_out[120]=c_in[120]
+ c_out[119]=c_in[119] c_out[118]=c_in[118] c_out[117]=c_in[117]
+ c_out[116]=c_in[116] c_out[115]=c_in[115] c_out[114]=c_in[114]
+ c_out[113]=c_in[113] c_out[112]=c_in[112] c_out[111]=c_in[111]
+ c_out[110]=c_in[110] c_out[109]=c_in[109] c_out[108]=c_in[108]
+ c_out[107]=c_in[107] c_out[106]=c_in[106] c_out[105]=c_in[105]
+ c_out[104]=c_in[104] c_out[103]=c_in[103] c_out[102]=c_in[102]
+ c_out[101]=c_in[101] c_out[100]=c_in[100] c_out[99]=c_in[99] c_out[98]=c_in[98]
+ c_out[97]=c_in[97] c_out[96]=c_in[96] c_out[95]=c_in[95] c_out[94]=c_in[94]
+ c_out[93]=c_in[93] c_out[92]=c_in[92] c_out[91]=c_in[91] c_out[90]=c_in[90]
+ c_out[89]=c_in[89] c_out[88]=c_in[88] c_out[87]=c_in[87] c_out[86]=c_in[86]
+ c_out[85]=c_in[85] c_out[84]=c_in[84] c_out[83]=c_in[83] c_out[82]=c_in[82]
+ c_out[81]=c_in[81] c_out[80]=c_in[80] c_out[79]=c_in[79] c_out[78]=c_in[78]
+ c_out[77]=c_in[77] c_out[76]=c_in[76] c_out[75]=c_in[75] c_out[74]=c_in[74]
+ c_out[73]=c_in[73] c_out[72]=c_in[72] c_out[71]=c_in[71] c_out[70]=c_in[70]
+ c_out[69]=c_in[69] c_out[68]=c_in[68] c_out[67]=c_in[67] c_out[66]=c_in[66]
+ c_out[65]=c_in[65] c_out[64]=c_in[64] c_out[63]=c_in[63] c_out[62]=c_in[62]
+ c_out[61]=c_in[61] c_out[60]=c_in[60] c_out[59]=c_in[59] c_out[58]=c_in[58]
+ c_out[57]=c_in[57] c_out[56]=c_in[56] c_out[55]=c_in[55] c_out[54]=c_in[54]
+ c_out[53]=c_in[53] c_out[52]=c_in[52] c_out[51]=c_in[51] c_out[50]=c_in[50]
+ c_out[49]=c_in[49] c_out[48]=c_in[48] c_out[47]=c_in[47] c_out[46]=c_in[46]
+ c_out[45]=c_in[45] c_out[44]=c_in[44] c_out[43]=c_in[43] c_out[42]=c_in[42]
+ c_out[41]=c_in[41] c_out[40]=c_in[40] c_out[39]=c_in[39] c_out[38]=c_in[38]
+ c_out[37]=c_in[37] c_out[36]=c_in[36] c_out[35]=c_in[35] c_out[34]=c_in[34]
+ c_out[33]=c_in[33] c_out[32]=c_in[32] c_out[31]=c_in[31] c_out[30]=c_in[30]
+ c_out[29]=c_in[29] c_out[28]=c_in[28] c_out[27]=c_in[27] c_out[26]=c_in[26]
+ c_out[25]=c_in[25] c_out[24]=c_in[24] c_out[23]=c_in[23] c_out[22]=c_in[22]
+ c_out[21]=c_in[21] c_out[20]=c_in[20] c_out[19]=c_in[19] c_out[18]=c_in[18]
+ c_out[17]=c_in[17] c_out[16]=c_in[16] c_out[15]=c_in[15] c_out[14]=c_in[14]
+ c_out[13]=c_in[13] c_out[12]=c_in[12] c_out[11]=c_in[11] c_out[10]=c_in[10]
+ c_out[9]=c_in[9] c_out[8]=c_in[8] c_out[7]=c_in[7] c_out[6]=c_in[6]
+ c_out[5]=c_in[5] c_out[4]=c_in[4] c_out[3]=c_in[3] c_out[2]=c_in[2]
+ c_out[1]=c_in[1] c_out[0]=c_in[0] VDD=VDD VSS=VSS ZCTSNET_39=ZCTSNET_22
+ ZCTSNET_40=ZCTSNET_12 ZCTSNET_43=ZCTSNET_1 HFSNET_8=HFSNET_40
+ HFSNET_9=HFSNET_46 HFSNET_10=HFSNET_47 HFSNET_11=HFSNET_48 HFSNET_12=HFSNET_49
+ HFSNET_14=HFSNET_50 HFSNET_16=HFSNET_51 HFSNET_18=HFSNET_52 HFSNET_21=HFSNET_54
+ HFSNET_22=array_en HFSNET_24=HFSNET_57 HFSNET_25=HFSNET_58 HFSNET_26=HFSNET_59
+ HFSNET_27=HFSNET_74 HFSNET_29=HFSNET_75 HFSNET_30=HFSNET_83 HFSNET_31=HFSNET_90
+ HFSNET_32=HFSNET_91 HFSNET_33=HFSNET_94 HFSNET_34=HFSNET_95 HFSNET_35=HFSNET_96
+ ZCTSNET_2=ZCTSNET_14 ZCTSNET_4=ZCTSNET_17 ZCTSNET_5=ZCTSNET_19
+ ZCTSNET_8=ZCTSNET_45 sbcto_ht1_0=ZCTSNET_20
XU2 inv0d4 $PINS I=VSS ZN=pready VDD=VDD VSS=VSS
Xcopt_h_inst_3035 dl02d1 $PINS I=dma_rdata[26] Z=copt_net_205 VDD=VDD VSS=VSS
Xropt_h_inst_5867 bufbd4 $PINS I=ropt_net_3211 Z=prdata[1] VDD=VDD VSS=VSS
XctmTdsLR_1_2998 buffd7 $PINS I=n77 Z=prdata[16] VDD=VDD VSS=VSS
XctmTdsLR_1_2999 bufbd4 $PINS I=n73 Z=prdata[20] VDD=VDD VSS=VSS
Xcopt_h_inst_3046 dl02d1 $PINS I=dma_rdata[9] Z=copt_net_216 VDD=VDD VSS=VSS
Xcopt_h_inst_3063 dl02d1 $PINS I=earlybuf_pwdata_4__22_a1_n Z=copt_net_233
+ VDD=VDD VSS=VSS
Xcopt_h_inst_5775 bufbd4 $PINS I=aps_rename_140_ Z=dma_valid VDD=VDD VSS=VSS
Xantbuf_paddr_7__0_t1a1 buffd1 $PINS I=paddr[7] Z=antbuf_paddr_7__0_t1a1_n
+ VDD=VDD VSS=VSS
XU20 buffd4 $PINS I=n63 Z=prdata[31] VDD=VDD VSS=VSS
XHFSINV_63092_583 inv0d1 $PINS I=HFSNET_40 ZN=HFSNET_39 VDD=VDD VSS=VSS
XctmTdsLR_1_2964 buffd4 $PINS I=n82 Z=prdata[11] VDD=VDD VSS=VSS
XZCTSBUF_54466_2497 buffda $PINS I=ZCTSNET_22 Z=ZCTSNET_1 VDD=VDD VSS=VSS
XU51 buffd4 $PINS I=n79 Z=prdata[14] VDD=VDD VSS=VSS
XU58 buffd4 $PINS I=n75 Z=prdata[18] VDD=VDD VSS=VSS
XU61 buffd3 $PINS I=paddr[2] Z=n60 VDD=VDD VSS=VSS
XHFSINV_7238_617 inv0d2 $PINS I=HFSNET_60 ZN=HFSNET_56 VDD=VDD VSS=VSS
XHFSINV_7826_619 inv0d2 $PINS I=HFSNET_60 ZN=HFSNET_57 VDD=VDD VSS=VSS
XZCTSBUF_51565_2499 buffda $PINS I=ZCTSNET_6 Z=ZCTSNET_2 VDD=VDD VSS=VSS
XZCTSBUF_46304_2500 buffda $PINS I=ZCTSNET_6 Z=ZCTSNET_3 VDD=VDD VSS=VSS
XZCTSBUF_47812_2501 buffda $PINS I=ZCTSNET_6 Z=ZCTSNET_4 VDD=VDD VSS=VSS
XZCTSBUF_53291_2502 buffd7 $PINS I=ZCTSNET_6 Z=ZCTSNET_5 VDD=VDD VSS=VSS
XZCTSBUF_53572_2503 bufbda $PINS I=ZCTSNET_22 Z=ZCTSNET_6 VDD=VDD VSS=VSS
XZCTSBUF_43580_2504 buffd7 $PINS I=ZCTSNET_22 Z=ZCTSNET_7 VDD=VDD VSS=VSS
XZCTSBUF_41569_2506 bufbdf $PINS I=ZCTSNET_22 Z=ZCTSNET_8 VDD=VDD VSS=VSS
XZCTSBUF_14842_2507 buffd3 $PINS I=ZCTSNET_22 Z=ZCTSNET_9 VDD=VDD VSS=VSS
XZCTSBUF_14245_2509 bufbdf $PINS I=ZCTSNET_22 Z=ZCTSNET_10 VDD=VDD VSS=VSS
Xsbcto_ht1_inst_2806 buffd3 $PINS I=ZCTSNET_60 Z=sbcto_ht1_1 VDD=VDD VSS=VSS
XZCTSBUF_23079_2511 bufbda $PINS I=ZCTSNET_22 Z=ZCTSNET_12 VDD=VDD VSS=VSS
Xsbcto_ht1_inst_2807 buffd7 $PINS I=ZCTSNET_58 Z=sbcto_ht1_2 VDD=VDD VSS=VSS
XZCTSBUF_23080_2513 buffda $PINS I=ZCTSNET_22 Z=ZCTSNET_14 VDD=VDD VSS=VSS
XctmTdsLR_1_2965 bufbd7 $PINS I=n81 Z=prdata[12] VDD=VDD VSS=VSS
XZCTSBUF_25794_2515 buffda $PINS I=ZCTSNET_20 Z=ZCTSNET_16 VDD=VDD VSS=VSS
XZCTSBUF_31312_2516 buffda $PINS I=ZCTSNET_20 Z=ZCTSNET_17 VDD=VDD VSS=VSS
XctmTdsLR_1_2966 bufbd4 $PINS I=n87 Z=prdata[6] VDD=VDD VSS=VSS
XZCTSBUF_28593_2518 buffda $PINS I=ZCTSNET_20 Z=ZCTSNET_19 VDD=VDD VSS=VSS
XZCTSBUF_33359_2519 bufbda $PINS I=ZCTSNET_22 Z=ZCTSNET_20 VDD=VDD VSS=VSS
XZCTSBUF_57952_2521 bufbda $PINS I=ZCTSNET_22 Z=ZCTSNET_21 VDD=VDD VSS=VSS
XZCTSINV_60805_2522 invbdf $PINS I=sbcto_ht1_1 ZN=ZCTSNET_22 VDD=VDD VSS=VSS
XctmTdsLR_1_2967 buffd7 $PINS I=n85 Z=prdata[8] VDD=VDD VSS=VSS
XctmTdsLR_1_2968 buffd7 $PINS I=n80 Z=prdata[13] VDD=VDD VSS=VSS
XZCTSBUF_86727_2532 bufbd3 $PINS I=ZCTSNET_31 Z=ZCTSNET_25 VDD=VDD VSS=VSS
XZCTSBUF_81175_2533 bufbd3 $PINS I=ZCTSNET_31 Z=ZCTSNET_26 VDD=VDD VSS=VSS
XZCTSBUF_82137_2534 buffd4 $PINS I=ZCTSNET_31 Z=ZCTSNET_27 VDD=VDD VSS=VSS
XZCTSBUF_84540_2535 bufbd3 $PINS I=ZCTSNET_31 Z=ZCTSNET_28 VDD=VDD VSS=VSS
XctmTdsLR_1_2969 buffd4 $PINS I=n78 Z=prdata[15] VDD=VDD VSS=VSS
XZCTSBUF_85447_2537 bufbd3 $PINS I=ZCTSNET_31 Z=ZCTSNET_30 VDD=VDD VSS=VSS
XZCTSINV_92165_2538 invbdk $PINS I=ZCTSNET_59 ZN=ZCTSNET_31 VDD=VDD VSS=VSS
XctmTdsLR_1_2970 bufbda $PINS I=n76 Z=prdata[17] VDD=VDD VSS=VSS
XZCTSBUF_63124_2540 buffda $PINS I=ZCTSNET_43 Z=ZCTSNET_33 VDD=VDD VSS=VSS
XZCTSBUF_77511_2541 buffda $PINS I=ZCTSNET_43 Z=ZCTSNET_34 VDD=VDD VSS=VSS
XctmTdsLR_1_2971 bufbd7 $PINS I=n74 Z=prdata[19] VDD=VDD VSS=VSS
XZCTSBUF_72675_2544 buffd3 $PINS I=ZCTSNET_43 Z=ZCTSNET_36 VDD=VDD VSS=VSS
XZCTSBUF_74777_2545 buffda $PINS I=ZCTSNET_43 Z=ZCTSNET_37 VDD=VDD VSS=VSS
Xearlybuf_rst_n_1_a2 buffd1 $PINS I=rst_n Z=earlybuf_rst_n_1_a2_n VDD=VDD
+ VSS=VSS
Xearlybuf_pwdata_31__2_a1 buffd1 $PINS I=pwdata[31]
+ Z=earlybuf_pwdata_31__2_a1_n VDD=VDD VSS=VSS
XHFSINV_13_284 invbd4 $PINS I=aps_rename_2_ ZN=dma_addr[31] VDD=VDD VSS=VSS
XHFSINV_24_286 invbd4 $PINS I=aps_rename_6_ ZN=dma_addr[1] VDD=VDD VSS=VSS
XHFSINV_21_287 invbd4 $PINS I=aps_rename_4_ ZN=dma_addr[11] VDD=VDD VSS=VSS
XHFSINV_2_fp_288 invbd4 $PINS I=aps_rename_3_ ZN=dma_addr[13] VDD=VDD VSS=VSS
XHFSINV_65064_584 inv0d2 $PINS I=HFSNET_53 ZN=HFSNET_40 VDD=VDD VSS=VSS
XHFSBUF_28958_585 buffd1 $PINS I=HFSNET_45 Z=HFSNET_41 VDD=VDD VSS=VSS
XHFSINV_28828_587 inv0d1 $PINS I=HFSNET_45 ZN=HFSNET_42 VDD=VDD VSS=VSS
XHFSINV_32665_588 inv0d1 $PINS I=HFSNET_45 ZN=HFSNET_43 VDD=VDD VSS=VSS
XHFSINV_30526_590 inv0d1 $PINS I=HFSNET_45 ZN=HFSNET_44 VDD=VDD VSS=VSS
XHFSINV_38423_598 inv0d2 $PINS I=HFSNET_53 ZN=HFSNET_45 VDD=VDD VSS=VSS
XHFSINV_7553_599 inv0d1 $PINS I=HFSNET_52 ZN=HFSNET_46 VDD=VDD VSS=VSS
XHFSINV_10162_600 inv0d1 $PINS I=HFSNET_52 ZN=HFSNET_47 VDD=VDD VSS=VSS
XHFSINV_2414_601 inv0d1 $PINS I=HFSNET_52 ZN=HFSNET_48 VDD=VDD VSS=VSS
XHFSINV_15339_603 inv0d1 $PINS I=HFSNET_52 ZN=HFSNET_49 VDD=VDD VSS=VSS
XHFSBUF_7805_605 buffd1 $PINS I=HFSNET_52 Z=HFSNET_50 VDD=VDD VSS=VSS
XHFSBUF_2382_607 buffd1 $PINS I=HFSNET_52 Z=HFSNET_51 VDD=VDD VSS=VSS
XHFSINV_18081_610 inv0d2 $PINS I=HFSNET_53 ZN=HFSNET_52 VDD=VDD VSS=VSS
XHFSINV_66500_611 inv0d1 $PINS I=array_en ZN=HFSNET_53 VDD=VDD VSS=VSS
XHFSBUF_19836_612 buffd1 $PINS I=HFSNET_55 Z=HFSNET_54 VDD=VDD VSS=VSS
XHFSINV_65884_613 inv0d1 $PINS I=array_en ZN=HFSNET_55 VDD=VDD VSS=VSS
XHFSINV_7961_620 inv0d2 $PINS I=HFSNET_60 ZN=HFSNET_58 VDD=VDD VSS=VSS
XHFSINV_7673_621 inv0d2 $PINS I=HFSNET_60 ZN=HFSNET_59 VDD=VDD VSS=VSS
XHFSINV_8708_623 inv0d1 $PINS I=HFSNET_84 ZN=HFSNET_60 VDD=VDD VSS=VSS
XHFSINV_11410_627 inv0d2 $PINS I=HFSNET_70 ZN=HFSNET_61 VDD=VDD VSS=VSS
XHFSINV_11540_628 inv0d2 $PINS I=HFSNET_70 ZN=HFSNET_62 VDD=VDD VSS=VSS
XHFSINV_11259_629 inv0d2 $PINS I=HFSNET_70 ZN=HFSNET_63 VDD=VDD VSS=VSS
XHFSINV_11057_630 inv0d2 $PINS I=HFSNET_70 ZN=HFSNET_64 VDD=VDD VSS=VSS
XHFSINV_12134_632 inv0d2 $PINS I=HFSNET_70 ZN=HFSNET_65 VDD=VDD VSS=VSS
XHFSINV_10556_635 inv0d2 $PINS I=HFSNET_70 ZN=HFSNET_66 VDD=VDD VSS=VSS
XHFSINV_9209_638 inv0d2 $PINS I=HFSNET_70 ZN=HFSNET_67 VDD=VDD VSS=VSS
XHFSINV_9455_639 inv0d2 $PINS I=HFSNET_70 ZN=HFSNET_68 VDD=VDD VSS=VSS
XHFSINV_9355_642 inv0d2 $PINS I=HFSNET_70 ZN=HFSNET_69 VDD=VDD VSS=VSS
XHFSINV_13077_645 inv0d2 $PINS I=HFSNET_84 ZN=HFSNET_70 VDD=VDD VSS=VSS
XHFSBUF_6802_646 buffd1 $PINS I=HFSNET_84 Z=HFSNET_71 VDD=VDD VSS=VSS
XHFSBUF_6909_648 buffd3 $PINS I=HFSNET_84 Z=HFSNET_72 VDD=VDD VSS=VSS
XHFSBUF_6693_649 buffd3 $PINS I=HFSNET_84 Z=HFSNET_73 VDD=VDD VSS=VSS
XHFSINV_19562_652 inv0d2 $PINS I=HFSNET_83 ZN=HFSNET_74 VDD=VDD VSS=VSS
XHFSINV_19417_653 inv0d2 $PINS I=HFSNET_83 ZN=HFSNET_75 VDD=VDD VSS=VSS
XHFSINV_16256_655 inv0d2 $PINS I=HFSNET_83 ZN=HFSNET_76 VDD=VDD VSS=VSS
XHFSINV_16357_656 inv0d2 $PINS I=HFSNET_83 ZN=HFSNET_77 VDD=VDD VSS=VSS
XHFSINV_16141_657 inv0d2 $PINS I=HFSNET_83 ZN=HFSNET_78 VDD=VDD VSS=VSS
XHFSINV_17643_660 inv0d2 $PINS I=HFSNET_83 ZN=HFSNET_79 VDD=VDD VSS=VSS
XHFSINV_17501_661 inv0d2 $PINS I=HFSNET_83 ZN=HFSNET_80 VDD=VDD VSS=VSS
Xearlybuf_pwdata_30__3_a1 buffd1 $PINS I=pwdata[30]
+ Z=earlybuf_pwdata_30__3_a1_n VDD=VDD VSS=VSS
XHFSINV_18322_667 inv0d2 $PINS I=HFSNET_83 ZN=HFSNET_82 VDD=VDD VSS=VSS
XHFSINV_20390_672 inv0d4 $PINS I=HFSNET_84 ZN=HFSNET_83 VDD=VDD VSS=VSS
XHFSBUF_21604_673 dl01d2 $PINS I=earlybuf_rst_n_1_a2_n Z=HFSNET_84 VDD=VDD
+ VSS=VSS
XHFSINV_583_676 inv0d2 $PINS I=HFSNET_99 ZN=HFSNET_85 VDD=VDD VSS=VSS
XHFSINV_811_677 inv0d2 $PINS I=HFSNET_99 ZN=HFSNET_86 VDD=VDD VSS=VSS
XHFSINV_697_679 inv0d2 $PINS I=HFSNET_99 ZN=HFSNET_87 VDD=VDD VSS=VSS
XHFSINV_2164_686 inv0d2 $PINS I=HFSNET_99 ZN=HFSNET_88 VDD=VDD VSS=VSS
XHFSINV_2349_687 inv0d2 $PINS I=HFSNET_99 ZN=HFSNET_89 VDD=VDD VSS=VSS
XHFSINV_3214_688 inv0d2 $PINS I=HFSNET_99 ZN=HFSNET_90 VDD=VDD VSS=VSS
XHFSINV_3376_689 inv0d2 $PINS I=HFSNET_99 ZN=HFSNET_91 VDD=VDD VSS=VSS
XHFSINV_2868_691 inv0d2 $PINS I=HFSNET_99 ZN=HFSNET_92 VDD=VDD VSS=VSS
XHFSINV_2733_692 inv0d2 $PINS I=HFSNET_99 ZN=HFSNET_93 VDD=VDD VSS=VSS
XHFSINV_4032_694 inv0d2 $PINS I=HFSNET_99 ZN=HFSNET_94 VDD=VDD VSS=VSS
XHFSINV_4183_695 inv0d2 $PINS I=HFSNET_99 ZN=HFSNET_95 VDD=VDD VSS=VSS
XHFSINV_1265_696 inv0d2 $PINS I=HFSNET_99 ZN=HFSNET_96 VDD=VDD VSS=VSS
Xearlybuf_pwdata_28__4_a1 buffd1 $PINS I=pwdata[28]
+ Z=earlybuf_pwdata_28__4_a1_n VDD=VDD VSS=VSS
Xearlybuf_pwdata_26__5_a1 buffd1 $PINS I=pwdata[26]
+ Z=earlybuf_pwdata_26__5_a1_n VDD=VDD VSS=VSS
XHFSINV_6350_703 inv0d2 $PINS I=earlybuf_rst_n_1_a2_n ZN=HFSNET_99 VDD=VDD
+ VSS=VSS
Xearlybuf_pwdata_24__6_a1 buffd1 $PINS I=pwdata[24]
+ Z=earlybuf_pwdata_24__6_a1_n VDD=VDD VSS=VSS
Xearlybuf_pwdata_23__7_a1 buffd1 $PINS I=pwdata[23]
+ Z=earlybuf_pwdata_23__7_a1_n VDD=VDD VSS=VSS
Xearlybuf_pwdata_22__8_a1 buffd1 $PINS I=pwdata[22]
+ Z=earlybuf_pwdata_22__8_a1_n VDD=VDD VSS=VSS
Xearlybuf_pwdata_21__9_a1 buffd1 $PINS I=pwdata[21]
+ Z=earlybuf_pwdata_21__9_a1_n VDD=VDD VSS=VSS
Xearlybuf_pwdata_20__10_a1 buffd1 $PINS I=pwdata[20]
+ Z=earlybuf_pwdata_20__10_a1_n VDD=VDD VSS=VSS
Xearlybuf_pwdata_18__11_a1 buffd1 $PINS I=pwdata[18]
+ Z=earlybuf_pwdata_18__11_a1_n VDD=VDD VSS=VSS
Xearlybuf_pwdata_16__12_a1 buffd1 $PINS I=pwdata[16]
+ Z=earlybuf_pwdata_16__12_a1_n VDD=VDD VSS=VSS
Xearlybuf_pwdata_14__13_a1 buffd1 $PINS I=pwdata[14]
+ Z=earlybuf_pwdata_14__13_a1_n VDD=VDD VSS=VSS
Xearlybuf_pwdata_12__14_a1 buffd1 $PINS I=pwdata[12]
+ Z=earlybuf_pwdata_12__14_a1_n VDD=VDD VSS=VSS
Xearlybuf_pwdata_11__15_a1 buffd1 $PINS I=pwdata[11]
+ Z=earlybuf_pwdata_11__15_a1_n VDD=VDD VSS=VSS
Xearlybuf_pwdata_10__16_a1 buffd1 $PINS I=pwdata[10]
+ Z=earlybuf_pwdata_10__16_a1_n VDD=VDD VSS=VSS
Xearlybuf_pwdata_9__17_a1 buffd1 $PINS I=pwdata[9] Z=earlybuf_pwdata_9__17_a1_n
+ VDD=VDD VSS=VSS
Xearlybuf_pwdata_8__18_a1 buffd1 $PINS I=pwdata[8] Z=earlybuf_pwdata_8__18_a1_n
+ VDD=VDD VSS=VSS
Xearlybuf_pwdata_7__19_a1 buffd1 $PINS I=pwdata[7] Z=earlybuf_pwdata_7__19_a1_n
+ VDD=VDD VSS=VSS
Xearlybuf_pwdata_6__20_a1 buffd1 $PINS I=pwdata[6] Z=earlybuf_pwdata_6__20_a1_n
+ VDD=VDD VSS=VSS
Xearlybuf_pwdata_5__21_a1 buffd1 $PINS I=pwdata[5] Z=earlybuf_pwdata_5__21_a1_n
+ VDD=VDD VSS=VSS
Xearlybuf_pwdata_4__22_a1 buffd1 $PINS I=pwdata[4] Z=earlybuf_pwdata_4__22_a1_n
+ VDD=VDD VSS=VSS
Xearlybuf_pwdata_3__23_a1 buffd1 $PINS I=pwdata[3] Z=earlybuf_pwdata_3__23_a1_n
+ VDD=VDD VSS=VSS
Xearlybuf_pwdata_2__24_a1 buffd1 $PINS I=pwdata[2] Z=earlybuf_pwdata_2__24_a1_n
+ VDD=VDD VSS=VSS
Xearlybuf_pwdata_0__25_a1 buffd1 $PINS I=pwdata[0] Z=earlybuf_pwdata_0__25_a1_n
+ VDD=VDD VSS=VSS
Xearlybuf_psel_26_a1 buffd1 $PINS I=psel Z=earlybuf_psel_26_a1_n VDD=VDD
+ VSS=VSS
Xearlybuf_dma_rdata_31__27_a1 buffd1 $PINS I=dma_rdata[31]
+ Z=earlybuf_dma_rdata_31__27_a1_n VDD=VDD VSS=VSS
Xearlybuf_dma_rdata_30__28_a1 buffd1 $PINS I=dma_rdata[30]
+ Z=earlybuf_dma_rdata_30__28_a1_n VDD=VDD VSS=VSS
Xearlybuf_dma_rdata_29__29_a1 buffd1 $PINS I=dma_rdata[29]
+ Z=earlybuf_dma_rdata_29__29_a1_n VDD=VDD VSS=VSS
Xearlybuf_dma_rdata_28__30_a1 buffd1 $PINS I=dma_rdata[28]
+ Z=earlybuf_dma_rdata_28__30_a1_n VDD=VDD VSS=VSS
Xearlybuf_dma_rdata_27__31_a1 buffd1 $PINS I=dma_rdata[27]
+ Z=earlybuf_dma_rdata_27__31_a1_n VDD=VDD VSS=VSS
Xearlybuf_dma_rdata_26__32_a1 buffd1 $PINS I=copt_net_205
+ Z=earlybuf_dma_rdata_26__32_a1_n VDD=VDD VSS=VSS
Xearlybuf_dma_rdata_25__33_a1 buffd1 $PINS I=dma_rdata[25]
+ Z=earlybuf_dma_rdata_25__33_a1_n VDD=VDD VSS=VSS
Xearlybuf_dma_rdata_24__34_a1 buffd1 $PINS I=dma_rdata[24]
+ Z=earlybuf_dma_rdata_24__34_a1_n VDD=VDD VSS=VSS
Xearlybuf_dma_rdata_23__35_a1 buffd1 $PINS I=dma_rdata[23]
+ Z=earlybuf_dma_rdata_23__35_a1_n VDD=VDD VSS=VSS
Xearlybuf_dma_rdata_22__36_a1 buffd1 $PINS I=dma_rdata[22]
+ Z=earlybuf_dma_rdata_22__36_a1_n VDD=VDD VSS=VSS
Xearlybuf_dma_rdata_20__37_a1 buffd1 $PINS I=dma_rdata[20]
+ Z=earlybuf_dma_rdata_20__37_a1_n VDD=VDD VSS=VSS
Xearlybuf_dma_rdata_19__38_a1 buffd1 $PINS I=dma_rdata[19]
+ Z=earlybuf_dma_rdata_19__38_a1_n VDD=VDD VSS=VSS
Xearlybuf_dma_rdata_18__39_a1 buffd1 $PINS I=dma_rdata[18]
+ Z=earlybuf_dma_rdata_18__39_a1_n VDD=VDD VSS=VSS
Xearlybuf_dma_rdata_17__40_a1 buffd1 $PINS I=dma_rdata[17]
+ Z=earlybuf_dma_rdata_17__40_a1_n VDD=VDD VSS=VSS
Xearlybuf_dma_rdata_16__41_a1 buffd1 $PINS I=dma_rdata[16]
+ Z=earlybuf_dma_rdata_16__41_a1_n VDD=VDD VSS=VSS
Xearlybuf_dma_rdata_15__42_a1 buffd1 $PINS I=dma_rdata[15]
+ Z=earlybuf_dma_rdata_15__42_a1_n VDD=VDD VSS=VSS
Xearlybuf_dma_rdata_14__43_a1 buffd1 $PINS I=dma_rdata[14]
+ Z=earlybuf_dma_rdata_14__43_a1_n VDD=VDD VSS=VSS
Xearlybuf_dma_rdata_13__44_a1 buffd1 $PINS I=dma_rdata[13]
+ Z=earlybuf_dma_rdata_13__44_a1_n VDD=VDD VSS=VSS
Xearlybuf_dma_rdata_12__45_a1 buffd1 $PINS I=dma_rdata[12]
+ Z=earlybuf_dma_rdata_12__45_a1_n VDD=VDD VSS=VSS
Xearlybuf_dma_rdata_10__46_a1 buffd1 $PINS I=dma_rdata[10]
+ Z=earlybuf_dma_rdata_10__46_a1_n VDD=VDD VSS=VSS
Xearlybuf_dma_rdata_9__47_a1 buffd1 $PINS I=copt_net_216
+ Z=earlybuf_dma_rdata_9__47_a1_n VDD=VDD VSS=VSS
Xearlybuf_dma_rdata_8__48_a1 buffd1 $PINS I=dma_rdata[8]
+ Z=earlybuf_dma_rdata_8__48_a1_n VDD=VDD VSS=VSS
Xearlybuf_dma_rdata_7__49_a1 buffd1 $PINS I=dma_rdata[7]
+ Z=earlybuf_dma_rdata_7__49_a1_n VDD=VDD VSS=VSS
Xearlybuf_dma_rdata_6__50_a1 buffd1 $PINS I=dma_rdata[6]
+ Z=earlybuf_dma_rdata_6__50_a1_n VDD=VDD VSS=VSS
Xearlybuf_dma_rdata_5__51_a1 buffd1 $PINS I=dma_rdata[5]
+ Z=earlybuf_dma_rdata_5__51_a1_n VDD=VDD VSS=VSS
Xearlybuf_dma_rdata_4__52_a1 buffd1 $PINS I=dma_rdata[4]
+ Z=earlybuf_dma_rdata_4__52_a1_n VDD=VDD VSS=VSS
Xearlybuf_dma_rdata_0__53_a1 buffd1 $PINS I=dma_rdata[0]
+ Z=earlybuf_dma_rdata_0__53_a1_n VDD=VDD VSS=VSS
Xearlybuf_dma_ready_54_a1 buffd1 $PINS I=dma_ready Z=earlybuf_dma_ready_54_a1_n
+ VDD=VDD VSS=VSS
XZCTSBUF_64770_2548 buffda $PINS I=ZCTSNET_43 Z=ZCTSNET_38 VDD=VDD VSS=VSS
XZCTSBUF_69038_2549 bufbd7 $PINS I=ZCTSNET_43 Z=ZCTSNET_39 VDD=VDD VSS=VSS
XZCTSBUF_65445_2550 buffd7 $PINS I=ZCTSNET_43 Z=ZCTSNET_40 VDD=VDD VSS=VSS
XZCTSBUF_65983_2551 buffd3 $PINS I=ZCTSNET_43 Z=ZCTSNET_41 VDD=VDD VSS=VSS
XZCTSBUF_68008_2552 buffda $PINS I=ZCTSNET_43 Z=ZCTSNET_42 VDD=VDD VSS=VSS
XZCTSINV_78667_2553 invbdf $PINS I=ZCTSNET_59 ZN=ZCTSNET_43 VDD=VDD VSS=VSS
XctmTdsLR_1_2972 buffd7 $PINS I=n71 Z=prdata[23] VDD=VDD VSS=VSS
XZCTSBUF_113226_2556 buffda $PINS I=ZCTSNET_50 Z=ZCTSNET_45 VDD=VDD VSS=VSS
XctmTdsLR_1_2973 buffd7 $PINS I=n69 Z=prdata[25] VDD=VDD VSS=VSS
XctmTdsLR_1_2974 buffd7 $PINS I=n67 Z=prdata[27] VDD=VDD VSS=VSS
XZCTSBUF_118575_2560 buffd3 $PINS I=ZCTSNET_50 Z=ZCTSNET_48 VDD=VDD VSS=VSS
XZCTSBUF_110968_2561 buffda $PINS I=ZCTSNET_50 Z=ZCTSNET_49 VDD=VDD VSS=VSS
XZCTSINV_119797_2562 invbd7 $PINS I=ZCTSNET_59 ZN=ZCTSNET_50 VDD=VDD VSS=VSS
XctmTdsLR_1_2975 buffd4 $PINS I=n66 Z=prdata[28] VDD=VDD VSS=VSS
XctmTdsLR_1_2976 bufbd4 $PINS I=n64 Z=prdata[30] VDD=VDD VSS=VSS
XctmTdsLR_1_2977 buffd4 $PINS I=n88 Z=prdata[5] VDD=VDD VSS=VSS
XZCTSBUF_98939_2567 buffd3 $PINS I=ZCTSNET_58 Z=ZCTSNET_54 VDD=VDD VSS=VSS
XZCTSBUF_94308_2568 bufbd4 $PINS I=ZCTSNET_58 Z=ZCTSNET_55 VDD=VDD VSS=VSS
XZCTSBUF_98149_2572 bufbd3 $PINS I=ZCTSNET_58 Z=ZCTSNET_56 VDD=VDD VSS=VSS
XZCTSBUF_107819_2573 buffd3 $PINS I=ZCTSNET_58 Z=ZCTSNET_57 VDD=VDD VSS=VSS
XZCTSINV_108022_2574 invbdk $PINS I=ZCTSNET_59 ZN=ZCTSNET_58 VDD=VDD VSS=VSS
XZCTSBUF_121299_2575 buffda $PINS I=ZCTSNET_60 Z=ZCTSNET_59 VDD=VDD VSS=VSS
XZCTSINV_121579_2576 inv0da $PINS I=clk ZN=ZCTSNET_60 VDD=VDD VSS=VSS
XctmTdsLR_1_2978 buffd4 $PINS I=n86 Z=prdata[7] VDD=VDD VSS=VSS
XctmTdsLR_1_2979 buffd4 $PINS I=n83 Z=prdata[10] VDD=VDD VSS=VSS
XctmTdsLR_1_2980 bufbd4 $PINS I=n72 Z=prdata[22] VDD=VDD VSS=VSS
XctmTdsLR_1_2981 buffd4 $PINS I=n70 Z=prdata[24] VDD=VDD VSS=VSS
XctmTdsLR_1_2982 buffd7 $PINS I=n84 Z=prdata[9] VDD=VDD VSS=VSS
XctmTdsLR_1_2983 buffd4 $PINS I=n68 Z=prdata[26] VDD=VDD VSS=VSS
XctmTdsLR_1_2984 bufbdf $PINS I=n65 Z=prdata[29] VDD=VDD VSS=VSS
.ENDS
.GLOBAL VDD
.GLOBAL VSS
